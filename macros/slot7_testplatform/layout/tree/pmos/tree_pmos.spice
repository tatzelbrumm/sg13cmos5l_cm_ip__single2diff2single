* SPDX-FileCopyrightText: 2026 Christoph Maier
* SPDX-License-Identifier: Apache-2.0
* tree_pmos: PMOS devices of bias_tree_noab_pd as drawn (generated by build_tree_pmos.py).
* Fingers of the same L in parallel; netgen merges them to the source netlist's devices:
*   BP 5 x 1/6 = 5/6, PBN 5 x 1/6 = 5/6, PBNC 2 x 1/6 = 2/6, MDBP 1/6 + 2 x 0.5/6 = 2/6, BPC 1/4, TGP 1/0.45.
* score (left to right): r a b c a b b x a b a c a b r
.subckt tree_pmos vdd vbp vbn vbnc vbpc iref ni en_3v3_b
XBPC vbpc vbpc vdd vdd sg13_hv_pmos w=1u l=4u ng=1
XTGP iref en_3v3_b ni vdd sg13_hv_pmos w=1u l=0.45u ng=1
XMDBP_rL vdd vbp vdd vdd sg13_hv_pmos w=0.5u l=6u ng=1
XBP_1 vbp vbp vdd vdd sg13_hv_pmos w=1u l=6u ng=1
XPBN_1 vbn vbp vdd vdd sg13_hv_pmos w=1u l=6u ng=1
XPBNC_1 vbnc vbp vdd vdd sg13_hv_pmos w=1u l=6u ng=1
XBP_2 vbp vbp vdd vdd sg13_hv_pmos w=1u l=6u ng=1
XPBN_2 vbn vbp vdd vdd sg13_hv_pmos w=1u l=6u ng=1
XPBN_3 vbn vbp vdd vdd sg13_hv_pmos w=1u l=6u ng=1
XMDBP_x vdd vbp vdd vdd sg13_hv_pmos w=1u l=6u ng=1
XBP_3 vbp vbp vdd vdd sg13_hv_pmos w=1u l=6u ng=1
XPBN_4 vbn vbp vdd vdd sg13_hv_pmos w=1u l=6u ng=1
XBP_4 vbp vbp vdd vdd sg13_hv_pmos w=1u l=6u ng=1
XPBNC_2 vbnc vbp vdd vdd sg13_hv_pmos w=1u l=6u ng=1
XBP_5 vbp vbp vdd vdd sg13_hv_pmos w=1u l=6u ng=1
XPBN_5 vbn vbp vdd vdd sg13_hv_pmos w=1u l=6u ng=1
XMDBP_rR vdd vbp vdd vdd sg13_hv_pmos w=0.5u l=6u ng=1
.ends tree_pmos
