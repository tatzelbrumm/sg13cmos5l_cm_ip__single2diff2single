* SPDX-FileCopyrightText: 2026 Christoph Maier
* SPDX-License-Identifier: Apache-2.0
* tree_nmos: NMOS half of bias_tree_noab_pd (+ bias_diodes BN, BNC) as drawn in tree_nmos.gds,
* one line per finger; generated by build_tree_nmos.py. Parallel fingers sum to the source W:
* NI 5 x 1.2 = 6u, NBP 5 x 1.2 = 6u, NBPC 2 x 1.2 = 2.4u, MDBN 2 x 1.2 = 2.4u, BN 5 x 1.2 = 6u.
.subckt tree_nmos vss ni iref vbp vbpc vbn vbnc en_3v3 en_3v3_b
XMDBN_f0 vss ni vss vss sg13_hv_nmos w=1.2u l=6u ng=1
XNI_f1 ni ni vss vss sg13_hv_nmos w=1.2u l=6u ng=1
XNBP_f2 vbp ni vss vss sg13_hv_nmos w=1.2u l=6u ng=1
XNBPC_f3 vbpc ni vss vss sg13_hv_nmos w=1.2u l=6u ng=1
XNBP_f4 vbp ni vss vss sg13_hv_nmos w=1.2u l=6u ng=1
XNI_f5 ni ni vss vss sg13_hv_nmos w=1.2u l=6u ng=1
XNBP_f6 vbp ni vss vss sg13_hv_nmos w=1.2u l=6u ng=1
XNI_f7 ni ni vss vss sg13_hv_nmos w=1.2u l=6u ng=1
XNBP_f8 vbp ni vss vss sg13_hv_nmos w=1.2u l=6u ng=1
XNI_f9 ni ni vss vss sg13_hv_nmos w=1.2u l=6u ng=1
XNBPC_f10 vbpc ni vss vss sg13_hv_nmos w=1.2u l=6u ng=1
XNI_f11 ni ni vss vss sg13_hv_nmos w=1.2u l=6u ng=1
XNBP_f12 vbp ni vss vss sg13_hv_nmos w=1.2u l=6u ng=1
XMDBN_f13 vss ni vss vss sg13_hv_nmos w=1.2u l=6u ng=1
XBN_f0 vbn vbn vss vss sg13_hv_nmos w=1.2u l=6u ng=1
XBN_f1 vbn vbn vss vss sg13_hv_nmos w=1.2u l=6u ng=1
XBN_f2 vbn vbn vss vss sg13_hv_nmos w=1.2u l=6u ng=1
XBN_f3 vbn vbn vss vss sg13_hv_nmos w=1.2u l=6u ng=1
XBN_f4 vbn vbn vss vss sg13_hv_nmos w=1.2u l=6u ng=1
XBNC vbnc vbnc vss vss sg13_hv_nmos w=1u l=8u ng=1
XTDN ni en_3v3_b vss vss sg13_hv_nmos w=1u l=0.45u ng=1
XTGN iref en_3v3 ni vss sg13_hv_nmos w=1u l=0.45u ng=1
.ends tree_nmos
