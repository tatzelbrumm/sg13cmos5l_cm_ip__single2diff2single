* the NMOS lines of bias_tree_noab_pd + bias_diodes, verbatim sizes (no finger split)
.subckt tree_nmos vss ni iref vbp vbpc vbn vbnc en_3v3 en_3v3_b
XTGN iref en_3v3 ni vss sg13_hv_nmos w=1u l=0.45u ng=1
XTDN ni en_3v3_b vss vss sg13_hv_nmos w=1u l=0.45u ng=1
XNI ni ni vss vss sg13_hv_nmos w=6u l=6u ng=1
XNBP vbp ni vss vss sg13_hv_nmos w=6u l=6u ng=1
XNBPC vbpc ni vss vss sg13_hv_nmos w=2.4u l=6u ng=1
XMDBN vss ni vss vss sg13_hv_nmos w=2.4u l=6u ng=1
XBN vbn vbn vss vss sg13_hv_nmos w=6u l=6u ng=1
XBNC vbnc vbnc vss vss sg13_hv_nmos w=1u l=8u ng=1
.ends tree_nmos
