* LVS reference for bias_tree_noab_pd, generated by make_ref.py: source subckts copied unchanged
* from macros/bias_tree_pd/netlist/source/bias_ref_pd.spice
.subckt bias_diodes vdd vss vbp vbn vbpc vbnc
XBP vbp vbp vdd vdd sg13_hv_pmos w=5u l=6u ng=1
XBN vbn vbn vss vss sg13_hv_nmos w=6u l=6u ng=1
XBNC vbnc vbnc vss vss sg13_hv_nmos w=1u l=8u ng=1
XBPC vbpc vbpc vdd vdd sg13_hv_pmos w=1u l=4u ng=1
.ends bias_diodes
* from macros/bias_tree_noab_pd/netlist/source/bias_tree_noab_pd.spice
.subckt bias_tree_noab_pd vdd vss iref vbp vbn vbpc vbnc en_3v3 en_3v3_b
XTGN iref en_3v3 ni vss sg13_hv_nmos w=1u l=0.45u ng=1
XTGP iref en_3v3_b ni vdd sg13_hv_pmos w=1u l=0.45u ng=1
XTDN ni en_3v3_b vss vss sg13_hv_nmos w=1u l=0.45u ng=1
XNI ni ni vss vss sg13_hv_nmos w=6u l=6u ng=1
XNBP vbp ni vss vss sg13_hv_nmos w=6u l=6u ng=1
XNBPC vbpc ni vss vss sg13_hv_nmos w=2.4u l=6u ng=1
XPBN vbn vbp vdd vdd sg13_hv_pmos w=5u l=6u ng=1
XPBNC vbnc vbp vdd vdd sg13_hv_pmos w=2u l=6u ng=1
Xd vdd vss vbp vbn vbpc vbnc bias_diodes
* --- layout dummies of the tree rows (C3 backannotation, pad_candidate.cdl), D = S on the rail, gate by poly abutment
XMDBP vdd vbp vdd vdd sg13_hv_pmos w=2u l=6u ng=1
XMDBN vss ni vss vss sg13_hv_nmos w=2.4u l=6u ng=1
.ends bias_tree_noab_pd
