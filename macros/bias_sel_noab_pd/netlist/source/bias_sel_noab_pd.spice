* SPDX-FileCopyrightText: 2026 Christoph Maier
* SPDX-License-Identifier: Apache-2.0
* bias_sel_noab_pd: bias_sel_pd (../../../bias_sel_pd/netlist/source/bias_sel_pd.spice) with bias_tree_noab_pd instead of
* bias_tree_pd, i.e. without the class-AB lines vabp / vabn (2026-10-27): the s2d pad's bias, generator in the pad.
* Uses bias_ref_pd.spice (oa_core_pd, bg_core_pd, bias_diodes), bias_tree_noab_pd.spice and hv_logic.spice.
.subckt bias_sel_noab_pd vdd vss ibias vbp vbn vbpc vbnc en_3v3 sel0_3v3 sel1_3v3 en_3v3_b
Xt vdd vss ir vbp vbn vbpc vbnc en_3v3 en_3v3_b bias_tree_noab_pd
* decode
XDA vdd vss en_3v3 sel0_3v3 en_oa_b nand2_hv
XDB vdd vss en_oa_b en_oa inv_hv
XDC vdd vss en_3v3 sel1_3v3 en_bg_b nand2_hv
XDD vdd vss en_bg_b en_bg inv_hv
XDE vdd vss sel0_3v3 sel1_3v3 s00 nor2_hv
XDF vdd vss en_3v3 s00 en_ext_b nand2_hv
XDG vdd vss en_ext_b en_ext inv_hv
* reference sources into ir
Xoa vdd vss ir en_oa en_oa_b oa_core_pd
Xbg vdd vss ir en_bg en_bg_b bg_core_pd
XTEN ibias en_ext ir vss sg13_hv_nmos w=1u l=0.45u ng=1
XTEP ibias en_ext_b ir vdd sg13_hv_pmos w=1u l=0.45u ng=1
.ends bias_sel_noab_pd
