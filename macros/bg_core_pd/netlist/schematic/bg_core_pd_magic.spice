** sch_path: /home/user/sg13cmos5l_cm_ip__single2diff2single/macros/bg_core_pd/schematic/xschem/bg_core_pd.sch
.subckt bg_core_pd vdd vss iout en_3v3 en_3v3_b
*.PININFO vdd:B vss:B en_3v3:I en_3v3_b:I iout:O
XMS2 ks g vss vss sg13_hv_nmos w=10u l=1u ng=1 m=1 mm_ok=1
XMS3 vpc ks vss vss sg13_hv_nmos w=0.5u l=2u ng=1 m=1 mm_ok=1
XPB vpg vpg vdd vdd sg13_hv_pmos w=40u l=1u ng=4 m=1 mm_ok=1
XPBC vpc vpc vpg vdd sg13_hv_pmos w=40u l=1u ng=4 m=1 mm_ok=1
XNB vpc g eb vss sg13_hv_nmos w=20u l=4u ng=2 m=1 mm_ok=1
XQ2 vss vss e2 pnpMPA a=4e-12 p=8e-06 m=8
XPA ca vpg vdd vdd sg13_hv_pmos w=40u l=1u ng=4 m=1 mm_ok=1
XPAC g vpc ca vdd sg13_hv_pmos w=40u l=1u ng=4 m=1 mm_ok=1
XNA g g ea vss sg13_hv_nmos w=20u l=4u ng=2 m=1 mm_ok=1
XQ1 vss vss ea pnpMPA a=4e-12 p=8e-06
XPO co vpg vdd vdd sg13_hv_pmos w=80u l=1u ng=8 m=1 mm_ok=1
XPOC iout vpc co vdd sg13_hv_pmos w=80u l=1u ng=8 m=1 mm_ok=1
XSKS ks en_3v3_b vss vss sg13_hv_nmos w=1u l=0.45u ng=1 m=1 mm_ok=1
XSVPG vpg en_3v3 vdd vdd sg13_hv_pmos w=1u l=0.45u ng=1 m=1 mm_ok=1
XR1B[9] eb n1b[8] vss rhigh w=0.5u l=9.94u m=1 b=0 mm_ok=1
XR1B[8] n1b[8] n1b[7] vss rhigh w=0.5u l=9.94u m=1 b=0 mm_ok=1
XR1B[7] n1b[7] n1b[6] vss rhigh w=0.5u l=9.94u m=1 b=0 mm_ok=1
XR1B[6] n1b[6] n1b[5] vss rhigh w=0.5u l=9.94u m=1 b=0 mm_ok=1
XR1B[5] n1b[5] n1b[4] vss rhigh w=0.5u l=9.94u m=1 b=0 mm_ok=1
XR1B[4] n1b[4] n1b[3] vss rhigh w=0.5u l=9.94u m=1 b=0 mm_ok=1
XR1B[3] n1b[3] n1b[2] vss rhigh w=0.5u l=9.94u m=1 b=0 mm_ok=1
XR1B[2] n1b[2] n1b[1] vss rhigh w=0.5u l=9.94u m=1 b=0 mm_ok=1
XR1B[1] n1b[1] n1b[0] vss rhigh w=0.5u l=9.94u m=1 b=0 mm_ok=1
XR1B[0] n1b[0] vss vss rhigh w=0.5u l=9.94u m=1 b=0 mm_ok=1
XR0[17] eb n0[16] vss rhigh w=0.5u l=9.94u m=1 b=0 mm_ok=1
XR0[16] n0[16] n0[15] vss rhigh w=0.5u l=9.94u m=1 b=0 mm_ok=1
XR0[15] n0[15] n0[14] vss rhigh w=0.5u l=9.94u m=1 b=0 mm_ok=1
XR0[14] n0[14] n0[13] vss rhigh w=0.5u l=9.94u m=1 b=0 mm_ok=1
XR0[13] n0[13] n0[12] vss rhigh w=0.5u l=9.94u m=1 b=0 mm_ok=1
XR0[12] n0[12] n0[11] vss rhigh w=0.5u l=9.94u m=1 b=0 mm_ok=1
XR0[11] n0[11] n0[10] vss rhigh w=0.5u l=9.94u m=1 b=0 mm_ok=1
XR0[10] n0[10] n0[9] vss rhigh w=0.5u l=9.94u m=1 b=0 mm_ok=1
XR0[9] n0[9] n0[8] vss rhigh w=0.5u l=9.94u m=1 b=0 mm_ok=1
XR0[8] n0[8] n0[7] vss rhigh w=0.5u l=9.94u m=1 b=0 mm_ok=1
XR0[7] n0[7] n0[6] vss rhigh w=0.5u l=9.94u m=1 b=0 mm_ok=1
XR0[6] n0[6] n0[5] vss rhigh w=0.5u l=9.94u m=1 b=0 mm_ok=1
XR0[5] n0[5] n0[4] vss rhigh w=0.5u l=9.94u m=1 b=0 mm_ok=1
XR0[4] n0[4] n0[3] vss rhigh w=0.5u l=9.94u m=1 b=0 mm_ok=1
XR0[3] n0[3] n0[2] vss rhigh w=0.5u l=9.94u m=1 b=0 mm_ok=1
XR0[2] n0[2] n0[1] vss rhigh w=0.5u l=9.94u m=1 b=0 mm_ok=1
XR0[1] n0[1] n0[0] vss rhigh w=0.5u l=9.94u m=1 b=0 mm_ok=1
XR0[0] n0[0] e2 vss rhigh w=0.5u l=9.94u m=1 b=0 mm_ok=1
XR1A[10] ea n1a[9] vss rhigh w=0.5u l=9.94u m=1 b=0 mm_ok=1
XR1A[9] n1a[9] n1a[8] vss rhigh w=0.5u l=9.94u m=1 b=0 mm_ok=1
XR1A[8] n1a[8] n1a[7] vss rhigh w=0.5u l=9.94u m=1 b=0 mm_ok=1
XR1A[7] n1a[7] n1a[6] vss rhigh w=0.5u l=9.94u m=1 b=0 mm_ok=1
XR1A[6] n1a[6] n1a[5] vss rhigh w=0.5u l=9.94u m=1 b=0 mm_ok=1
XR1A[5] n1a[5] n1a[4] vss rhigh w=0.5u l=9.94u m=1 b=0 mm_ok=1
XR1A[4] n1a[4] n1a[3] vss rhigh w=0.5u l=9.94u m=1 b=0 mm_ok=1
XR1A[3] n1a[3] n1a[2] vss rhigh w=0.5u l=9.94u m=1 b=0 mm_ok=1
XR1A[2] n1a[2] n1a[1] vss rhigh w=0.5u l=9.94u m=1 b=0 mm_ok=1
XR1A[1] n1a[1] n1a[0] vss rhigh w=0.5u l=9.94u m=1 b=0 mm_ok=1
XR1A[0] n1a[0] vss vss rhigh w=0.5u l=9.94u m=1 b=0 mm_ok=1
XMS1_0 net1 en_3v3_b vdd vdd sg13_hv_pmos w=0.5u l=12.5u ng=1 m=1 mm_ok=1
XMS1_1 net2 en_3v3_b net1 vdd sg13_hv_pmos w=0.5u l=12.5u ng=1 m=1 mm_ok=1
XMS1_2 net3 en_3v3_b net2 vdd sg13_hv_pmos w=0.5u l=12.5u ng=1 m=1 mm_ok=1
XMS1_3 net4 en_3v3_b net3 vdd sg13_hv_pmos w=0.5u l=12.5u ng=1 m=1 mm_ok=1
XMS1_4 net5 en_3v3_b net4 vdd sg13_hv_pmos w=0.5u l=12.5u ng=1 m=1 mm_ok=1
XMS1_5 net6 en_3v3_b net5 vdd sg13_hv_pmos w=0.5u l=12.5u ng=1 m=1 mm_ok=1
XMS1_6 net7 en_3v3_b net6 vdd sg13_hv_pmos w=0.5u l=12.5u ng=1 m=1 mm_ok=1
XMS1_7 ks en_3v3_b net7 vdd sg13_hv_pmos w=0.5u l=12.5u ng=1 m=1 mm_ok=1
XMDUM0 vdd vpg vdd vdd sg13_hv_pmos w=2.4u l=1u ng=8 m=1 mm_ok=1
XMDUM1 vdd vpc vdd vdd sg13_hv_pmos w=2.4u l=1u ng=8 m=1 mm_ok=1
XMDUM2 g g g vss sg13_hv_nmos w=2u l=1u ng=1 m=1 mm_ok=1
XMDUM3 g g g vss sg13_hv_nmos w=16u l=4u ng=8 m=1 mm_ok=1
XRDUM[1] vss vss vss rhigh w=0.5u l=9.94u m=1 b=0 mm_ok=1
XRDUM[0] vss vss vss rhigh w=0.5u l=9.94u m=1 b=0 mm_ok=1
.ends
