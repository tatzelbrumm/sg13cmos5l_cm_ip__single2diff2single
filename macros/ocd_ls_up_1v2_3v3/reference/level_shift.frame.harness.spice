.subckt level_shift in_n in_p out vdd vss
*.PININFO in_n:I in_p:I out:O
XM1 net1 in_p vss vss sg13_hv_nmos w=4u l=0.5u ng=1 m=2 mm_ok=1
XM2 net1 S1_N vdd vdd sg13_hv_pmos w=1u l=0.5u ng=1 m=2 mm_ok=1
XM3 S1_N in_n vss vss sg13_hv_nmos w=4u l=0.5u ng=1 m=2 mm_ok=1
XM4 S1_N net1 vdd vdd sg13_hv_pmos w=1u l=0.5u ng=1 m=2 mm_ok=1
XM5 S2_N S1_N vdd vdd sg13_hv_pmos w=2u l=0.5u ng=1 m=2 mm_ok=1
XM6 S2_N S1_N vss vss sg13_hv_nmos w=1u l=0.5u ng=1 m=2 mm_ok=1
XM7 out S2_N vdd vdd sg13_hv_pmos w=2u l=0.5u ng=1 m=4 mm_ok=1
XM8 out S2_N vss vss sg13_hv_nmos w=1u l=0.5u ng=1 m=4 mm_ok=1
.ends
