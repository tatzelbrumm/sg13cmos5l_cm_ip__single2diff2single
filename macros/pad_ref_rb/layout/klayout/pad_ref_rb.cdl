* SPDX-FileCopyrightText: 2026 Christoph Maier
* SPDX-License-Identifier: Apache-2.0
* pad_ref_rb.cdl: flat LVS reference of pad_ref_rb, composed by compose_cdl_rb.py (Claude, agent F, C4)
* from: pad_ref_rb.spice vcm_rb.spice vref_s2d_rb.spice bypass_rb_drawn.spice

.SUBCKT pad_ref_rb vddh vssh iref vcm vref en_3v3 en_3v3_b
Mt_TGN iref en_3v3 ni vssh sg13_hv_nmos w=1u l=0.45u ng=1 m=1
Mt_TGP ni en_3v3_b iref vddh sg13_hv_pmos w=1u l=0.45u ng=1 m=1
Mt_TDN ni en_3v3_b vssh vssh sg13_hv_nmos w=1u l=0.45u ng=1 m=1
Mt_NI ni ni vssh vssh sg13_hv_nmos w=6u l=6u ng=1 m=1
Mt_NBP vbp ni vssh vssh sg13_hv_nmos w=2.4u l=6u ng=1 m=1
Mt_BP vbp vbp vddh vddh sg13_hv_pmos w=2u l=6u ng=1 m=1
Mt_PBNC vbnc vbp vddh vddh sg13_hv_pmos w=2u l=6u ng=1 m=1
Mt_BNC vbnc vbnc vssh vssh sg13_hv_nmos w=1u l=8u ng=1 m=1
Mt_MDPBN vddh vbp vddh vddh sg13_hv_pmos w=5u l=6u ng=1 m=1
Mt_MDTN6 vssh ni vssh vssh sg13_hv_nmos w=2u l=6u ng=1 m=1
Mt_MDTN7 vssh ni vssh vssh sg13_hv_nmos w=2.4u l=6u ng=1 m=1
Mc_TR c_ts vbp vddh vddh sg13_hv_pmos w=5u l=6u ng=1 m=1
Mc_MR c_gh c_gh c_ts c_ts sg13_hv_pmos w=20u l=1u ng=2 m=1
Mc_SH1 c_gh ni vssh vssh sg13_hv_nmos w=2.4u l=6u ng=1 m=1
Mc_SH2 c_gh ni vssh vssh sg13_hv_nmos w=2.4u l=6u ng=1 m=1
Mc_CY vddh vbnc c_xp vssh sg13_hv_nmos w=15u l=3u ng=1 m=1
Mc_SY c_xp ni vssh vssh sg13_hv_nmos w=6u l=6u ng=1 m=1
Mc_SU c_m c_m c_gh c_gh sg13_hv_pmos w=1u l=4u ng=1 m=1
Mc_SL1 c_xp c_xp c_m c_m sg13_hv_pmos w=1u l=4u ng=1 m=1
Mc_SL2 c_xp c_xp c_m c_m sg13_hv_pmos w=1u l=4u ng=1 m=1
Mc_BT c_bt vbp vddh vddh sg13_hv_pmos w=5u l=6u ng=1 m=1
Mc_BA c_bd c_m c_bt c_bt sg13_hv_pmos w=20u l=1u ng=2 m=1
Mc_BB vcm vcm c_bt c_bt sg13_hv_pmos w=20u l=1u ng=2 m=1
Mc_BD c_bd c_bd vssh vssh sg13_hv_nmos w=6u l=6u ng=1 m=1
Mc_BM vcm c_bd vssh vssh sg13_hv_nmos w=6u l=6u ng=1 m=1
Mc_CB vssh vcm vssh vssh sg13_hv_nmos w=12u l=12u ng=1 m=1
Mc_SPD vcm en_3v3_b vssh vssh sg13_hv_nmos w=1u l=0.45u ng=1 m=1
Mc_MDT1 vddh vbp vddh vddh sg13_hv_pmos w=5u l=6u ng=1 m=1
Mc_MDT0 vddh vbp vddh vddh sg13_hv_pmos w=5u l=6u ng=1 m=1
Mc_MDU1 vddh vddh vddh vddh sg13_hv_pmos w=20u l=1u ng=2 m=1
Mc_MDU0 vddh vddh vddh vddh sg13_hv_pmos w=20u l=1u ng=2 m=1
Mc_MDAU1 c_gh c_m c_gh c_gh sg13_hv_pmos w=1u l=4u ng=1 m=1
Mc_MDAU0 c_gh c_m c_gh c_gh sg13_hv_pmos w=1u l=4u ng=1 m=1
Mc_MDAL1 c_m c_xp c_m c_m sg13_hv_pmos w=1u l=4u ng=1 m=1
Mc_MDAL0 c_m c_xp c_m c_m sg13_hv_pmos w=1u l=4u ng=1 m=1
Mc_MDM1 vssh c_bd vssh vssh sg13_hv_nmos w=2u l=6u ng=1 m=1
Mc_MDM0 vssh c_bd vssh vssh sg13_hv_nmos w=2u l=6u ng=1 m=1
Mr_F1 vddh vbnc vref vssh sg13_hv_nmos w=15u l=3u ng=1 m=1
Mr_F2 vddh vbnc vref vssh sg13_hv_nmos w=15u l=3u ng=1 m=1
Mr_F3 vddh vbnc vref vssh sg13_hv_nmos w=15u l=3u ng=1 m=1
Mr_F4 vddh vbnc vref vssh sg13_hv_nmos w=15u l=3u ng=1 m=1
Mr_SF vref ni vssh vssh sg13_hv_nmos w=2u l=6u ng=1 m=1
Mr_SPD vref en_3v3_b vssh vssh sg13_hv_nmos w=1u l=0.45u ng=1 m=1
Mr_MDC3 vssh vbnc vssh vssh sg13_hv_nmos w=2u l=3u ng=1 m=1
Mr_MDC2 vssh vbnc vssh vssh sg13_hv_nmos w=2u l=3u ng=1 m=1
Mr_MDC1 vssh vbnc vssh vssh sg13_hv_nmos w=2u l=3u ng=1 m=1
Mr_MDC0 vssh vbnc vssh vssh sg13_hv_nmos w=2u l=3u ng=1 m=1
Mr_MDCX2 vssh vbnc vssh vssh sg13_hv_nmos w=15u l=3u ng=1 m=1
Mr_MDCX1 vssh vbnc vssh vssh sg13_hv_nmos w=15u l=3u ng=1 m=1
Mr_MDCX0 vssh vbnc vssh vssh sg13_hv_nmos w=15u l=3u ng=1 m=1
Mb_CBR_cload vssh vref vssh vssh sg13_hv_nmos w=12u l=12u ng=1 m=1
Mb_CBR_capr_0 vssh vref vssh vssh sg13_hv_nmos w=34.1u l=16.9u ng=1 m=1
Mb_CBR_capr_1 vssh vref vssh vssh sg13_hv_nmos w=34.1u l=16.9u ng=1 m=1
Mb_CBM_capm_0 vssh vcm vssh vssh sg13_hv_nmos w=8.18u l=3.25u ng=1 m=1
Mb_CBM_capm_1 vssh vcm vssh vssh sg13_hv_nmos w=8.18u l=3.25u ng=1 m=1
Mb_CBM_capt vssh vcm vssh vssh sg13_hv_nmos w=2.9u l=12.4u ng=1 m=1
Mb_CBM_capv_0 vssh vcm vssh vssh sg13_hv_nmos w=19.24u l=12.66u ng=1 m=1
Mb_CBM_capv_1 vssh vcm vssh vssh sg13_hv_nmos w=19.24u l=12.66u ng=1 m=1
.ENDS pad_ref_rb
