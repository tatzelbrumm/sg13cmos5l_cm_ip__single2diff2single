* SPDX-FileCopyrightText: 2026 Christoph Maier
* SPDX-License-Identifier: Apache-2.0
* pad_ref_rb: the replica bias of the custom pads' reference voltages in one cell (2026-11-07, option A of the user's
* question on sharing): the shared bias tree bias_tree_rb feeds vcm_rb (S2D vcm = D2S vref) and vref_s2d_rb (S2D vref).
* One 5 uA reference current, one enable. Needs ../../../vcm_rb/netlist/source/vcm_rb.spice and
* ../../../vref_s2d_rb/netlist/source/vref_s2d_rb.spice. Task docs/launch/replica_bias_TASK.md (branch harness-test),
* records in docs/replica_bias/.
* Ports: vddh vssh iref vcm vref en_3v3 en_3v3_b (Christoph, 2026-11-07: "Pin names vddh and vssh, so they can be
* connected without conflict either way": to the pads' iovdd / iovss or the slot's vdd_3v3 / vss_3v3; iref: 5 uA SOURCED into the cell, from bias_gen_pd's iref, a bias_dist_pd
* output or a core's iout; en_3v3 / en_3v3_b from en_ctrl_3v3). vdd / vss: the rails of the pads it serves (the top edge
* that vcm_rb tracks is referenced to the pads' unit rail).
* Supply current (tt 27 C, 3.3 V): tree 9 uA (5 uA reference + 2 BP + 2 BNC) + vcm_rb 14 uA + vref_s2d_rb 1.7 uA.

* bias_tree_rb: the lines of both replica blocks, as bias_tree_pd at the pad devices' current densities.
*   ni   = NI, 6u/6u NMOS diode carrying the reference (= the pads' BN density: 5 uA in 6u/6u)
*   vbp  = BP, 2u/6u PMOS diode at 2 uA from NBP 2.4u/6u (= the pads' BP density: 5 uA in 5u/6u)
*   vbnc = BNC, 1u/8u NMOS diode at 2 uA from PBNC 2u/6u (= the pads' BNC)
* Disabled (en_3v3 = 0): TGN / TGP open the reference, TDN pulls ni to vss; BP pulls vbp to vdd, BNC vbnc to vss.
* TGP: drain ni, source iref as drawn by Christoph (2026-11-07, b4cd2288); a transmission gate is symmetric.
.subckt bias_tree_rb vdd vss iref ni vbp vbnc en_3v3 en_3v3_b
* --- reference input (as bias_tree_pd)
XTGN iref en_3v3 ni vss sg13_hv_nmos w=1u l=0.45u ng=1 mm_ok=1
XTGP ni en_3v3_b iref vdd sg13_hv_pmos w=1u l=0.45u ng=1 mm_ok=1
XTDN ni en_3v3_b vss vss sg13_hv_nmos w=1u l=0.45u ng=1 mm_ok=1
XNI ni ni vss vss sg13_hv_nmos w=6u l=6u ng=1 mm_ok=1
* --- lines
XNBP vbp ni vss vss sg13_hv_nmos w=2.4u l=6u ng=1 mm_ok=1
XBP vbp vbp vdd vdd sg13_hv_pmos w=2u l=6u ng=1 mm_ok=1
XPBNC vbnc vbp vdd vdd sg13_hv_pmos w=2u l=6u ng=1 mm_ok=1
XBNC vbnc vbnc vss vss sg13_hv_nmos w=1u l=8u ng=1 mm_ok=1
* --- layout dummy (Christoph, 2026-11-07): the layout copies the s2d pad's tree row bias_tree_noab_p_c3, whose 5u/6u
*     device PBN (the pad's vbn leg) has no use here. It stays drawn as a dummy in the pads' convention: D = S = B =
*     vdd, gate vbp by poly abutment with BP and PBNC. No current (V_DS = 0); 30 um2 of gate on vbp.
XMDPBN vdd vbp vdd vdd sg13_hv_pmos w=5u l=6u ng=1 mm_ok=1
* --- layout dummies of the NMOS tree row rb_tree_n (agent N, 2026-11-07): [TGN] SH2 SF NBP SY | NI SH1 MDTN6 MDTN7
*     [TDN], the right half the mirror image of the left in widths (2.4 2 2.4 6 | 6 2.4 2 2.4); D = S = B = vss, gate
*     ni by poly abutment. No current; 26.4 um2 of gate on ni.
XMDTN6 vss ni vss vss sg13_hv_nmos w=2u l=6u ng=1 mm_ok=1
XMDTN7 vss ni vss vss sg13_hv_nmos w=2.4u l=6u ng=1 mm_ok=1
.ends bias_tree_rb

* bypass_rb: the bypass capacitors of vcm and vref (Christoph, 2026-11-07: in a cell of their own, distinct from the
* blocks; "6 on vref, 4 on vcm"). All hv NMOS to vss, the s2d pad's load-capacitor device type (CLP / CLN); NMOS to vss
* only: PMOS to iovdd couples iovdd into vref, the S2D's zero point (4 ... 7 x the S2D's input-referred iovdd ripple at
* 1 MHz), and raises vcm's 10 MHz ripple (explore_bypass.py).
* Shapes as drawn in the layout (agent F, pad_ref_rb v2, 2026-11-07; Christoph: "The bypass mos capacitors don't have to
* be a contiguous array, and they don't even have to be square ... The capacitor placement is pretty much ad lib
* (maintaining overall capacitance to the nodes and avoiding long interconnects)"). The total gate area per node is that
* of the 12u x 12u array it replaces (until then: parameters ncm = 4, ncr = 9, m={ncm} / m={ncr}):
*   vref 1296.6 um2 = 9 x 144: CBR1 12u/12u (rb_cload, the pad's CLN slot) + CBR2 2 x 34.1u/16.9u (under rb_casc);
*   vcm   576.3 um2 = 4 x 144 (+ CB 144 in vcm_rb): CBM1 2 x 19.24u/12.66u, CBM2 2 x 8.18u/3.25u, CBM3 2.9u/12.4u.
* The drawn shapes give the same results as the array to within 0.1 % (|Z|), 33 ns (enable) and 0.7 mV (the S2D's
* enable kick: 0.236 -> 0.112 V on vcm, 0.212 -> 0.088 V on vref); explore_layout_caps.py, results/drawn_*.tsv.
.subckt bypass_rb vss vcm vref
XCBR1 vss vref vss vss sg13_hv_nmos w=12u l=12u ng=1 m=1 mm_ok=1
XCBR2 vss vref vss vss sg13_hv_nmos w=34.1u l=16.9u ng=1 m=2 mm_ok=1
XCBM1 vss vcm vss vss sg13_hv_nmos w=19.24u l=12.66u ng=1 m=2 mm_ok=1
XCBM2 vss vcm vss vss sg13_hv_nmos w=8.18u l=3.25u ng=1 m=2 mm_ok=1
XCBM3 vss vcm vss vss sg13_hv_nmos w=2.9u l=12.4u ng=1 m=1 mm_ok=1
.ends bypass_rb

.subckt pad_ref_rb vddh vssh iref vcm vref en_3v3 en_3v3_b
Xt vddh vssh iref ni vbp vbnc en_3v3 en_3v3_b bias_tree_rb
Xc vddh vssh ni vbp vbnc vcm en_3v3_b vcm_rb
Xr vddh vssh ni vbnc vref en_3v3_b vref_s2d_rb
Xb vssh vcm vref bypass_rb
.ends pad_ref_rb
