** sch_path: /home/user/sg13cmos5l_cm_ip__single2diff2single/macros/pad_ref_rb/schematic/xschem/pad_ref_rb.sch
.subckt pad_ref_rb vddh vssh iref vcm vref en_3v3 en_3v3_b
*.PININFO vddh:B vssh:B iref:I vcm:O vref:O en_3v3:I en_3v3_b:I
Xt vddh vssh iref ni vbp vbnc en_3v3 en_3v3_b bias_tree_rb
Xc vddh vssh ni vbp vbnc vcm en_3v3_b vcm_rb
Xr vddh vssh ni vbnc vref en_3v3_b vref_s2d_rb
Xb vssh vcm vref bypass_rb
.ends

* expanding   symbol:  bias_tree_rb.sym # of pins=8
** sym_path: /home/user/sg13cmos5l_cm_ip__single2diff2single/macros/pad_ref_rb/schematic/xschem/bias_tree_rb.sym
** sch_path: /home/user/sg13cmos5l_cm_ip__single2diff2single/macros/pad_ref_rb/schematic/xschem/bias_tree_rb.sch
.subckt bias_tree_rb vdd vss iref ni vbp vbnc en_3v3 en_3v3_b
*.PININFO vdd:B vss:B iref:I ni:O vbp:O vbnc:O en_3v3:I en_3v3_b:I
MMDTN6 vss ni vss vss sg13_hv_nmos w=2u l=6u ng=1
MMDTN7 vss ni vss vss sg13_hv_nmos w=2.4u l=6u ng=1
MTGN iref en_3v3 ni vss sg13_hv_nmos w=1u l=0.45u ng=1
MTGP ni en_3v3_b iref vdd sg13_hv_pmos w=1u l=0.45u ng=1
MTDN ni en_3v3_b vss vss sg13_hv_nmos w=1u l=0.45u ng=1
MNI ni ni vss vss sg13_hv_nmos w=6u l=6u ng=1
MNBP vbp ni vss vss sg13_hv_nmos w=2.4u l=6u ng=1
MBP vbp vbp vdd vdd sg13_hv_pmos w=2u l=6u ng=1
MPBNC vbnc vbp vdd vdd sg13_hv_pmos w=2u l=6u ng=1
MBNC vbnc vbnc vss vss sg13_hv_nmos w=1u l=8u ng=1
MMDPBN vdd vbp vdd vdd sg13_hv_pmos w=5u l=6u ng=1
.ends

* expanding   symbol:  vcm_rb.sym # of pins=7
** sym_path: /home/user/sg13cmos5l_cm_ip__single2diff2single/macros/vcm_rb/schematic/xschem/vcm_rb.sym
** sch_path: /home/user/sg13cmos5l_cm_ip__single2diff2single/macros/vcm_rb/schematic/xschem/vcm_rb.sch
.subckt vcm_rb vdd vss ni vbp vbnc vcm en_3v3_b
*.PININFO vdd:B vss:B ni:I vbp:I vbnc:I vcm:O en_3v3_b:I
MTR ts vbp vdd vdd sg13_hv_pmos w=5u l=6u ng=1
MMR gh gh ts ts sg13_hv_pmos w=20u l=1u ng=2
MSH1 gh ni vss vss sg13_hv_nmos w=2.4u l=6u ng=1
MSH2 gh ni vss vss sg13_hv_nmos w=2.4u l=6u ng=1
MCY vdd vbnc xp vss sg13_hv_nmos w=15u l=3u ng=1
MSY xp ni vss vss sg13_hv_nmos w=6u l=6u ng=1
MSU m m gh gh sg13_hv_pmos w=1u l=4u ng=1
MSL1 xp xp m m sg13_hv_pmos w=1u l=4u ng=1
MSL2 xp xp m m sg13_hv_pmos w=1u l=4u ng=1
MBT bt vbp vdd vdd sg13_hv_pmos w=5u l=6u ng=1
MBA bd m bt bt sg13_hv_pmos w=20u l=1u ng=2
MBB vcm vcm bt bt sg13_hv_pmos w=20u l=1u ng=2
MBD bd bd vss vss sg13_hv_nmos w=6u l=6u ng=1
MBM vcm bd vss vss sg13_hv_nmos w=6u l=6u ng=1
MCB vss vcm vss vss sg13_hv_nmos w=12u l=12u ng=1
MSPD vcm en_3v3_b vss vss sg13_hv_nmos w=1u l=0.45u ng=1
MMDT[1] vdd vbp vdd vdd sg13_hv_pmos w=5u l=6u ng=1
MDT[0] vdd vbp vdd vdd sg13_hv_pmos w=5u l=6u ng=1
MMDU[1] vdd vdd vdd vdd sg13_hv_pmos w=20u l=1u ng=2
MDU[0] vdd vdd vdd vdd sg13_hv_pmos w=20u l=1u ng=2
MMDAU[1] gh m gh gh sg13_hv_pmos w=1u l=4u ng=1
MDAU[0] gh m gh gh sg13_hv_pmos w=1u l=4u ng=1
MMDAL[1] m xp m m sg13_hv_pmos w=1u l=4u ng=1
MDAL[0] m xp m m sg13_hv_pmos w=1u l=4u ng=1
MMDM[1] vss bd vss vss sg13_hv_nmos w=2u l=6u ng=1
MDM[0] vss bd vss vss sg13_hv_nmos w=2u l=6u ng=1
.ends

* expanding   symbol:  vref_s2d_rb.sym # of pins=6
** sym_path: /home/user/sg13cmos5l_cm_ip__single2diff2single/macros/vref_s2d_rb/schematic/xschem/vref_s2d_rb.sym
** sch_path: /home/user/sg13cmos5l_cm_ip__single2diff2single/macros/vref_s2d_rb/schematic/xschem/vref_s2d_rb.sch
.subckt vref_s2d_rb vdd vss ni vbnc vref en_3v3_b
*.PININFO vdd:B vss:B ni:I vbnc:I vref:O en_3v3_b:I
MF1 vdd vbnc vref vss sg13_hv_nmos w=15u l=3u ng=1
MF2 vdd vbnc vref vss sg13_hv_nmos w=15u l=3u ng=1
MF3 vdd vbnc vref vss sg13_hv_nmos w=15u l=3u ng=1
MF4 vdd vbnc vref vss sg13_hv_nmos w=15u l=3u ng=1
MSF vref ni vss vss sg13_hv_nmos w=2u l=6u ng=1
MSPD vref en_3v3_b vss vss sg13_hv_nmos w=1u l=0.45u ng=1
MMDC[3] vss vbnc vss vss sg13_hv_nmos w=2u l=3u ng=1
MDC[2] vss vbnc vss vss sg13_hv_nmos w=2u l=3u ng=1
MDC[1] vss vbnc vss vss sg13_hv_nmos w=2u l=3u ng=1
MDC[0] vss vbnc vss vss sg13_hv_nmos w=2u l=3u ng=1
MMDCX[2] vss vbnc vss vss sg13_hv_nmos w=15u l=3u ng=1
MDCX[1] vss vbnc vss vss sg13_hv_nmos w=15u l=3u ng=1
MDCX[0] vss vbnc vss vss sg13_hv_nmos w=15u l=3u ng=1
.ends

* expanding   symbol:  bypass_rb.sym # of pins=3
** sym_path: /home/user/sg13cmos5l_cm_ip__single2diff2single/macros/pad_ref_rb/schematic/xschem/bypass_rb.sym
** sch_path: /home/user/sg13cmos5l_cm_ip__single2diff2single/macros/pad_ref_rb/schematic/xschem/bypass_rb.sch
.subckt bypass_rb vss vcm vref
*.PININFO vss:B vcm:B vref:B
MCBM1 vss vcm vss vss sg13_hv_nmos w=19.24u l=12.66u ng=1 m=2
MCBM2 vss vcm vss vss sg13_hv_nmos w=8.18u l=3.25u ng=1 m=2
MCBM3 vss vcm vss vss sg13_hv_nmos w=2.9u l=12.4u ng=1
MCBR1 vss vref vss vss sg13_hv_nmos w=12u l=12u ng=1
MCBR2 vss vref vss vss sg13_hv_nmos w=34.1u l=16.9u ng=1 m=2
.ends
