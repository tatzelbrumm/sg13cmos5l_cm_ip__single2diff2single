** sch_path: /home/user/sg13cmos5l_cm_ip__single2diff2single/macros/bias_dist_pd/schematic/xschem/bias_dist_pd.sch
.subckt bias_dist_pd vddh vssh en_3v3 en_3v3_b iin0 iin1 iin2 iin3 en_in0 en_in1 en_in2 en_in3 iout0 iout1 iout2 iout3 en_out0
+ en_out1 en_out2 en_out3
*.PININFO vddh:B vssh:B en_3v3:I en_3v3_b:I iin0:B iin1:B iin2:B iin3:B en_in0:I en_in1:I en_in2:I en_in3:I iout0:O iout1:O
*+ iout2:O iout3:O en_out0:I en_out1:I en_out2:I en_out3:I
MTDN ni en_3v3_b vssh vssh sg13_hv_nmos w=1u l=0.45u ng=1
MNI ni ni vssh vssh sg13_hv_nmos w=6u l=6u ng=1
MNM vpd ni vssh vssh sg13_hv_nmos w=6u l=6u ng=1
MPD vpd vpd vddh vddh sg13_hv_pmos w=5u l=6u ng=1
MSVPD vpd en_3v3 vddh vddh sg13_hv_pmos w=1u l=0.45u ng=1
MPO0 po0 vpd vddh vddh sg13_hv_pmos w=5u l=6u ng=1
MPO1 po1 vpd vddh vddh sg13_hv_pmos w=5u l=6u ng=1
MPO2 po2 vpd vddh vddh sg13_hv_pmos w=5u l=6u ng=1
MPO3 po3 vpd vddh vddh sg13_hv_pmos w=5u l=6u ng=1
MMDP[1] vddh vpd vddh vddh sg13_hv_pmos w=5u l=6u ng=1
MDP[0] vddh vpd vddh vddh sg13_hv_pmos w=5u l=6u ng=1
MMDN[1] vssh ni vssh vssh sg13_hv_nmos w=2u l=6u ng=1
MDN[0] vssh ni vssh vssh sg13_hv_nmos w=2u l=6u ng=1
Xsi0 vddh vssh en_3v3 en_in0 iin0 ni bdp_slice
Xsi1 vddh vssh en_3v3 en_in1 iin1 ni bdp_slice
Xsi2 vddh vssh en_3v3 en_in2 iin2 ni bdp_slice
Xsi3 vddh vssh en_3v3 en_in3 iin3 ni bdp_slice
Xso0 vddh vssh en_3v3 en_out0 po0 iout0 bdp_slice
Xso1 vddh vssh en_3v3 en_out1 po1 iout1 bdp_slice
Xso2 vddh vssh en_3v3 en_out2 po2 iout2 bdp_slice
Xso3 vddh vssh en_3v3 en_out3 po3 iout3 bdp_slice
.ends

* expanding   symbol:  bdp_slice.sym # of pins=6
** sym_path: /home/user/sg13cmos5l_cm_ip__single2diff2single/macros/bias_dist_pd/schematic/xschem/bdp_slice.sym
** sch_path: /home/user/sg13cmos5l_cm_ip__single2diff2single/macros/bias_dist_pd/schematic/xschem/bdp_slice.sch
.subckt bdp_slice vdd vss en_3v3 en a b
*.PININFO vdd:B vss:B en_3v3:I en:I a:B b:B
XA vdd vss en_3v3 en e_b nand2_hv
XB vdd vss e_b e inv_hv
XT vdd vss e e_b a b tg_hv
.ends

* expanding   symbol:  nand2_hv.sym # of pins=5
** sym_path: /home/user/sg13cmos5l_cm_ip__single2diff2single/macros/hv_logic/schematic/xschem/nand2_hv.sym
** sch_path: /home/user/sg13cmos5l_cm_ip__single2diff2single/macros/hv_logic/schematic/xschem/nand2_hv.sch
.subckt nand2_hv vdd vss a b y
*.PININFO vdd:B vss:B a:I b:I y:O
MPA y a vdd vdd sg13_hv_pmos w=1u l=0.45u ng=1
MPB y b vdd vdd sg13_hv_pmos w=1u l=0.45u ng=1
MNA y a n1 vss sg13_hv_nmos w=1u l=0.45u ng=1
MNB n1 b vss vss sg13_hv_nmos w=1u l=0.45u ng=1
.ends

* expanding   symbol:  inv_hv.sym # of pins=4
** sym_path: /home/user/sg13cmos5l_cm_ip__single2diff2single/macros/hv_logic/schematic/xschem/inv_hv.sym
** sch_path: /home/user/sg13cmos5l_cm_ip__single2diff2single/macros/hv_logic/schematic/xschem/inv_hv.sch
.subckt inv_hv vdd vss a y
*.PININFO vdd:B vss:B a:I y:O
MP y a vdd vdd sg13_hv_pmos w=1u l=0.45u ng=1
MN y a vss vss sg13_hv_nmos w=1u l=0.45u ng=1
.ends

* expanding   symbol:  tg_hv.sym # of pins=6
** sym_path: /home/user/sg13cmos5l_cm_ip__single2diff2single/macros/hv_logic/schematic/xschem/tg_hv.sym
** sch_path: /home/user/sg13cmos5l_cm_ip__single2diff2single/macros/hv_logic/schematic/xschem/tg_hv.sch
.subckt tg_hv vdd vss en en_b a b
*.PININFO vdd:B vss:B en:I en_b:I a:B b:B
MN a en b vss sg13_hv_nmos w=1u l=0.45u ng=1
MP a en_b b vdd sg13_hv_pmos w=1u l=0.45u ng=1
.ends
