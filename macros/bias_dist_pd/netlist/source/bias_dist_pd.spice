* SPDX-FileCopyrightText: 2026 Christoph Maier
* SPDX-License-Identifier: Apache-2.0
* bias_dist_pd: switchable distribution mirror (2026-10-27; 4 inputs since 2026-11-07, Christoph: one shared set of
* sources for all pads, any combination of the Oguey-Aebischer core, the bandgap core and the harness ibias0 / ibias1).
* Sourced reference currents into iin0..3 (intended: iin0 = oa_core_pd, iin1 = bg_core_pd, iin2 = ibias0,
* iin3 = ibias1); every input with en_in<k> = 1 is passed by its
* transmission gate TIN / TIP into the NMOS diode NI, so enabled inputs add. NM copies the sum into the PMOS diode
* PD; the four PMOS outputs PO0..3 source it (1 : 1) through their transmission gates TON / TOP into iout0..3,
* each enabled by en_out<j>. iout<j> goes into a bias_tree_pd (NMOS input diode behind its own TG).
* en_3v3 = 0: every TG open, TDN pulls ni to vssh, SVPD pulls vpd to vddh. Gates: hv_logic (nand2_hv, inv_hv).
* Supply ports vddh / vssh (2026-11-07, as pad_ref_rb's: they connect either to the pads' rails or the slot's 3.3 V).
.subckt bias_dist_pd vddh vssh en_3v3 en_3v3_b iin0 iin1 iin2 iin3 en_in0 en_in1 en_in2 en_in3 iout0 iout1 iout2 iout3 en_out0 en_out1 en_out2 en_out3
XIA0 vddh vssh en_3v3 en_in0 ei0_b nand2_hv
XIB0 vddh vssh ei0_b ei0 inv_hv
XTIN0 iin0 ei0 ni vssh sg13_hv_nmos w=1u l=0.45u ng=1
XTIP0 iin0 ei0_b ni vddh sg13_hv_pmos w=1u l=0.45u ng=1
XIA1 vddh vssh en_3v3 en_in1 ei1_b nand2_hv
XIB1 vddh vssh ei1_b ei1 inv_hv
XTIN1 iin1 ei1 ni vssh sg13_hv_nmos w=1u l=0.45u ng=1
XTIP1 iin1 ei1_b ni vddh sg13_hv_pmos w=1u l=0.45u ng=1
XIA2 vddh vssh en_3v3 en_in2 ei2_b nand2_hv
XIB2 vddh vssh ei2_b ei2 inv_hv
XTIN2 iin2 ei2 ni vssh sg13_hv_nmos w=1u l=0.45u ng=1
XTIP2 iin2 ei2_b ni vddh sg13_hv_pmos w=1u l=0.45u ng=1
XIA3 vddh vssh en_3v3 en_in3 ei3_b nand2_hv
XIB3 vddh vssh ei3_b ei3 inv_hv
XTIN3 iin3 ei3 ni vssh sg13_hv_nmos w=1u l=0.45u ng=1
XTIP3 iin3 ei3_b ni vddh sg13_hv_pmos w=1u l=0.45u ng=1
XTDN ni en_3v3_b vssh vssh sg13_hv_nmos w=1u l=0.45u ng=1
XNI ni ni vssh vssh sg13_hv_nmos w=6u l=6u ng=1
XNM vpd ni vssh vssh sg13_hv_nmos w=6u l=6u ng=1
XPD vpd vpd vddh vddh sg13_hv_pmos w=5u l=6u ng=1
XSVPD vpd en_3v3 vddh vddh sg13_hv_pmos w=1u l=0.45u ng=1
XOA0 vddh vssh en_3v3 en_out0 eo0_b nand2_hv
XOB0 vddh vssh eo0_b eo0 inv_hv
XPO0 po0 vpd vddh vddh sg13_hv_pmos w=5u l=6u ng=1
XTON0 po0 eo0 iout0 vssh sg13_hv_nmos w=1u l=0.45u ng=1
XTOP0 po0 eo0_b iout0 vddh sg13_hv_pmos w=1u l=0.45u ng=1
XOA1 vddh vssh en_3v3 en_out1 eo1_b nand2_hv
XOB1 vddh vssh eo1_b eo1 inv_hv
XPO1 po1 vpd vddh vddh sg13_hv_pmos w=5u l=6u ng=1
XTON1 po1 eo1 iout1 vssh sg13_hv_nmos w=1u l=0.45u ng=1
XTOP1 po1 eo1_b iout1 vddh sg13_hv_pmos w=1u l=0.45u ng=1
XOA2 vddh vssh en_3v3 en_out2 eo2_b nand2_hv
XOB2 vddh vssh eo2_b eo2 inv_hv
XPO2 po2 vpd vddh vddh sg13_hv_pmos w=5u l=6u ng=1
XTON2 po2 eo2 iout2 vssh sg13_hv_nmos w=1u l=0.45u ng=1
XTOP2 po2 eo2_b iout2 vddh sg13_hv_pmos w=1u l=0.45u ng=1
XOA3 vddh vssh en_3v3 en_out3 eo3_b nand2_hv
XOB3 vddh vssh eo3_b eo3 inv_hv
XPO3 po3 vpd vddh vddh sg13_hv_pmos w=5u l=6u ng=1
XTON3 po3 eo3 iout3 vssh sg13_hv_nmos w=1u l=0.45u ng=1
XTOP3 po3 eo3_b iout3 vddh sg13_hv_pmos w=1u l=0.45u ng=1
* --- layout dummies [DM] (agent D, 2026-11-07): the matched rows end in dummies in the pads' convention, D = S = B on
*     the rail, gate by poly abutment: MDN at both ends of the NMOS row D NI NM D (rb_mirror's code), MDP at both ends of
*     the PMOS row D PO0 PO1 PD PO2 PO3 D (rb_tails' code). No current.
XMDN[1] vssh ni vssh vssh sg13_hv_nmos w=2u l=6u ng=1
XMDN[0] vssh ni vssh vssh sg13_hv_nmos w=2u l=6u ng=1
XMDP[1] vddh vpd vddh vddh sg13_hv_pmos w=5u l=6u ng=1
XMDP[0] vddh vpd vddh vddh sg13_hv_pmos w=5u l=6u ng=1
.ends bias_dist_pd
