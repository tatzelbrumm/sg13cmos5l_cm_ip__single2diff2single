* SPDX-FileCopyrightText: 2026 Christoph Maier
* SPDX-License-Identifier: Apache-2.0
* bias_dist_pd: switchable distribution mirror (2026-10-27; 4 inputs since 2026-11-07, Christoph: one shared set of
* sources for all pads, any combination of the Oguey-Aebischer core, the bandgap core and the harness ibias0 / ibias1).
* Sourced reference currents into iin0..3 (intended: iin0 = oa_core_pd, iin1 = bg_core_pd, iin2 = ibias0,
* iin3 = ibias1; outputs iout0 = pad_ref_rb, iout1 = S2D, iout2 = D2S, iout3 = spare: PO1 / PO2 are the layout's inner
* pair beside PD, Christoph 2026-11-08: "both pads on the inner pair please"); every input with en_in<k> = 1 is passed by its
* transmission gate TIN / TIP into the NMOS diode NI, so enabled inputs add. NM copies the sum into the PMOS diode
* PD; the four PMOS outputs PO0..3 source it (1 : 1) through their transmission gates TON / TOP into iout0..3,
* each enabled by en_out<j>. iout<j> goes into a bias_tree_pd (NMOS input diode behind its own TG).
* en_3v3 = 0: every TG open, TDN pulls ni to vssh, SVPD pulls vpd to vddh. Gates: hv_logic (nand2_hv, inv_hv, tg_hv).
* Hierarchy as in the layout (2026-11-08, Christoph: backannotate the logic / transmission gate hierarchy): 8 legs as
* bdp_slice (nand2_hv | inv_hv | tg_hv); TDN, SVPD, the mirrors and their dummies flat.
* Supply ports vddh / vssh (2026-11-07, as pad_ref_rb's: they connect either to the pads' rails or the slot's 3.3 V).
* bdp_slice: one switched leg, as agent D's layout cell bdp_slice (2026-11-07 / 08): e_b = NAND(en_3v3, en), e = NOT e_b,
* the transmission gate tg_hv between a and b conducts while e = 1 (en_3v3 = 1 and en = 1).
.subckt bdp_slice vdd vss en_3v3 en a b
XA vdd vss en_3v3 en e_b nand2_hv
XB vdd vss e_b e inv_hv
XT vdd vss e e_b a b tg_hv
.ends bdp_slice

.subckt bias_dist_pd vddh vssh en_3v3 en_3v3_b iin0 iin1 iin2 iin3 en_in0 en_in1 en_in2 en_in3 iout0 iout1 iout2 iout3 en_out0 en_out1 en_out2 en_out3
* --- input slices (layout: bdp_slice in0..in3): en_3v3 AND en_in<k> passes iin<k> into ni
Xsi0 vddh vssh en_3v3 en_in0 iin0 ni bdp_slice
Xsi1 vddh vssh en_3v3 en_in1 iin1 ni bdp_slice
Xsi2 vddh vssh en_3v3 en_in2 iin2 ni bdp_slice
Xsi3 vddh vssh en_3v3 en_in3 iin3 ni bdp_slice
* --- output slices (layout: bdp_slice out0..out3): en_3v3 AND en_out<j> passes po<j> to iout<j>
Xso0 vddh vssh en_3v3 en_out0 po0 iout0 bdp_slice
Xso1 vddh vssh en_3v3 en_out1 po1 iout1 bdp_slice
Xso2 vddh vssh en_3v3 en_out2 po2 iout2 bdp_slice
Xso3 vddh vssh en_3v3 en_out3 po3 iout3 bdp_slice
XTDN ni en_3v3_b vssh vssh sg13_hv_nmos w=1u l=0.45u ng=1
XNI ni ni vssh vssh sg13_hv_nmos w=6u l=6u ng=1
XNM vpd ni vssh vssh sg13_hv_nmos w=6u l=6u ng=1
XPD vpd vpd vddh vddh sg13_hv_pmos w=5u l=6u ng=1
XSVPD vpd en_3v3 vddh vddh sg13_hv_pmos w=1u l=0.45u ng=1
XPO0 po0 vpd vddh vddh sg13_hv_pmos w=5u l=6u ng=1
XPO1 po1 vpd vddh vddh sg13_hv_pmos w=5u l=6u ng=1
XPO2 po2 vpd vddh vddh sg13_hv_pmos w=5u l=6u ng=1
XPO3 po3 vpd vddh vddh sg13_hv_pmos w=5u l=6u ng=1
* --- layout dummies [DM] (agent D, 2026-11-07): the matched rows end in dummies in the pads' convention, D = S = B on
*     the rail, gate by poly abutment: MDN at both ends of the NMOS row D NI NM D (rb_mirror's code), MDP at both ends of
*     the PMOS row D PO0 PO1 PD PO2 PO3 D (rb_tails' code). No current.
XMDN[1] vssh ni vssh vssh sg13_hv_nmos w=2u l=6u ng=1
XMDN[0] vssh ni vssh vssh sg13_hv_nmos w=2u l=6u ng=1
XMDP[1] vddh vpd vddh vddh sg13_hv_pmos w=5u l=6u ng=1
XMDP[0] vddh vpd vddh vddh sg13_hv_pmos w=5u l=6u ng=1
.ends bias_dist_pd
