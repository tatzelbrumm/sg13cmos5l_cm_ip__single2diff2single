* Extracted by KLayout with SG13CMOS5L LVS runset on : 08/11/2026 12:10

.SUBCKT bias_dist_pd en_3v3 en_3v3_b en_in0 en_in1 en_in2 en_in3 en_out0
+ en_out1 en_out2 en_out3 iin0 iin1 iin2 iin3 iout0 iout1 iout2 iout3 vddh vssh
X$1 en_3v3 en_in0 iin0 \$9 vssh vddh bdp_slice
X$2 en_3v3 en_in1 iin1 \$9 vssh vddh bdp_slice
X$3 en_3v3 en_in2 iin2 \$9 vssh vddh bdp_slice
X$4 en_3v3 en_in3 iin3 \$9 vssh vddh bdp_slice
X$5 en_3v3 en_out0 \$26 iout0 vssh vddh bdp_slice
X$6 en_3v3 en_out1 \$27 iout1 vssh vddh bdp_slice
X$7 en_3v3 en_out2 \$29 iout2 vssh vddh bdp_slice
X$8 en_3v3 en_out3 \$30 iout3 vssh vddh bdp_slice
M$1 vddh en_3v3 \$28 vddh sg13_hv_pmos L=0.45u W=1u AS=0.34p AD=0.34p PS=2.68u
+ PD=2.68u rfmode=0
M$2 vssh en_3v3_b \$9 vssh sg13_hv_nmos L=0.45u W=1u AS=0.34p AD=0.34p PS=2.68u
+ PD=2.68u rfmode=0
M$3 vddh \$28 \$28 vddh sg13_hv_pmos L=6u W=5u AS=1.7p AD=1.7p PS=10.68u
+ PD=10.68u rfmode=0
M$4 vddh \$28 vddh vddh sg13_hv_pmos L=6u W=10u AS=3.4p AD=3.4p PS=21.36u
+ PD=21.36u rfmode=0
M$5 vddh \$28 \$30 vddh sg13_hv_pmos L=6u W=5u AS=1.7p AD=1.7p PS=10.68u
+ PD=10.68u rfmode=0
M$6 vddh \$28 \$29 vddh sg13_hv_pmos L=6u W=5u AS=1.7p AD=1.7p PS=10.68u
+ PD=10.68u rfmode=0
M$7 vddh \$28 \$27 vddh sg13_hv_pmos L=6u W=5u AS=1.7p AD=1.7p PS=10.68u
+ PD=10.68u rfmode=0
M$8 vddh \$28 \$26 vddh sg13_hv_pmos L=6u W=5u AS=1.7p AD=1.7p PS=10.68u
+ PD=10.68u rfmode=0
M$10 \$9 \$9 vssh vssh sg13_hv_nmos L=6u W=6u AS=2.04p AD=2.04p PS=12.68u
+ PD=12.68u rfmode=0
M$11 \$28 \$9 vssh vssh sg13_hv_nmos L=6u W=6u AS=2.04p AD=2.04p PS=12.68u
+ PD=12.68u rfmode=0
M$12 vssh \$9 vssh vssh sg13_hv_nmos L=6u W=4u AS=1.36p AD=1.36p PS=9.36u
+ PD=9.36u rfmode=0
.ENDS bias_dist_pd

.SUBCKT bdp_slice \$2 \$3 \$4 \$5 \$6 \$I2
M$1 \$7 \$2 \$I5 \$6 sg13_hv_nmos L=0.45u W=1u AS=0.34p AD=0.19p PS=2.68u
+ PD=1.38u rfmode=0
M$2 \$I5 \$3 \$6 \$6 sg13_hv_nmos L=0.45u W=1u AS=0.19p AD=0.19p PS=1.38u
+ PD=1.38u rfmode=0
M$3 \$6 \$7 \$1 \$6 sg13_hv_nmos L=0.45u W=1u AS=0.19p AD=0.34p PS=1.38u
+ PD=2.68u rfmode=0
M$4 \$I2 \$2 \$7 \$I2 sg13_hv_pmos L=0.45u W=1u AS=0.34p AD=0.19p PS=2.68u
+ PD=1.38u rfmode=0
M$5 \$7 \$3 \$I2 \$I2 sg13_hv_pmos L=0.45u W=1u AS=0.19p AD=0.19p PS=1.38u
+ PD=1.38u rfmode=0
M$6 \$I2 \$7 \$1 \$I2 sg13_hv_pmos L=0.45u W=1u AS=0.19p AD=0.34p PS=1.38u
+ PD=2.68u rfmode=0
M$7 \$4 \$1 \$5 \$6 sg13_hv_nmos L=0.45u W=1u AS=0.34p AD=0.34p PS=2.68u
+ PD=2.68u rfmode=0
M$8 \$4 \$7 \$5 \$I2 sg13_hv_pmos L=0.45u W=1u AS=0.34p AD=0.34p PS=2.68u
+ PD=2.68u rfmode=0
.ENDS bdp_slice
