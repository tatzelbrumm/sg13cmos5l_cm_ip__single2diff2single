* PEX produced on Mon Aug 31 09:29:44 PM CEST 2026 using /foss/tools/sak/sak-pex.sh with m=3 and s=1 (extresist threshold=10000 mOhm, minres=1000 mOhm, mindelay=1 ps)
* NGSPICE file created from counter_top_pex.ext - technology: ihp-sg13cmos5l

.subckt counter_top_pex VDD VSS clock_i reset_n_i enable_i counter_value_o[0]
+ counter_value_o[1] counter_value_o[2] counter_value_o[3] counter_value_o[4]
+ counter_value_o[5] counter_value_o[6] counter_value_o[7]
X0 VDD VSS.t876 VDD VDD sg13_lv_pmos ad=0.19p pd=1.38u as=3.19196n ps=0.01242 w=1u l=1u
X1 VDD enable_i a_1192_3900# VDD sg13_lv_pmos ad=0.2114p pd=1.54u as=0.2856p ps=2.36u w=0.84u l=0.13u
X2 VDD VSS.t2621 VDD VDD sg13_lv_pmos ad=0.19p pd=1.38u as=0 ps=0 w=1u l=1u
X3 VSS.t11 a_4432_15454# a_4081_15311# VSS.t47 sg13_lv_nmos ad=79.8f pd=0.8u as=0.1428p ps=1.52u w=0.42u l=0.13u
X4 VDD VSS.t1714 VDD VDD sg13_lv_pmos ad=0.34p pd=2.68u as=0 ps=0 w=1u l=1u
X5 VSS.t2002 VDD VSS.t2004 VSS.t2003 sg13_lv_nmos ad=79.8f pd=0.8u as=0 ps=0 w=0.42u l=1u
X6 VDD sg13cmos5l_and2_1_2.B a_8685_14832# VDD sg13_lv_pmos ad=0.1918p pd=1.5u as=0.1596p ps=1.22u w=0.84u l=0.13u
X7 VDD VSS.t583 VDD VDD sg13_lv_pmos ad=0.34p pd=2.68u as=0 ps=0 w=1u l=1u
X8 VSS.t1565 VDD VSS.t1567 VSS.t1566 sg13_lv_nmos ad=79.8f pd=0.8u as=0 ps=0 w=0.42u l=1u
X9 VSS.t3082 VDD VSS.t3084 VSS.t3083 sg13_lv_nmos ad=79.8f pd=0.8u as=0 ps=0 w=0.42u l=1u
X10 VDD VSS.t1161 VDD VDD sg13_lv_pmos ad=0.34p pd=2.68u as=0 ps=0 w=1u l=1u
X11 VSS.t1957 VDD VSS.t1956 VSS.t1955 sg13_lv_nmos ad=0.1428p pd=1.52u as=0 ps=0 w=0.42u l=1u
X12 VDD VSS.t813 VDD VDD sg13_lv_pmos ad=0.34p pd=2.68u as=0 ps=0 w=1u l=1u
X13 VSS.t2631 VDD VSS.t2632 VSS.t198 sg13_lv_nmos ad=79.8f pd=0.8u as=0 ps=0 w=0.42u l=1u
X14 VSS.t1304 VDD VSS.t1303 VSS.t1154 sg13_lv_nmos ad=0.1428p pd=1.52u as=0 ps=0 w=0.42u l=1u
X15 VDD VSS.t2403 VDD VDD sg13_lv_pmos ad=0.34p pd=2.68u as=0 ps=0 w=1u l=1u
X16 VDD VSS.t2061 VDD VDD sg13_lv_pmos ad=0.34p pd=2.68u as=0 ps=0 w=1u l=1u
X17 VDD VSS.t1836 VDD VDD sg13_lv_pmos ad=0.34p pd=2.68u as=0 ps=0 w=1u l=1u
X18 VDD VSS.t2632 VDD VDD sg13_lv_pmos ad=0.34p pd=2.68u as=0 ps=0 w=1u l=1u
X19 VSS.t934 VDD VSS.t933 VSS.t932 sg13_lv_nmos ad=0.1428p pd=1.52u as=0 ps=0 w=0.42u l=1u
X20 VDD VSS.t550 VDD VDD sg13_lv_pmos ad=0.34p pd=2.68u as=0 ps=0 w=1u l=1u
X21 VSS.t979 VDD VSS.t978 VSS.t977 sg13_lv_nmos ad=0.1428p pd=1.52u as=0 ps=0 w=0.42u l=1u
X22 VDD VSS.t1170 VDD VDD sg13_lv_pmos ad=0.34p pd=2.68u as=0 ps=0 w=1u l=1u
X23 a_27500_15960# sg13cmos5l_dfrbpq_1_6.Q VSS.t59 VSS.t88 sg13_lv_nmos ad=0.187p pd=1.78u as=0.14875p ps=1.16u w=0.55u l=0.13u
X24 VDD VSS.t1031 VDD VDD sg13_lv_pmos ad=0.19p pd=1.38u as=0 ps=0 w=1u l=1u
X25 VDD VSS.t1281 VDD VDD sg13_lv_pmos ad=0.19p pd=1.38u as=0 ps=0 w=1u l=1u
X26 VDD a_27407_13799# a_27664_13942# VDD sg13_lv_pmos ad=2.42015p pd=15.68u as=79.8f ps=0.8u w=0.42u l=0.13u
X27 VDD VSS.t843 VDD VDD sg13_lv_pmos ad=0.34p pd=2.68u as=0 ps=0 w=1u l=1u
X28 VSS.t2677 VDD VSS.t2677 VSS.t198 sg13_lv_nmos ad=0.1428p pd=1.52u as=0 ps=0 w=0.42u l=1u
X29 VDD sg13cmos5l_xnor2_1_2.A sg13cmos5l_nand4_1_0.Y VDD sg13_lv_pmos ad=0.2128p pd=1.5u as=0.2128p ps=1.5u w=1.12u l=0.13u
X30 VSS.t2489 VDD VSS.t2491 VSS.t2490 sg13_lv_nmos ad=79.8f pd=0.8u as=0 ps=0 w=0.42u l=1u
X31 a_19450_15202# sg13cmos5l_dfrbpq_1_3.Q VSS.t52 VSS.t18 sg13_lv_nmos ad=0.1428p pd=1.52u as=79.8f ps=0.8u w=0.42u l=0.13u
X32 VDD VSS.t632 VDD VDD sg13_lv_pmos ad=0.19p pd=1.38u as=0 ps=0 w=1u l=1u
X33 VDD VSS.t1557 VDD VDD sg13_lv_pmos ad=0.19p pd=1.38u as=0 ps=0 w=1u l=1u
X34 VDD VSS.t3016 VDD VDD sg13_lv_pmos ad=0.34p pd=2.68u as=0 ps=0 w=1u l=1u
X35 VSS.t2749 VDD VSS.t2748 VSS.t198 sg13_lv_nmos ad=0.1428p pd=1.52u as=0 ps=0 w=0.42u l=1u
X36 VDD VSS.t1891 VDD VDD sg13_lv_pmos ad=0.34p pd=2.68u as=0 ps=0 w=1u l=1u
X37 a_26436_13735# a_26148_14040# a_26374_13735# VSS.t170 sg13_lv_nmos ad=0.1428p pd=1.52u as=37.8f ps=0.6u w=0.42u l=0.13u
X38 VSS.t899 VDD VSS.t901 VSS.t900 sg13_lv_nmos ad=79.8f pd=0.8u as=0 ps=0 w=0.42u l=1u
X39 VSS.t1987 VDD VSS.t1989 VSS.t1988 sg13_lv_nmos ad=79.8f pd=0.8u as=0 ps=0 w=0.42u l=1u
X40 VDD VSS.t1562 VDD VDD sg13_lv_pmos ad=0.19p pd=1.38u as=0 ps=0 w=1u l=1u
X41 VSS.t1318 VDD VSS.t1317 VSS.t1154 sg13_lv_nmos ad=0.1428p pd=1.52u as=0 ps=0 w=0.42u l=1u
X42 VSS.t2623 VDD VSS.t2624 VSS.t198 sg13_lv_nmos ad=79.8f pd=0.8u as=0 ps=0 w=0.42u l=1u
X43 VDD VSS.t906 VDD VDD sg13_lv_pmos ad=0.19p pd=1.38u as=0 ps=0 w=1u l=1u
X44 VSS.t949 VDD VSS.t948 VSS.t947 sg13_lv_nmos ad=0.1428p pd=1.52u as=0 ps=0 w=0.42u l=1u
X45 VSS.t2359 VDD VSS.t2361 VSS.t2360 sg13_lv_nmos ad=79.8f pd=0.8u as=0 ps=0 w=0.42u l=1u
X46 VSS.t1907 VDD VSS.t1906 VSS.t1905 sg13_lv_nmos ad=0.1428p pd=1.52u as=0 ps=0 w=0.42u l=1u
X47 VDD VSS.t1904 VDD VDD sg13_lv_pmos ad=0.19p pd=1.38u as=0 ps=0 w=1u l=1u
X48 VSS.t774 VDD VSS.t776 VSS.t775 sg13_lv_nmos ad=79.8f pd=0.8u as=0 ps=0 w=0.42u l=1u
X49 VDD VSS.t428 VDD VDD sg13_lv_pmos ad=0.34p pd=2.68u as=0 ps=0 w=1u l=1u
X50 VDD VSS.t833 VDD VDD sg13_lv_pmos ad=0.34p pd=2.68u as=0 ps=0 w=1u l=1u
X51 VDD VSS.t2029 VDD VDD sg13_lv_pmos ad=0.19p pd=1.38u as=0 ps=0 w=1u l=1u
X52 a_17412_14922# sg13cmos5l_dfrbpq_1_3.D a_17318_14922# VSS.t57 sg13_lv_nmos ad=60.89999f pd=0.71u as=0.1428p ps=1.52u w=0.42u l=0.13u
X53 VSS.t1450 VDD VSS.t1449 VSS.t1448 sg13_lv_nmos ad=0.1428p pd=1.52u as=0 ps=0 w=0.42u l=1u
X54 VDD VSS.t1261 VDD VDD sg13_lv_pmos ad=0.34p pd=2.68u as=0 ps=0 w=1u l=1u
X55 VDD VSS.t3131 VDD VDD sg13_lv_pmos ad=0.34p pd=2.68u as=0 ps=0 w=1u l=1u
X56 VSS.t2638 VDD VSS.t2638 VSS.t198 sg13_lv_nmos ad=0.1428p pd=1.52u as=0 ps=0 w=0.42u l=1u
X57 VDD a_25774_15423# sg13cmos5l_dfrbpq_1_7.D VDD sg13_lv_pmos ad=0.2254p pd=1.53u as=0.4256p ps=3u w=1.12u l=0.13u
X58 VDD VSS.t686 VDD VDD sg13_lv_pmos ad=0.19p pd=1.38u as=0 ps=0 w=1u l=1u
X59 VSS.t1009 VDD VSS.t1011 VSS.t1010 sg13_lv_nmos ad=79.8f pd=0.8u as=0 ps=0 w=0.42u l=1u
X60 VSS.t2694 VDD VSS.t2696 VSS.t198 sg13_lv_nmos ad=79.8f pd=0.8u as=0 ps=0 w=0.42u l=1u
X61 VDD VSS.t1712 VDD VDD sg13_lv_pmos ad=0.19p pd=1.38u as=0 ps=0 w=1u l=1u
X62 VDD a_18021_14495# a_18123_14495# VDD sg13_lv_pmos ad=2.42015p pd=15.68u as=0.3864p ps=2.93u w=1.12u l=0.13u
X63 VDD a_22319_14845# a_22986_14484# VDD sg13_lv_pmos ad=0.2128p pd=1.5u as=0.3864p ps=2.93u w=1.12u l=0.13u
X64 VSS.t869 VDD VSS.t868 VSS.t867 sg13_lv_nmos ad=0.1428p pd=1.52u as=0 ps=0 w=0.42u l=1u
X65 VDD VSS.t1542 VDD VDD sg13_lv_pmos ad=0.19p pd=1.38u as=0 ps=0 w=1u l=1u
X66 VSS.t385 VDD VSS.t384 VSS.t383 sg13_lv_nmos ad=0.1428p pd=1.52u as=0 ps=0 w=0.42u l=1u
X67 VDD VSS.t588 VDD VDD sg13_lv_pmos ad=0.34p pd=2.68u as=0 ps=0 w=1u l=1u
X68 VSS.t1204 VDD VSS.t1205 VSS.t1154 sg13_lv_nmos ad=79.8f pd=0.8u as=0 ps=0 w=0.42u l=1u
X69 VDD VSS.t1299 VDD VDD sg13_lv_pmos ad=0.19p pd=1.38u as=0 ps=0 w=1u l=1u
X70 VDD VSS.t291 VDD VDD sg13_lv_pmos ad=0.34p pd=2.68u as=0 ps=0 w=1u l=1u
X71 VSS.t2650 VDD VSS.t2649 VSS.t198 sg13_lv_nmos ad=0.1428p pd=1.52u as=0 ps=0 w=0.42u l=1u
X72 VDD VSS.t2456 VDD VDD sg13_lv_pmos ad=0.19p pd=1.38u as=0 ps=0 w=1u l=1u
X73 VDD sg13cmos5l_dlygate4sd3_1_4.X a_17165_16020# VDD sg13_lv_pmos ad=0.3822p pd=1.84u as=0.1575p ps=1.315u w=1u l=0.13u
X74 VSS.t1942 VDD VSS.t1941 VSS.t1940 sg13_lv_nmos ad=0.1428p pd=1.52u as=0 ps=0 w=0.42u l=1u
X75 VSS.t3022 VDD VSS.t3021 VSS.t3020 sg13_lv_nmos ad=0.1428p pd=1.52u as=0 ps=0 w=0.42u l=1u
X76 VSS.t279 VDD VSS.t279 VSS.t281 sg13_lv_nmos ad=0.1428p pd=1.52u as=0 ps=0 w=0.42u l=1u
X77 VDD VSS.t2243 VDD VDD sg13_lv_pmos ad=0.34p pd=2.68u as=0 ps=0 w=1u l=1u
X78 VDD VSS.t796 VDD VDD sg13_lv_pmos ad=0.19p pd=1.38u as=0 ps=0 w=1u l=1u
X79 VDD VSS.t1507 VDD VDD sg13_lv_pmos ad=0.19p pd=1.38u as=0 ps=0 w=1u l=1u
X80 VDD VSS.t2416 VDD VDD sg13_lv_pmos ad=0.19p pd=1.38u as=0 ps=0 w=1u l=1u
X81 VSS.t2474 VDD VSS.t2476 VSS.t2475 sg13_lv_nmos ad=79.8f pd=0.8u as=0 ps=0 w=0.42u l=1u
X82 VSS.t405 VDD VSS.t406 VSS.t11 sg13_lv_nmos ad=79.8f pd=0.8u as=0 ps=0 w=0.42u l=1u
X83 VDD VSS.t241 VDD VDD sg13_lv_pmos ad=0.34p pd=2.68u as=0 ps=0 w=1u l=1u
X84 VDD VSS.t508 VDD VDD sg13_lv_pmos ad=0.34p pd=2.68u as=0 ps=0 w=1u l=1u
X85 VSS.t979 VDD VSS.t978 VSS.t977 sg13_lv_nmos ad=0.1428p pd=1.52u as=0 ps=0 w=0.42u l=1u
X86 VSS.t1852 VDD VSS.t1851 VSS.t1850 sg13_lv_nmos ad=0.1428p pd=1.52u as=0 ps=0 w=0.42u l=1u
X87 VDD VSS.t550 VDD VDD sg13_lv_pmos ad=0.34p pd=2.68u as=0 ps=0 w=1u l=1u
X88 VSS.t1640 VDD VSS.t1642 VSS.t1641 sg13_lv_nmos ad=79.8f pd=0.8u as=0 ps=0 w=0.42u l=1u
X89 VSS.t2022 VDD VSS.t2024 VSS.t2023 sg13_lv_nmos ad=79.8f pd=0.8u as=0 ps=0 w=0.42u l=1u
X90 VSS.t1187 VDD VSS.t1188 VSS.t1154 sg13_lv_nmos ad=79.8f pd=0.8u as=0 ps=0 w=0.42u l=1u
X91 VDD VSS.t1951 VDD VDD sg13_lv_pmos ad=0.34p pd=2.68u as=0 ps=0 w=1u l=1u
X92 VSS.t75 a_26633_16334# a_26554_16237# VSS.t220 sg13_lv_nmos ad=7.70437p pd=50.66u as=0.27427p ps=2.28u w=0.795u l=0.13u
X93 VDD VSS.t1308 VDD VDD sg13_lv_pmos ad=0.19p pd=1.38u as=0 ps=0 w=1u l=1u
X94 sg13cmos5l_dfrbpq_1_2.D sg13cmos5l_a21oi_1_3.B1 VSS.t21 VSS.t20 sg13_lv_nmos ad=0.1406p pd=1.12u as=0.2516p ps=2.16u w=0.74u l=0.13u
X95 a_2516_14484# a_2490_14447# sg13cmos5l_xor2_1_0.X VDD sg13_lv_pmos ad=0.2128p pd=1.5u as=0.3808p ps=2.92u w=1.12u l=0.13u
X96 VSS.t2670 VDD VSS.t2669 VSS.t198 sg13_lv_nmos ad=0.1428p pd=1.52u as=0 ps=0 w=0.42u l=1u
X97 VDD VSS.t436 VDD VDD sg13_lv_pmos ad=0.19p pd=1.38u as=0 ps=0 w=1u l=1u
X98 VSS.t899 VDD VSS.t901 VSS.t900 sg13_lv_nmos ad=79.8f pd=0.8u as=0 ps=0 w=0.42u l=1u
X99 VDD VSS.t888 VDD VDD sg13_lv_pmos ad=0.34p pd=2.68u as=0 ps=0 w=1u l=1u
X100 VDD VSS.t1719 VDD VDD sg13_lv_pmos ad=0.34p pd=2.68u as=0 ps=0 w=1u l=1u
X101 VDD VSS.t325 VDD VDD sg13_lv_pmos ad=0.19p pd=1.38u as=0 ps=0 w=1u l=1u
X102 VSS.t1570 VDD VSS.t1572 VSS.t1571 sg13_lv_nmos ad=79.8f pd=0.8u as=0 ps=0 w=0.42u l=1u
X103 VSS.t3087 VDD VSS.t3089 VSS.t3088 sg13_lv_nmos ad=79.8f pd=0.8u as=0 ps=0 w=0.42u l=1u
X104 VDD VSS.t573 VDD VDD sg13_lv_pmos ad=0.34p pd=2.68u as=0 ps=0 w=1u l=1u
X105 VSS.t608 VDD VSS.t605 VSS.t607 sg13_lv_nmos ad=0.1428p pd=1.52u as=0 ps=0 w=0.42u l=1u
X106 VDD VSS.t1013 VDD VDD sg13_lv_pmos ad=0.34p pd=2.68u as=0 ps=0 w=1u l=1u
X107 VDD a_3130_16237# sg13cmos5l_dfrbpq_1_0.RESET_B VDD sg13_lv_pmos ad=2.8961p pd=18.25u as=0.3927p ps=2.99u w=1.155u l=0.13u
X108 VSS.t620 VDD VSS.t620 VSS.t750 sg13_lv_nmos ad=0.1428p pd=1.52u as=0 ps=0 w=0.42u l=1u
X109 VSS.t2344 VDD VSS.t2346 VSS.t2345 sg13_lv_nmos ad=79.8f pd=0.8u as=0 ps=0 w=0.42u l=1u
X110 VDD VSS.t2408 VDD VDD sg13_lv_pmos ad=0.34p pd=2.68u as=0 ps=0 w=1u l=1u
X111 VSS.t774 VDD VSS.t776 VSS.t775 sg13_lv_nmos ad=79.8f pd=0.8u as=0 ps=0 w=0.42u l=1u
X112 VDD VSS.t763 VDD VDD sg13_lv_pmos ad=0.34p pd=2.68u as=0 ps=0 w=1u l=1u
X113 VDD VSS.t951 VDD VDD sg13_lv_pmos ad=0.19p pd=1.38u as=0 ps=0 w=1u l=1u
X114 VDD VSS.t2066 VDD VDD sg13_lv_pmos ad=0.34p pd=2.68u as=0 ps=0 w=1u l=1u
X115 VSS.t531 VDD VSS.t533 VSS.t532 sg13_lv_nmos ad=79.8f pd=0.8u as=0 ps=0 w=0.42u l=1u
X116 VDD VSS.t366 VDD VDD sg13_lv_pmos ad=0.34p pd=2.68u as=0 ps=0 w=1u l=1u
X117 VDD sg13cmos5l_dlygate4sd3_1_0.X a_5613_14832# VDD sg13_lv_pmos ad=0.1918p pd=1.5u as=0.1596p ps=1.22u w=0.84u l=0.13u
X118 VDD VSS.t209 VDD VDD sg13_lv_pmos ad=0.19p pd=1.38u as=0 ps=0 w=1u l=1u
X119 VDD VSS.t1229 VDD VDD sg13_lv_pmos ad=0.19p pd=1.38u as=0 ps=0 w=1u l=1u
X120 VDD VSS.t2728 VDD VDD sg13_lv_pmos ad=0.19p pd=1.38u as=0 ps=0 w=1u l=1u
X121 VSS.t2429 VDD VSS.t2428 VSS.t2427 sg13_lv_nmos ad=0.1428p pd=1.52u as=0 ps=0 w=0.42u l=1u
X122 VSS.t2042 VDD VSS.t2044 VSS.t2043 sg13_lv_nmos ad=79.8f pd=0.8u as=0 ps=0 w=0.42u l=1u
X123 sg13cmos5l_a21oi_1_0.A2 a_16969_16020# VSS.t83 VSS.t260 sg13_lv_nmos ad=0.2516p pd=2.16u as=0.13395p ps=1.12u w=0.74u l=0.13u
X124 VSS.t869 VDD VSS.t868 VSS.t867 sg13_lv_nmos ad=0.1428p pd=1.52u as=0 ps=0 w=0.42u l=1u
X125 VSS.t1164 VDD VSS.t1165 VSS.t1154 sg13_lv_nmos ad=79.8f pd=0.8u as=0 ps=0 w=0.42u l=1u
X126 VDD VSS.t2109 VDD VDD sg13_lv_pmos ad=0.19p pd=1.38u as=0 ps=0 w=1u l=1u
X127 VSS.t423 VDD VSS.t424 VSS.t11 sg13_lv_nmos ad=79.8f pd=0.8u as=0 ps=0 w=0.42u l=1u
X128 VDD VSS.t416 VDD VDD sg13_lv_pmos ad=0.34p pd=2.68u as=0 ps=0 w=1u l=1u
X129 VSS.t2662 VDD VSS.t2662 VSS.t198 sg13_lv_nmos ad=0.1428p pd=1.52u as=0 ps=0 w=0.42u l=1u
X130 VDD VSS.t227 VDD VDD sg13_lv_pmos ad=0.19p pd=1.38u as=0 ps=0 w=1u l=1u
X131 VSS.t914 VDD VSS.t913 VSS.t912 sg13_lv_nmos ad=0.1428p pd=1.52u as=0 ps=0 w=0.42u l=1u
X132 VSS.t2494 VDD VSS.t2496 VSS.t2495 sg13_lv_nmos ad=79.8f pd=0.8u as=0 ps=0 w=0.42u l=1u
X133 a_27407_13799# a_26565_13701# a_26148_14040# VDD sg13_lv_pmos ad=0.2048p pd=1.63u as=0.34p ps=2.68u w=1u l=0.13u
X134 VDD VSS.t2986 VDD VDD sg13_lv_pmos ad=0.34p pd=2.68u as=0 ps=0 w=1u l=1u
X135 VDD VSS.t1896 VDD VDD sg13_lv_pmos ad=0.34p pd=2.68u as=0 ps=0 w=1u l=1u
X136 VSS.t123 a_22319_14845# a_22986_14484# VSS.t4 sg13_lv_nmos ad=0.1406p pd=1.12u as=0.2516p ps=2.16u w=0.74u l=0.13u
X137 VDD VSS.t1527 VDD VDD sg13_lv_pmos ad=0.19p pd=1.38u as=0 ps=0 w=1u l=1u
X138 VDD VSS.t1704 VDD VDD sg13_lv_pmos ad=0.34p pd=2.68u as=0 ps=0 w=1u l=1u
X139 VSS.t1992 VDD VSS.t1994 VSS.t1993 sg13_lv_nmos ad=79.8f pd=0.8u as=0 ps=0 w=0.42u l=1u
X140 VDD VSS.t269 VDD VDD sg13_lv_pmos ad=0.19p pd=1.38u as=0 ps=0 w=1u l=1u
X141 VDD VSS.t1567 VDD VDD sg13_lv_pmos ad=0.19p pd=1.38u as=0 ps=0 w=1u l=1u
X142 VSS.t2642 VDD VSS.t2642 VSS.t198 sg13_lv_nmos ad=0.1428p pd=1.52u as=0 ps=0 w=0.42u l=1u
X143 VSS.t521 VDD VSS.t520 VSS.t519 sg13_lv_nmos ad=0.1428p pd=1.52u as=0 ps=0 w=0.42u l=1u
X144 VDD VSS.t1213 VDD VDD sg13_lv_pmos ad=0.34p pd=2.68u as=0 ps=0 w=1u l=1u
X145 VDD VSS.t2688 VDD VDD sg13_lv_pmos ad=0.19p pd=1.38u as=0 ps=0 w=1u l=1u
X146 VDD VSS.t918 VDD VDD sg13_lv_pmos ad=0.34p pd=2.68u as=0 ps=0 w=1u l=1u
X147 a_17892_14909# a_17604_14488# a_17830_14909# VSS.t80 sg13_lv_nmos ad=0.1428p pd=1.52u as=37.8f ps=0.6u w=0.42u l=0.13u
X148 VDD VSS.t508 VDD VDD sg13_lv_pmos ad=0.34p pd=2.68u as=0 ps=0 w=1u l=1u
X149 VSS.t1250 VDD VSS.t1251 VSS.t1154 sg13_lv_nmos ad=79.8f pd=0.8u as=0 ps=0 w=0.42u l=1u
X150 VDD VSS.t2228 VDD VDD sg13_lv_pmos ad=0.34p pd=2.68u as=0 ps=0 w=1u l=1u
X151 VSS.t2289 VDD VSS.t2291 VSS.t2290 sg13_lv_nmos ad=79.8f pd=0.8u as=0 ps=0 w=0.42u l=1u
X152 VSS.t1837 VDD VSS.t1836 VSS.t1835 sg13_lv_nmos ad=0.1428p pd=1.52u as=0 ps=0 w=0.42u l=1u
X153 a_16425_14113# a_16068_14040# VDD VDD sg13_lv_pmos ad=63f pd=0.72u as=0.1563p ps=1.22u w=0.42u l=0.13u
X154 VSS.t2641 VDD VSS.t2640 VSS.t198 sg13_lv_nmos ad=0.1428p pd=1.52u as=0 ps=0 w=0.42u l=1u
X155 VSS.t1254 VDD VSS.t1256 VSS.t1154 sg13_lv_nmos ad=79.8f pd=0.8u as=0 ps=0 w=0.42u l=1u
X156 VSS.t2733 VDD VSS.t2734 VSS.t198 sg13_lv_nmos ad=79.8f pd=0.8u as=0 ps=0 w=0.42u l=1u
X157 VDD a_17584_13942# a_17529_14037# VDD sg13_lv_pmos ad=2.42015p pd=15.68u as=93.45f ps=0.865u w=0.42u l=0.13u
X158 VSS.t1580 VDD VSS.t1579 VSS.t1578 sg13_lv_nmos ad=0.1428p pd=1.52u as=0 ps=0 w=0.42u l=1u
X159 VDD VSS.t3054 VDD VDD sg13_lv_pmos ad=0.19p pd=1.38u as=0 ps=0 w=1u l=1u
X160 VSS.t2329 VDD VSS.t2331 VSS.t2330 sg13_lv_nmos ad=79.8f pd=0.8u as=0 ps=0 w=0.42u l=1u
X161 VDD VSS.t2271 VDD VDD sg13_lv_pmos ad=0.19p pd=1.38u as=0 ps=0 w=1u l=1u
X162 VDD VSS.t933 VDD VDD sg13_lv_pmos ad=0.34p pd=2.68u as=0 ps=0 w=1u l=1u
X163 VDD VSS.t1236 VDD VDD sg13_lv_pmos ad=0.34p pd=2.68u as=0 ps=0 w=1u l=1u
X164 VDD VSS.t2734 VDD VDD sg13_lv_pmos ad=0.34p pd=2.68u as=0 ps=0 w=1u l=1u
X165 VSS.t1555 VDD VSS.t1557 VSS.t1556 sg13_lv_nmos ad=79.8f pd=0.8u as=0 ps=0 w=0.42u l=1u
X166 VDD VSS.t1191 VDD VDD sg13_lv_pmos ad=0.19p pd=1.38u as=0 ps=0 w=1u l=1u
X167 a_9252_15234# sg13cmos5l_and2_1_2.X a_9158_15234# VSS.t114 sg13_lv_nmos ad=60.89999f pd=0.71u as=0.1428p ps=1.52u w=0.42u l=0.13u
X168 a_17806_15423# a_17921_15424# VDD VDD sg13_lv_pmos ad=0.34p pd=2.68u as=0.2254p ps=1.53u w=1u l=0.5u
X169 VSS.t1947 VDD VSS.t1946 VSS.t1945 sg13_lv_nmos ad=0.1428p pd=1.52u as=0 ps=0 w=0.42u l=1u
X170 VSS.t444 VDD VSS.t443 VSS.t11 sg13_lv_nmos ad=0.1428p pd=1.52u as=0 ps=0 w=0.42u l=1u
X171 VSS.t576 VDD VSS.t576 VSS.t701 sg13_lv_nmos ad=79.8f pd=0.8u as=0 ps=0 w=0.42u l=1u
X172 VDD VSS.t996 VDD VDD sg13_lv_pmos ad=0.19p pd=1.38u as=0 ps=0 w=1u l=1u
X173 VSS.t1399 VDD VSS.t1265 VSS.t1154 sg13_lv_nmos ad=79.8f pd=0.8u as=0 ps=0 w=0.42u l=1u
X174 VDD VSS.t1574 VDD VDD sg13_lv_pmos ad=0.34p pd=2.68u as=0 ps=0 w=1u l=1u
X175 VDD VSS.t2421 VDD VDD sg13_lv_pmos ad=0.19p pd=1.38u as=0 ps=0 w=1u l=1u
X176 VSS.t2479 VDD VSS.t2481 VSS.t2480 sg13_lv_nmos ad=79.8f pd=0.8u as=0 ps=0 w=0.42u l=1u
X177 VDD VSS.t611 VDD VDD sg13_lv_pmos ad=0.19p pd=1.38u as=0 ps=0 w=1u l=1u
X178 VSS.t1645 VDD VSS.t1647 VSS.t1646 sg13_lv_nmos ad=79.8f pd=0.8u as=0 ps=0 w=0.42u l=1u
X179 VSS.t2027 VDD VSS.t2029 VSS.t2028 sg13_lv_nmos ad=79.8f pd=0.8u as=0 ps=0 w=0.42u l=1u
X180 VSS.t1029 VDD VSS.t1031 VSS.t1030 sg13_lv_nmos ad=79.8f pd=0.8u as=0 ps=0 w=0.42u l=1u
X181 VDD VSS.t291 VDD VDD sg13_lv_pmos ad=0.19p pd=1.38u as=0 ps=0 w=1u l=1u
X182 VSS.t914 VDD VSS.t913 VSS.t912 sg13_lv_nmos ad=0.1428p pd=1.52u as=0 ps=0 w=0.42u l=1u
X183 VDD VSS.t1921 VDD VDD sg13_lv_pmos ad=0.34p pd=2.68u as=0 ps=0 w=1u l=1u
X184 VDD VSS.t896 VDD VDD sg13_lv_pmos ad=0.19p pd=1.38u as=0 ps=0 w=1u l=1u
X185 VDD VSS.t3039 VDD VDD sg13_lv_pmos ad=0.19p pd=1.38u as=0 ps=0 w=1u l=1u
X186 VDD VSS.t2256 VDD VDD sg13_lv_pmos ad=0.19p pd=1.38u as=0 ps=0 w=1u l=1u
X187 VDD VSS.t2094 VDD VDD sg13_lv_pmos ad=0.19p pd=1.38u as=0 ps=0 w=1u l=1u
X188 VSS.t37 a_4078_14751# sg13cmos5l_xor2_1_0.B VSS.t36 sg13_lv_nmos ad=0.1426p pd=1.16u as=0.2516p ps=2.16u w=0.74u l=0.13u
X189 VSS.t2655 VDD VSS.t2654 VSS.t198 sg13_lv_nmos ad=0.1428p pd=1.52u as=0 ps=0 w=0.42u l=1u
X190 a_12010_15202# sg13cmos5l_buf_8_2.A VDD VDD sg13_lv_pmos ad=0.2128p pd=1.5u as=0.2128p ps=1.5u w=1.12u l=0.13u
X191 VDD sg13cmos5l_buf_8_2.A a_19323_13726# VDD sg13_lv_pmos ad=0.2128p pd=1.5u as=0.3808p ps=2.92u w=1.12u l=0.13u
X192 VDD VSS.t2046 VDD VDD sg13_lv_pmos ad=0.34p pd=2.68u as=0 ps=0 w=1u l=1u
X193 VDD VSS.t1173 VDD VDD sg13_lv_pmos ad=0.34p pd=2.68u as=0 ps=0 w=1u l=1u
X194 VDD VSS.t1881 VDD VDD sg13_lv_pmos ad=0.34p pd=2.68u as=0 ps=0 w=1u l=1u
X195 VDD VSS.t407 VDD VDD sg13_lv_pmos ad=0.34p pd=2.68u as=0 ps=0 w=1u l=1u
X196 VDD VSS.t1689 VDD VDD sg13_lv_pmos ad=0.34p pd=2.68u as=0 ps=0 w=1u l=1u
X197 VSS.t2274 VDD VSS.t2276 VSS.t2275 sg13_lv_nmos ad=79.8f pd=0.8u as=0 ps=0 w=0.42u l=1u
X198 VSS.t1977 VDD VSS.t1979 VSS.t1978 sg13_lv_nmos ad=79.8f pd=0.8u as=0 ps=0 w=0.42u l=1u
X199 VSS.t438 VDD VSS.t437 VSS.t11 sg13_lv_nmos ad=0.1428p pd=1.52u as=0 ps=0 w=0.42u l=1u
X200 VDD VSS.t508 VDD VDD sg13_lv_pmos ad=0.19p pd=1.38u as=0 ps=0 w=1u l=1u
X201 VSS.t1540 VDD VSS.t1542 VSS.t1541 sg13_lv_nmos ad=79.8f pd=0.8u as=0 ps=0 w=0.42u l=1u
X202 VSS.t3057 VDD VSS.t3059 VSS.t3058 sg13_lv_nmos ad=79.8f pd=0.8u as=0 ps=0 w=0.42u l=1u
X203 VDD VSS.t1240 VDD VDD sg13_lv_pmos ad=0.34p pd=2.68u as=0 ps=0 w=1u l=1u
X204 VSS.t1232 VDD VSS.t1233 VSS.t1154 sg13_lv_nmos ad=79.8f pd=0.8u as=0 ps=0 w=0.42u l=1u
X205 VDD VSS.t1552 VDD VDD sg13_lv_pmos ad=0.19p pd=1.38u as=0 ps=0 w=1u l=1u
X206 a_10905_15549# a_9963_15356# a_10703_15311# VDD sg13_lv_pmos ad=93.45f pd=0.865u as=0.2048p ps=1.63u w=0.42u l=0.13u
X207 VDD sg13cmos5l_xnor2_1_2.A a_6714_12972# VDD sg13_lv_pmos ad=0.2891p pd=1.695u as=0.1428p ps=1.375u w=1.12u l=0.13u
X208 VDD VSS.t771 VDD VDD sg13_lv_pmos ad=0.19p pd=1.38u as=0 ps=0 w=1u l=1u
X209 VSS.t2349 VDD VSS.t2351 VSS.t2350 sg13_lv_nmos ad=79.8f pd=0.8u as=0 ps=0 w=0.42u l=1u
X210 VDD VSS.t2413 VDD VDD sg13_lv_pmos ad=0.34p pd=2.68u as=0 ps=0 w=1u l=1u
X211 VSS.t30 a_12010_15202# sg13cmos5l_dfrbpq_1_2.CLK VSS.t32 sg13_lv_nmos ad=0.1406p pd=1.12u as=0.1406p ps=1.12u w=0.74u l=0.13u
X212 a_22426_15202# sg13cmos5l_dfrbpq_1_6.Q VSS.t89 VSS.t64 sg13_lv_nmos ad=0.1428p pd=1.52u as=79.8f ps=0.8u w=0.42u l=0.13u
X213 sg13cmos5l_a21oi_1_0.Y sg13cmos5l_a21oi_1_3.B1 VSS.t13 VSS.t17 sg13_lv_nmos ad=0.1406p pd=1.12u as=0.2516p ps=2.16u w=0.74u l=0.13u
X214 VDD VSS.t2622 VDD VDD sg13_lv_pmos ad=0.34p pd=2.68u as=0 ps=0 w=1u l=1u
X215 VDD sg13cmos5l_o21ai_1_2.B1 sg13cmos5l_or3_1_1.C VDD sg13_lv_pmos ad=0.3808p pd=2.92u as=0.2128p ps=1.5u w=1.12u l=0.13u
X216 a_19120_14726# sg13cmos5l_dfrbpq_1_3.RESET_B VDD VDD sg13_lv_pmos ad=79.8f pd=0.8u as=2.42015p ps=15.68u w=0.42u l=0.13u
X217 a_23480_15242# sg13cmos5l_dfrbpq_1_3.Q a_23378_15242# VSS.t64 sg13_lv_nmos ad=0.1406p pd=1.12u as=0.1406p ps=1.12u w=0.74u l=0.13u
X218 VDD VSS.t1181 VDD VDD sg13_lv_pmos ad=0.34p pd=2.68u as=0 ps=0 w=1u l=1u
X219 VSS.t1282 VDD VSS.t1283 VSS.t1154 sg13_lv_nmos ad=79.8f pd=0.8u as=0 ps=0 w=0.42u l=1u
X220 VSS.t2634 VDD VSS.t2633 VSS.t198 sg13_lv_nmos ad=0.1428p pd=1.52u as=0 ps=0 w=0.42u l=1u
X221 VSS.t304 VDD VSS.t303 VSS.t302 sg13_lv_nmos ad=0.1428p pd=1.52u as=0 ps=0 w=0.42u l=1u
X222 VDD a_21562_15960# a_21281_16262# VDD sg13_lv_pmos ad=0.1523p pd=1.38u as=0.34p ps=2.68u w=1u l=0.5u
X223 VDD sg13cmos5l_o21ai_1_2.Y a_24824_15238# VDD sg13_lv_pmos ad=0.1523p pd=1.38u as=0.1428p ps=1.52u w=0.42u l=0.13u
X224 VDD a_18863_14845# a_19530_14484# VDD sg13_lv_pmos ad=0.2128p pd=1.5u as=0.3864p ps=2.93u w=1.12u l=0.13u
X225 VDD VSS.t841 VDD VDD sg13_lv_pmos ad=0.19p pd=1.38u as=0 ps=0 w=1u l=1u
X226 VDD VSS.t1268 VDD VDD sg13_lv_pmos ad=0.19p pd=1.38u as=0 ps=0 w=1u l=1u
X227 VDD VSS.t2764 VDD VDD sg13_lv_pmos ad=0.19p pd=1.38u as=0 ps=0 w=1u l=1u
X228 VDD VSS.t2079 VDD VDD sg13_lv_pmos ad=0.19p pd=1.38u as=0 ps=0 w=1u l=1u
X229 a_20603_15532# sg13cmos5l_a21oi_1_3.B1 sg13cmos5l_a21oi_1_1.Y VDD sg13_lv_pmos ad=0.2128p pd=1.5u as=0.3808p ps=2.92u w=1.12u l=0.13u
X230 VSS.t2665 VDD VSS.t2664 VSS.t198 sg13_lv_nmos ad=0.1428p pd=1.52u as=0 ps=0 w=0.42u l=1u
X231 VSS.t2494 VDD VSS.t2493 VSS.t2492 sg13_lv_nmos ad=0.1428p pd=1.52u as=0 ps=0 w=0.42u l=1u
X232 VSS.t2314 VDD VSS.t2316 VSS.t2315 sg13_lv_nmos ad=79.8f pd=0.8u as=0 ps=0 w=0.42u l=1u
X233 VDD VSS.t2991 VDD VDD sg13_lv_pmos ad=0.34p pd=2.68u as=0 ps=0 w=1u l=1u
X234 VSS.t2736 VDD VSS.t2735 VSS.t198 sg13_lv_nmos ad=0.1428p pd=1.52u as=0 ps=0 w=0.42u l=1u
X235 sg13cmos5l_dfrbpq_1_2.CLK a_12010_15202# VDD VDD sg13_lv_pmos ad=0.2128p pd=1.5u as=0.2128p ps=1.5u w=1.12u l=0.13u
X236 VDD VSS.t1866 VDD VDD sg13_lv_pmos ad=0.34p pd=2.68u as=0 ps=0 w=1u l=1u
X237 VSS.t405 VDD VSS.t404 VSS.t11 sg13_lv_nmos ad=0.1428p pd=1.52u as=0 ps=0 w=0.42u l=1u
X238 VDD VSS.t926 VDD VDD sg13_lv_pmos ad=0.19p pd=1.38u as=0 ps=0 w=1u l=1u
X239 VSS.t1720 VDD VSS.t1719 VSS.t1718 sg13_lv_nmos ad=0.1428p pd=1.52u as=0 ps=0 w=0.42u l=1u
X240 VDD VSS.t1572 VDD VDD sg13_lv_pmos ad=0.19p pd=1.38u as=0 ps=0 w=1u l=1u
X241 VDD VSS.t2446 VDD VDD sg13_lv_pmos ad=0.19p pd=1.38u as=0 ps=0 w=1u l=1u
X242 VSS.t3012 VDD VSS.t3011 VSS.t3010 sg13_lv_nmos ad=0.1428p pd=1.52u as=0 ps=0 w=0.42u l=1u
X243 VDD a_15579_14854# sg13cmos5l_buf_8_2.A VDD sg13_lv_pmos ad=0.3864p pd=2.93u as=0.2128p ps=1.5u w=1.12u l=0.13u
X244 VDD VSS.t286 VDD VDD sg13_lv_pmos ad=0.34p pd=2.68u as=0 ps=0 w=1u l=1u
X245 VSS.t101 a_22508_15960# counter_value_o[4] VSS.t157 sg13_lv_nmos ad=0.14875p pd=1.16u as=0.2886p ps=2.26u w=0.74u l=0.13u
X246 VSS.t27 a_12010_15202# sg13cmos5l_dfrbpq_1_2.CLK VSS.t26 sg13_lv_nmos ad=0.1406p pd=1.12u as=0.1406p ps=1.12u w=0.74u l=0.13u
X247 VDD VSS.t415 VDD VDD sg13_lv_pmos ad=0.19p pd=1.38u as=0 ps=0 w=1u l=1u
X248 VDD VSS.t2727 VDD VDD sg13_lv_pmos ad=0.19p pd=1.38u as=0 ps=0 w=1u l=1u
X249 VSS.t2464 VDD VSS.t2466 VSS.t2465 sg13_lv_nmos ad=79.8f pd=0.8u as=0 ps=0 w=0.42u l=1u
X250 VSS.t1029 VDD VSS.t1031 VSS.t1030 sg13_lv_nmos ad=79.8f pd=0.8u as=0 ps=0 w=0.42u l=1u
X251 VDD VSS.t1273 VDD VDD sg13_lv_pmos ad=0.34p pd=2.68u as=0 ps=0 w=1u l=1u
X252 VDD VSS.t138 VDD VDD sg13_lv_pmos ad=0.19p pd=1.38u as=0 ps=0 w=1u l=1u
X253 VSS.t2626 VDD VSS.t2624 VSS.t198 sg13_lv_nmos ad=0.1428p pd=1.52u as=0 ps=0 w=0.42u l=1u
X254 VSS.t1223 VDD VSS.t1222 VSS.t1154 sg13_lv_nmos ad=0.1428p pd=1.52u as=0 ps=0 w=0.42u l=1u
X255 VDD VSS.t2501 VDD VDD sg13_lv_pmos ad=0.19p pd=1.38u as=0 ps=0 w=1u l=1u
X256 VDD VSS.t1906 VDD VDD sg13_lv_pmos ad=0.34p pd=2.68u as=0 ps=0 w=1u l=1u
X257 VSS.t531 VDD VSS.t533 VSS.t532 sg13_lv_nmos ad=79.8f pd=0.8u as=0 ps=0 w=0.42u l=1u
X258 VSS.t889 VDD VSS.t888 VSS.t887 sg13_lv_nmos ad=0.1428p pd=1.52u as=0 ps=0 w=0.42u l=1u
X259 VSS.t2334 VDD VSS.t2336 VSS.t2335 sg13_lv_nmos ad=79.8f pd=0.8u as=0 ps=0 w=0.42u l=1u
X260 VDD VSS.t2241 VDD VDD sg13_lv_pmos ad=0.19p pd=1.38u as=0 ps=0 w=1u l=1u
X261 VDD sg13cmos5l_dlygate4sd3_1_17.A a_24824_14525# VDD sg13_lv_pmos ad=0.1523p pd=1.38u as=0.1428p ps=1.52u w=0.42u l=0.13u
X262 VSS.t1216 VDD VSS.t1217 VSS.t1154 sg13_lv_nmos ad=79.8f pd=0.8u as=0 ps=0 w=0.42u l=1u
X263 VSS.t2107 VDD VSS.t2109 VSS.t2108 sg13_lv_nmos ad=79.8f pd=0.8u as=0 ps=0 w=0.42u l=1u
X264 VDD VSS.t2031 VDD VDD sg13_lv_pmos ad=0.34p pd=2.68u as=0 ps=0 w=1u l=1u
X265 VDD VSS.t508 VDD VDD sg13_lv_pmos ad=0.19p pd=1.38u as=0 ps=0 w=1u l=1u
X266 VDD VSS.t1311 VDD VDD sg13_lv_pmos ad=0.19p pd=1.38u as=0 ps=0 w=1u l=1u
X267 VDD a_19450_15202# a_19169_15424# VDD sg13_lv_pmos ad=0.1523p pd=1.38u as=0.34p ps=2.68u w=1u l=0.5u
X268 a_26373_14495# sg13cmos5l_buf_8_2.X VSS.t11 VSS.t78 sg13_lv_nmos ad=0.2516p pd=2.16u as=3.8707p ps=25.555u w=0.74u l=0.13u
X269 VSS.t1705 VDD VSS.t1704 VSS.t1703 sg13_lv_nmos ad=0.1428p pd=1.52u as=0 ps=0 w=0.42u l=1u
X270 a_26170_15202# sg13cmos5l_a21oi_1_3.Y VSS.t42 VSS.t3274 sg13_lv_nmos ad=0.1428p pd=1.52u as=79.8f ps=0.8u w=0.42u l=0.13u
X271 VDD VSS.t1714 VDD VDD sg13_lv_pmos ad=0.34p pd=2.68u as=0 ps=0 w=1u l=1u
X272 VDD VSS.t279 VDD VDD sg13_lv_pmos ad=0.34p pd=2.68u as=0 ps=0 w=1u l=1u
X273 VSS.t764 VDD VSS.t763 VSS.t762 sg13_lv_nmos ad=0.1428p pd=1.52u as=0 ps=0 w=0.42u l=1u
X274 VSS.t949 VDD VSS.t951 VSS.t950 sg13_lv_nmos ad=79.8f pd=0.8u as=0 ps=0 w=0.42u l=1u
X275 VSS.t65 sg13cmos5l_or3_1_2.B a_24310_15230# VSS.t64 sg13_lv_nmos ad=0.1406p pd=1.12u as=0.2516p ps=2.16u w=0.74u l=0.15u
X276 VDD VSS.t2398 VDD VDD sg13_lv_pmos ad=0.34p pd=2.68u as=0 ps=0 w=1u l=1u
X277 a_16042_13945# a_16485_13701# a_15782_13722# VSS.t3195 sg13_lv_nmos ad=79.8f pd=0.8u as=0.1296p ps=1.52u w=0.42u l=0.13u
X278 VDD VSS.t1544 VDD VDD sg13_lv_pmos ad=0.34p pd=2.68u as=0 ps=0 w=1u l=1u
X279 VSS.t2449 VDD VSS.t2451 VSS.t2450 sg13_lv_nmos ad=79.8f pd=0.8u as=0 ps=0 w=0.42u l=1u
X280 VSS.t423 VDD VSS.t422 VSS.t11 sg13_lv_nmos ad=0.1428p pd=1.52u as=0 ps=0 w=0.42u l=1u
X281 VDD VSS.t571 VDD VDD sg13_lv_pmos ad=0.34p pd=2.68u as=0 ps=0 w=1u l=1u
X282 VSS.t1615 VDD VSS.t1617 VSS.t1616 sg13_lv_nmos ad=79.8f pd=0.8u as=0 ps=0 w=0.42u l=1u
X283 VSS.t328 VDD VSS.t330 VSS.t329 sg13_lv_nmos ad=79.8f pd=0.8u as=0 ps=0 w=0.42u l=1u
X284 VDD VSS.t373 VDD VDD sg13_lv_pmos ad=0.19p pd=1.38u as=0 ps=0 w=1u l=1u
X285 VDD VSS.t1157 VDD VDD sg13_lv_pmos ad=0.34p pd=2.68u as=0 ps=0 w=1u l=1u
X286 VDD VSS.t1926 VDD VDD sg13_lv_pmos ad=0.34p pd=2.68u as=0 ps=0 w=1u l=1u
X287 a_17710_16263# a_17825_16262# VDD VDD sg13_lv_pmos ad=0.34p pd=2.68u as=0.2254p ps=1.53u w=1u l=0.5u
X288 a_19120_14726# a_18863_14845# a_19282_14922# VSS.t9 sg13_lv_nmos ad=0.1428p pd=1.52u as=37.8f ps=0.6u w=0.42u l=0.13u
X289 VSS.t1353 VDD VSS.t1197 VSS.t1154 sg13_lv_nmos ad=0.1428p pd=1.52u as=0 ps=0 w=0.42u l=1u
X290 VDD VSS.t1259 VDD VDD sg13_lv_pmos ad=0.19p pd=1.38u as=0 ps=0 w=1u l=1u
X291 VDD VSS.t2755 VDD VDD sg13_lv_pmos ad=0.19p pd=1.38u as=0 ps=0 w=1u l=1u
X292 VSS.t52 a_18863_14845# a_19530_14484# VSS.t9 sg13_lv_nmos ad=0.1406p pd=1.12u as=0.2516p ps=2.16u w=0.74u l=0.13u
X293 VDD VSS.t1291 VDD VDD sg13_lv_pmos ad=0.34p pd=2.68u as=0 ps=0 w=1u l=1u
X294 VSS.t2657 VDD VSS.t2657 VSS.t198 sg13_lv_nmos ad=0.1428p pd=1.52u as=0 ps=0 w=0.42u l=1u
X295 VSS.t2479 VDD VSS.t2478 VSS.t2477 sg13_lv_nmos ad=0.1428p pd=1.52u as=0 ps=0 w=0.42u l=1u
X296 VSS.t2092 VDD VSS.t2094 VSS.t2093 sg13_lv_nmos ad=79.8f pd=0.8u as=0 ps=0 w=0.42u l=1u
X297 VDD VSS.t11 VDD VDD sg13_lv_pmos ad=0.34p pd=2.68u as=0 ps=0 w=1u l=1u
X298 VSS.t620 VDD VSS.t617 VSS.t619 sg13_lv_nmos ad=0.1428p pd=1.52u as=0 ps=0 w=0.42u l=1u
X299 VDD VSS.t1033 VDD VDD sg13_lv_pmos ad=0.34p pd=2.68u as=0 ps=0 w=1u l=1u
X300 VSS.t1241 VDD VSS.t1240 VSS.t1154 sg13_lv_nmos ad=0.1428p pd=1.52u as=0 ps=0 w=0.42u l=1u
X301 VSS.t2279 VDD VSS.t2281 VSS.t2280 sg13_lv_nmos ad=79.8f pd=0.8u as=0 ps=0 w=0.42u l=1u
X302 VSS.t1982 VDD VSS.t1984 VSS.t1983 sg13_lv_nmos ad=79.8f pd=0.8u as=0 ps=0 w=0.42u l=1u
X303 VSS.t373 VDD VSS.t370 VSS.t372 sg13_lv_nmos ad=0.1428p pd=1.52u as=0 ps=0 w=0.42u l=1u
X304 VSS.t432 VDD VSS.t431 VSS.t11 sg13_lv_nmos ad=0.1428p pd=1.52u as=0 ps=0 w=0.42u l=1u
X305 VSS.t3062 VDD VSS.t3064 VSS.t3063 sg13_lv_nmos ad=79.8f pd=0.8u as=0 ps=0 w=0.42u l=1u
X306 VSS.t919 VDD VSS.t918 VSS.t917 sg13_lv_nmos ad=0.1428p pd=1.52u as=0 ps=0 w=0.42u l=1u
X307 VDD VSS.t1557 VDD VDD sg13_lv_pmos ad=0.19p pd=1.38u as=0 ps=0 w=1u l=1u
X308 VDD VSS.t971 VDD VDD sg13_lv_pmos ad=0.19p pd=1.38u as=0 ps=0 w=1u l=1u
X309 VDD VSS.t1612 VDD VDD sg13_lv_pmos ad=0.19p pd=1.38u as=0 ps=0 w=1u l=1u
X310 VSS.t399 VDD VSS.t241 VSS.t11 sg13_lv_nmos ad=0.1428p pd=1.52u as=0 ps=0 w=0.42u l=1u
X311 VSS.t2354 VDD VSS.t2356 VSS.t2355 sg13_lv_nmos ad=79.8f pd=0.8u as=0 ps=0 w=0.42u l=1u
X312 VDD VSS.t274 VDD VDD sg13_lv_pmos ad=0.19p pd=1.38u as=0 ps=0 w=1u l=1u
X313 a_27034_15202# sg13cmos5l_dfrbpq_1_7.Q VDD VDD sg13_lv_pmos ad=0.1428p pd=1.52u as=0.1523p ps=1.38u w=0.42u l=0.13u
X314 VSS.t2656 VDD VSS.t2655 VSS.t198 sg13_lv_nmos ad=0.1428p pd=1.52u as=0 ps=0 w=0.42u l=1u
X315 VDD VSS.t2383 VDD VDD sg13_lv_pmos ad=0.34p pd=2.68u as=0 ps=0 w=1u l=1u
X316 VDD VSS.t596 VDD VDD sg13_lv_pmos ad=0.19p pd=1.38u as=0 ps=0 w=1u l=1u
X317 VDD VSS.t236 VDD VDD sg13_lv_pmos ad=0.19p pd=1.38u as=0 ps=0 w=1u l=1u
X318 VDD VSS.t1894 VDD VDD sg13_lv_pmos ad=0.19p pd=1.38u as=0 ps=0 w=1u l=1u
X319 VDD VSS.t2718 VDD VDD sg13_lv_pmos ad=0.19p pd=1.38u as=0 ps=0 w=1u l=1u
X320 VSS.t1575 VDD VSS.t1574 VSS.t1573 sg13_lv_nmos ad=0.1428p pd=1.52u as=0 ps=0 w=0.42u l=1u
X321 VSS.t3092 VDD VSS.t3091 VSS.t3090 sg13_lv_nmos ad=0.1428p pd=1.52u as=0 ps=0 w=0.42u l=1u
X322 VDD VSS.t2301 VDD VDD sg13_lv_pmos ad=0.19p pd=1.38u as=0 ps=0 w=1u l=1u
X323 VSS.t13 a_18202_15202# a_17921_15424# VSS.t117 sg13_lv_nmos ad=79.8f pd=0.8u as=0.1428p ps=1.52u w=0.42u l=0.5u
X324 VDD VSS.t2689 VDD VDD sg13_lv_pmos ad=0.34p pd=2.68u as=0 ps=0 w=1u l=1u
X325 a_25390_16263# a_25505_16262# VDD VDD sg13_lv_pmos ad=0.34p pd=2.68u as=0.2254p ps=1.53u w=1u l=0.5u
X326 VSS.t435 VDD VSS.t436 VSS.t11 sg13_lv_nmos ad=79.8f pd=0.8u as=0 ps=0 w=0.42u l=1u
X327 VDD VSS.t428 VDD VDD sg13_lv_pmos ad=0.34p pd=2.68u as=0 ps=0 w=1u l=1u
X328 VDD VSS.t846 VDD VDD sg13_lv_pmos ad=0.19p pd=1.38u as=0 ps=0 w=1u l=1u
X329 VSS.t889 VDD VSS.t888 VSS.t887 sg13_lv_nmos ad=0.1428p pd=1.52u as=0 ps=0 w=0.42u l=1u
X330 VDD VSS.t2486 VDD VDD sg13_lv_pmos ad=0.19p pd=1.38u as=0 ps=0 w=1u l=1u
X331 VDD VSS.t1271 VDD VDD sg13_lv_pmos ad=0.19p pd=1.38u as=0 ps=0 w=1u l=1u
X332 VSS.t1570 VDD VSS.t1569 VSS.t1568 sg13_lv_nmos ad=0.1428p pd=1.52u as=0 ps=0 w=0.42u l=1u
X333 VDD VSS.t2767 VDD VDD sg13_lv_pmos ad=0.19p pd=1.38u as=0 ps=0 w=1u l=1u
X334 VDD VSS.t2084 VDD VDD sg13_lv_pmos ad=0.19p pd=1.38u as=0 ps=0 w=1u l=1u
X335 VDD VSS.t2438 VDD VDD sg13_lv_pmos ad=0.34p pd=2.68u as=0 ps=0 w=1u l=1u
X336 VSS.t2499 VDD VSS.t2498 VSS.t2497 sg13_lv_nmos ad=0.1428p pd=1.52u as=0 ps=0 w=0.42u l=1u
X337 VSS.t2319 VDD VSS.t2321 VSS.t2320 sg13_lv_nmos ad=79.8f pd=0.8u as=0 ps=0 w=0.42u l=1u
X338 VDD VSS.t2996 VDD VDD sg13_lv_pmos ad=0.34p pd=2.68u as=0 ps=0 w=1u l=1u
X339 VSS.t578 VDD VSS.t580 VSS.t579 sg13_lv_nmos ad=79.8f pd=0.8u as=0 ps=0 w=0.42u l=1u
X340 VSS.t2047 VDD VSS.t2046 VSS.t2045 sg13_lv_nmos ad=0.1428p pd=1.52u as=0 ps=0 w=0.42u l=1u
X341 VDD VSS.t1225 VDD VDD sg13_lv_pmos ad=0.34p pd=2.68u as=0 ps=0 w=1u l=1u
X342 VDD VSS.t2044 VDD VDD sg13_lv_pmos ad=0.19p pd=1.38u as=0 ps=0 w=1u l=1u
X343 VSS.t764 VDD VSS.t763 VSS.t762 sg13_lv_nmos ad=0.1428p pd=1.52u as=0 ps=0 w=0.42u l=1u
X344 VSS.t949 VDD VSS.t951 VSS.t950 sg13_lv_nmos ad=79.8f pd=0.8u as=0 ps=0 w=0.42u l=1u
X345 VDD VSS.t1542 VDD VDD sg13_lv_pmos ad=0.19p pd=1.38u as=0 ps=0 w=1u l=1u
X346 VDD VSS.t1597 VDD VDD sg13_lv_pmos ad=0.19p pd=1.38u as=0 ps=0 w=1u l=1u
X347 VDD a_8218_13690# a_7937_13912# VDD sg13_lv_pmos ad=0.1523p pd=1.38u as=0.34p ps=2.68u w=1u l=0.5u
X348 sg13cmos5l_dfrbpq_1_2.Q a_17994_14020# VDD VDD sg13_lv_pmos ad=0.3808p pd=2.92u as=0.2128p ps=1.5u w=1.12u l=0.13u
X349 VDD VSS.t703 VDD VDD sg13_lv_pmos ad=0.34p pd=2.68u as=0 ps=0 w=1u l=1u
X350 VDD VSS.t878 VDD VDD sg13_lv_pmos ad=0.34p pd=2.68u as=0 ps=0 w=1u l=1u
X351 VDD VSS.t2653 VDD VDD sg13_lv_pmos ad=0.19p pd=1.38u as=0 ps=0 w=1u l=1u
X352 VDD VSS.t2729 VDD VDD sg13_lv_pmos ad=0.19p pd=1.38u as=0 ps=0 w=1u l=1u
X353 VSS.t1997 VDD VSS.t1996 VSS.t1995 sg13_lv_nmos ad=0.1428p pd=1.52u as=0 ps=0 w=0.42u l=1u
X354 VDD VSS.t11 VDD VDD sg13_lv_pmos ad=0.34p pd=2.68u as=0 ps=0 w=1u l=1u
X355 a_23960_15242# sg13cmos5l_dfrbpq_1_3.Q a_23858_15242# VSS.t64 sg13_lv_nmos ad=0.1406p pd=1.12u as=0.1406p ps=1.12u w=0.74u l=0.13u
X356 VSS.t3077 VDD VSS.t3076 VSS.t3075 sg13_lv_nmos ad=0.1428p pd=1.52u as=0 ps=0 w=0.42u l=1u
X357 VSS.t2294 VDD VSS.t2293 VSS.t2292 sg13_lv_nmos ad=0.1428p pd=1.52u as=0 ps=0 w=0.42u l=1u
X358 VDD VSS.t316 VDD VDD sg13_lv_pmos ad=0.19p pd=1.38u as=0 ps=0 w=1u l=1u
X359 a_7680_15549# sg13cmos5l_dlygate4sd3_1_8.X VDD VDD sg13_lv_pmos ad=0.1596p pd=1.22u as=0.4536p ps=2.76u w=0.84u l=0.13u
X360 VSS.t417 VDD VSS.t416 VSS.t11 sg13_lv_nmos ad=0.1428p pd=1.52u as=0 ps=0 w=0.42u l=1u
X361 VSS.t2629 VDD VSS.t2628 VSS.t198 sg13_lv_nmos ad=0.1428p pd=1.52u as=0 ps=0 w=0.42u l=1u
X362 a_24923_15996# sg13cmos5l_or3_1_1.X VDD VDD sg13_lv_pmos ad=0.3808p pd=2.92u as=0.2128p ps=1.5u w=1.12u l=0.13u
X363 VDD sg13cmos5l_xnor2_1_0.Y a_8312_15238# VDD sg13_lv_pmos ad=0.1523p pd=1.38u as=0.1428p ps=1.52u w=0.42u l=0.13u
X364 VSS.t2720 VDD VSS.t2721 VSS.t198 sg13_lv_nmos ad=79.8f pd=0.8u as=0 ps=0 w=0.42u l=1u
X365 VDD VSS.t2471 VDD VDD sg13_lv_pmos ad=0.19p pd=1.38u as=0 ps=0 w=1u l=1u
X366 VDD VSS.t614 VDD VDD sg13_lv_pmos ad=0.19p pd=1.38u as=0 ps=0 w=1u l=1u
X367 VDD VSS.t1911 VDD VDD sg13_lv_pmos ad=0.34p pd=2.68u as=0 ps=0 w=1u l=1u
X368 VDD VSS.t2246 VDD VDD sg13_lv_pmos ad=0.19p pd=1.38u as=0 ps=0 w=1u l=1u
X369 VDD VSS.t3029 VDD VDD sg13_lv_pmos ad=0.19p pd=1.38u as=0 ps=0 w=1u l=1u
X370 VSS.t2077 VDD VSS.t2079 VSS.t2078 sg13_lv_nmos ad=79.8f pd=0.8u as=0 ps=0 w=0.42u l=1u
X371 VDD VSS.t132 VDD VDD sg13_lv_pmos ad=0.19p pd=1.38u as=0 ps=0 w=1u l=1u
X372 a_20868_14922# sg13cmos5l_dfrbpq_1_6.D a_20774_14922# VSS.t9 sg13_lv_nmos ad=60.89999f pd=0.71u as=0.1428p ps=1.52u w=0.42u l=0.13u
X373 VDD VSS.t2036 VDD VDD sg13_lv_pmos ad=0.34p pd=2.68u as=0 ps=0 w=1u l=1u
X374 VSS.t1299 VDD VSS.t1428 VSS.t1154 sg13_lv_nmos ad=0.1428p pd=1.52u as=0 ps=0 w=0.42u l=1u
X375 VSS.t355 VDD VSS.t355 VSS.t358 sg13_lv_nmos ad=79.8f pd=0.8u as=0 ps=0 w=0.42u l=1u
X376 VDD VSS.t535 VDD VDD sg13_lv_pmos ad=0.34p pd=2.68u as=0 ps=0 w=1u l=1u
X377 VSS.t919 VDD VSS.t918 VSS.t917 sg13_lv_nmos ad=0.1428p pd=1.52u as=0 ps=0 w=0.42u l=1u
X378 VDD sg13cmos5l_dlygate4sd3_1_1.A sg13cmos5l_nand3_1_0.Y VDD sg13_lv_pmos ad=0.2128p pd=1.5u as=0.2128p ps=1.5u w=1.12u l=0.13u
X379 VSS.t3047 VDD VSS.t3049 VSS.t3048 sg13_lv_nmos ad=79.8f pd=0.8u as=0 ps=0 w=0.42u l=1u
X380 VSS.t2264 VDD VSS.t2266 VSS.t2265 sg13_lv_nmos ad=79.8f pd=0.8u as=0 ps=0 w=0.42u l=1u
X381 a_21562_15960# sg13cmos5l_a21oi_1_1.Y VSS.t236 VSS.t3260 sg13_lv_nmos ad=0.1428p pd=1.52u as=79.8f ps=0.8u w=0.42u l=0.13u
X382 VDD VSS.t1719 VDD VDD sg13_lv_pmos ad=0.34p pd=2.68u as=0 ps=0 w=1u l=1u
X383 VDD a_21477_14495# a_21579_14495# VDD sg13_lv_pmos ad=2.42015p pd=15.68u as=0.3864p ps=2.93u w=1.12u l=0.13u
X384 VSS.t1625 VDD VSS.t1627 VSS.t1626 sg13_lv_nmos ad=79.8f pd=0.8u as=0 ps=0 w=0.42u l=1u
X385 VSS.t2339 VDD VSS.t2341 VSS.t2340 sg13_lv_nmos ad=79.8f pd=0.8u as=0 ps=0 w=0.42u l=1u
X386 a_17830_14909# sg13cmos5l_dfrbpq_1_3.RESET_B VSS.t13 VSS.t3212 sg13_lv_nmos ad=37.8f pd=0.6u as=0.1701p ps=1.65u w=0.42u l=0.13u
X387 VDD VSS.t623 VDD VDD sg13_lv_pmos ad=0.19p pd=1.38u as=0 ps=0 w=1u l=1u
X388 VDD VSS.t1549 VDD VDD sg13_lv_pmos ad=0.34p pd=2.68u as=0 ps=0 w=1u l=1u
X389 VSS.t1620 VDD VSS.t1622 VSS.t1621 sg13_lv_nmos ad=79.8f pd=0.8u as=0 ps=0 w=0.42u l=1u
X390 VDD VSS.t2680 VDD VDD sg13_lv_pmos ad=0.34p pd=2.68u as=0 ps=0 w=1u l=1u
X391 VDD VSS.t2463 VDD VDD sg13_lv_pmos ad=0.34p pd=2.68u as=0 ps=0 w=1u l=1u
X392 VSS.t839 VDD VSS.t841 VSS.t840 sg13_lv_nmos ad=79.8f pd=0.8u as=0 ps=0 w=0.42u l=1u
X393 VSS.t2731 VDD VSS.t2732 VSS.t198 sg13_lv_nmos ad=79.8f pd=0.8u as=0 ps=0 w=0.42u l=1u
X394 VDD VSS.t1160 VDD VDD sg13_lv_pmos ad=0.34p pd=2.68u as=0 ps=0 w=1u l=1u
X395 a_26565_13701# sg13cmos5l_buf_8_2.X VSS.t72 VSS.t77 sg13_lv_nmos ad=0.2516p pd=2.16u as=15.38618p ps=0.10091m w=0.74u l=0.13u
X396 VDD VSS.t1262 VDD VDD sg13_lv_pmos ad=0.19p pd=1.38u as=0 ps=0 w=1u l=1u
X397 VDD VSS.t2758 VDD VDD sg13_lv_pmos ad=0.19p pd=1.38u as=0 ps=0 w=1u l=1u
X398 VDD VSS.t2069 VDD VDD sg13_lv_pmos ad=0.19p pd=1.38u as=0 ps=0 w=1u l=1u
X399 VDD VSS.t2423 VDD VDD sg13_lv_pmos ad=0.34p pd=2.68u as=0 ps=0 w=1u l=1u
X400 VSS.t2484 VDD VSS.t2483 VSS.t2482 sg13_lv_nmos ad=0.1428p pd=1.52u as=0 ps=0 w=0.42u l=1u
X401 VDD VSS.t2732 VDD VDD sg13_lv_pmos ad=0.34p pd=2.68u as=0 ps=0 w=1u l=1u
X402 VSS.t21 a_15579_14854# sg13cmos5l_buf_8_2.A VSS.t3248 sg13_lv_nmos ad=0.1406p pd=1.12u as=0.1406p ps=1.12u w=0.74u l=0.13u
X403 VDD VSS.t44 VDD VDD sg13_lv_pmos ad=0.19p pd=1.38u as=0 ps=0 w=1u l=1u
X404 VSS.t1650 VDD VSS.t1649 VSS.t1648 sg13_lv_nmos ad=0.1428p pd=1.52u as=0 ps=0 w=0.42u l=1u
X405 VDD VSS.t2981 VDD VDD sg13_lv_pmos ad=0.34p pd=2.68u as=0 ps=0 w=1u l=1u
X406 sg13cmos5l_o21ai_1_3.Y sg13cmos5l_or3_1_1.C a_24408_15552# VDD sg13_lv_pmos ad=0.2128p pd=1.5u as=0.2128p ps=1.5u w=1.12u l=0.15u
X407 VDD sg13cmos5l_inv_1_0.Y a_16140_15424# VDD sg13_lv_pmos ad=0.4536p pd=2.76u as=0.1596p ps=1.22u w=0.84u l=0.13u
X408 a_27664_13942# a_27407_13799# a_27826_13722# VSS.t194 sg13_lv_nmos ad=0.1428p pd=1.52u as=37.8f ps=0.6u w=0.42u l=0.13u
X409 VDD VSS.t1939 VDD VDD sg13_lv_pmos ad=0.19p pd=1.38u as=0 ps=0 w=1u l=1u
X410 a_17584_13942# sg13cmos5l_dfrbpq_1_2.RESET_B VDD VDD sg13_lv_pmos ad=79.8f pd=0.8u as=2.42015p ps=15.68u w=0.42u l=0.13u
X411 VDD VSS.t1527 VDD VDD sg13_lv_pmos ad=0.19p pd=1.38u as=0 ps=0 w=1u l=1u
X412 VDD VSS.t1704 VDD VDD sg13_lv_pmos ad=0.34p pd=2.68u as=0 ps=0 w=1u l=1u
X413 VDD VSS.t602 VDD VDD sg13_lv_pmos ad=0.34p pd=2.68u as=0 ps=0 w=1u l=1u
X414 VSS.t2324 VDD VSS.t2326 VSS.t2325 sg13_lv_nmos ad=79.8f pd=0.8u as=0 ps=0 w=0.42u l=1u
X415 VDD a_25786_15960# a_25505_16262# VDD sg13_lv_pmos ad=0.1523p pd=1.38u as=0.34p ps=2.68u w=1u l=0.5u
X416 VSS.t1171 VDD VSS.t1172 VSS.t1154 sg13_lv_nmos ad=79.8f pd=0.8u as=0 ps=0 w=0.42u l=1u
X417 VDD VSS.t2646 VDD VDD sg13_lv_pmos ad=0.19p pd=1.38u as=0 ps=0 w=1u l=1u
X418 VSS.t1545 VDD VSS.t1544 VSS.t1543 sg13_lv_nmos ad=0.1428p pd=1.52u as=0 ps=0 w=0.42u l=1u
X419 VSS.t3062 VDD VSS.t3061 VSS.t3060 sg13_lv_nmos ad=0.1428p pd=1.52u as=0 ps=0 w=0.42u l=1u
X420 VSS.t2279 VDD VSS.t2278 VSS.t2277 sg13_lv_nmos ad=0.1428p pd=1.52u as=0 ps=0 w=0.42u l=1u
X421 VDD VSS.t2306 VDD VDD sg13_lv_pmos ad=0.19p pd=1.38u as=0 ps=0 w=1u l=1u
X422 VSS.t2620 VDD VSS.t199 VSS.t198 sg13_lv_nmos ad=0.1428p pd=1.52u as=0 ps=0 w=0.42u l=1u
X423 a_21466_15202# sg13cmos5l_o21ai_1_1.Y VSS.t172 VSS.t3265 sg13_lv_nmos ad=0.1428p pd=1.52u as=79.8f ps=0.8u w=0.42u l=0.13u
X424 VDD VSS.t2749 VDD VDD sg13_lv_pmos ad=0.19p pd=1.38u as=0 ps=0 w=1u l=1u
X425 VDD VSS.t2089 VDD VDD sg13_lv_pmos ad=0.19p pd=1.38u as=0 ps=0 w=1u l=1u
X426 a_3209_16334# a_3333_16033# VDD VDD sg13_lv_pmos ad=0.2442p pd=2.06u as=2.8961p ps=18.25u w=0.66u l=0.13u
X427 VDD VSS.t501 VDD VDD sg13_lv_pmos ad=0.34p pd=2.68u as=0 ps=0 w=1u l=1u
X428 VDD VSS.t798 VDD VDD sg13_lv_pmos ad=0.34p pd=2.68u as=0 ps=0 w=1u l=1u
X429 VSS.t1226 VDD VSS.t1225 VSS.t1154 sg13_lv_nmos ad=0.1428p pd=1.52u as=0 ps=0 w=0.42u l=1u
X430 VSS.t21 a_15579_14854# sg13cmos5l_buf_8_2.A VSS.t3244 sg13_lv_nmos ad=0.1406p pd=1.12u as=0.1406p ps=1.12u w=0.74u l=0.13u
X431 VSS.t566 VDD VSS.t568 VSS.t567 sg13_lv_nmos ad=79.8f pd=0.8u as=0 ps=0 w=0.42u l=1u
X432 VDD VSS.t535 VDD VDD sg13_lv_pmos ad=0.34p pd=2.68u as=0 ps=0 w=1u l=1u
X433 VSS.t1635 VDD VSS.t1634 VSS.t1633 sg13_lv_nmos ad=0.1428p pd=1.52u as=0 ps=0 w=0.42u l=1u
X434 VSS.t1179 VDD VSS.t1180 VSS.t1154 sg13_lv_nmos ad=79.8f pd=0.8u as=0 ps=0 w=0.42u l=1u
X435 VSS.t21 VDD VSS.t21 VSS.t395 sg13_lv_nmos ad=0.1428p pd=1.52u as=0 ps=0 w=0.42u l=1u
X436 VSS.t11 a_15671_15315# a_15671_15315# VSS.t63 sg13_lv_nmos ad=4.11262p pd=27.15u as=0.111p ps=1.34u w=0.3u l=0.13u
X437 VDD a_25094_14484# a_25206_14508# VDD sg13_lv_pmos ad=0.2254p pd=1.53u as=0.34p ps=2.68u w=1u l=0.5u
X438 VSS.t2504 VDD VSS.t2503 VSS.t2502 sg13_lv_nmos ad=0.1428p pd=1.52u as=0 ps=0 w=0.42u l=1u
X439 VSS.t1342 VDD VSS.t1184 VSS.t1154 sg13_lv_nmos ad=79.8f pd=0.8u as=0 ps=0 w=0.42u l=1u
X440 VSS.t1610 VDD VSS.t1612 VSS.t1611 sg13_lv_nmos ad=79.8f pd=0.8u as=0 ps=0 w=0.42u l=1u
X441 VDD VSS.t2286 VDD VDD sg13_lv_pmos ad=0.19p pd=1.38u as=0 ps=0 w=1u l=1u
X442 a_19054_15423# a_19169_15424# VDD VDD sg13_lv_pmos ad=0.34p pd=2.68u as=0.2254p ps=1.53u w=1u l=0.5u
X443 VDD VSS.t1884 VDD VDD sg13_lv_pmos ad=0.19p pd=1.38u as=0 ps=0 w=1u l=1u
X444 VDD VSS.t2712 VDD VDD sg13_lv_pmos ad=0.19p pd=1.38u as=0 ps=0 w=1u l=1u
X445 VSS.t2002 VDD VSS.t2001 VSS.t2000 sg13_lv_nmos ad=0.1428p pd=1.52u as=0 ps=0 w=0.42u l=1u
X446 VDD VSS.t397 VDD VDD sg13_lv_pmos ad=0.34p pd=2.68u as=0 ps=0 w=1u l=1u
X447 VSS.t1565 VDD VSS.t1564 VSS.t1563 sg13_lv_nmos ad=0.1428p pd=1.52u as=0 ps=0 w=0.42u l=1u
X448 VSS.t3082 VDD VSS.t3081 VSS.t3080 sg13_lv_nmos ad=0.1428p pd=1.52u as=0 ps=0 w=0.42u l=1u
X449 VSS.t839 VDD VSS.t841 VSS.t840 sg13_lv_nmos ad=79.8f pd=0.8u as=0 ps=0 w=0.42u l=1u
X450 VDD VSS.t1574 VDD VDD sg13_lv_pmos ad=0.34p pd=2.68u as=0 ps=0 w=1u l=1u
X451 VSS.t1605 VDD VSS.t1607 VSS.t1606 sg13_lv_nmos ad=79.8f pd=0.8u as=0 ps=0 w=0.42u l=1u
X452 VDD VSS.t2448 VDD VDD sg13_lv_pmos ad=0.34p pd=2.68u as=0 ps=0 w=1u l=1u
X453 VDD VSS.t401 VDD VDD sg13_lv_pmos ad=0.34p pd=2.68u as=0 ps=0 w=1u l=1u
X454 VSS.t2723 VDD VSS.t2724 VSS.t198 sg13_lv_nmos ad=79.8f pd=0.8u as=0 ps=0 w=0.42u l=1u
X455 VDD VSS.t2476 VDD VDD sg13_lv_pmos ad=0.19p pd=1.38u as=0 ps=0 w=1u l=1u
X456 VDD VSS.t1916 VDD VDD sg13_lv_pmos ad=0.34p pd=2.68u as=0 ps=0 w=1u l=1u
X457 VSS.t2309 VDD VSS.t2311 VSS.t2310 sg13_lv_nmos ad=79.8f pd=0.8u as=0 ps=0 w=0.42u l=1u
X458 VDD VSS.t2251 VDD VDD sg13_lv_pmos ad=0.19p pd=1.38u as=0 ps=0 w=1u l=1u
X459 a_9801_15625# a_9444_15552# VDD VDD sg13_lv_pmos ad=63f pd=0.72u as=0.1563p ps=1.22u w=0.42u l=0.13u
X460 VDD VSS.t953 VDD VDD sg13_lv_pmos ad=0.34p pd=2.68u as=0 ps=0 w=1u l=1u
X461 VDD VSS.t3034 VDD VDD sg13_lv_pmos ad=0.19p pd=1.38u as=0 ps=0 w=1u l=1u
X462 VSS.t2082 VDD VSS.t2084 VSS.t2083 sg13_lv_nmos ad=79.8f pd=0.8u as=0 ps=0 w=0.42u l=1u
X463 VSS.t536 VDD VSS.t535 VSS.t534 sg13_lv_nmos ad=0.1428p pd=1.52u as=0 ps=0 w=0.42u l=1u
X464 VDD VSS.t44 VDD VDD sg13_lv_pmos ad=0.19p pd=1.38u as=0 ps=0 w=1u l=1u
X465 VDD VSS.t1197 VDD VDD sg13_lv_pmos ad=0.19p pd=1.38u as=0 ps=0 w=1u l=1u
X466 VSS.t1271 VDD VSS.t1271 VSS.t1154 sg13_lv_nmos ad=79.8f pd=0.8u as=0 ps=0 w=0.42u l=1u
X467 VDD VSS.t1223 VDD VDD sg13_lv_pmos ad=0.34p pd=2.68u as=0 ps=0 w=1u l=1u
X468 VDD VSS.t2724 VDD VDD sg13_lv_pmos ad=0.34p pd=2.68u as=0 ps=0 w=1u l=1u
X469 VDD a_25094_15238# a_25206_15302# VDD sg13_lv_pmos ad=0.2254p pd=1.53u as=0.34p ps=2.68u w=1u l=0.5u
X470 VDD VSS.t2101 VDD VDD sg13_lv_pmos ad=0.34p pd=2.68u as=0 ps=0 w=1u l=1u
X471 VDD VSS.t1924 VDD VDD sg13_lv_pmos ad=0.19p pd=1.38u as=0 ps=0 w=1u l=1u
X472 VDD VSS.t407 VDD VDD sg13_lv_pmos ad=0.34p pd=2.68u as=0 ps=0 w=1u l=1u
X473 VDD VSS.t1689 VDD VDD sg13_lv_pmos ad=0.34p pd=2.68u as=0 ps=0 w=1u l=1u
X474 VSS.t2489 VDD VSS.t2488 VSS.t2487 sg13_lv_nmos ad=0.1428p pd=1.52u as=0 ps=0 w=0.42u l=1u
X475 VSS.t435 VDD VSS.t434 VSS.t11 sg13_lv_nmos ad=0.1428p pd=1.52u as=0 ps=0 w=0.42u l=1u
X476 VSS.t1595 VDD VSS.t1597 VSS.t1596 sg13_lv_nmos ad=79.8f pd=0.8u as=0 ps=0 w=0.42u l=1u
X477 VSS.t3112 VDD VSS.t3114 VSS.t3113 sg13_lv_nmos ad=79.8f pd=0.8u as=0 ps=0 w=0.42u l=1u
X478 VDD VSS.t87 VDD VDD sg13_lv_pmos ad=0.34p pd=2.68u as=0 ps=0 w=1u l=1u
X479 VDD VSS.t1554 VDD VDD sg13_lv_pmos ad=0.34p pd=2.68u as=0 ps=0 w=1u l=1u
X480 VSS.t2769 VDD VSS.t2770 VSS.t198 sg13_lv_nmos ad=79.8f pd=0.8u as=0 ps=0 w=0.42u l=1u
X481 VDD a_21946_16237# sg13cmos5l_dfrbpq_1_6.RESET_B VDD sg13_lv_pmos ad=2.8961p pd=18.25u as=0.3927p ps=2.99u w=1.155u l=0.13u
X482 VDD a_12010_15202# sg13cmos5l_dfrbpq_1_2.CLK VDD sg13_lv_pmos ad=0.2128p pd=1.5u as=0.2128p ps=1.5u w=1.12u l=0.13u
X483 VDD VSS.t968 VDD VDD sg13_lv_pmos ad=0.34p pd=2.68u as=0 ps=0 w=1u l=1u
X484 VDD VSS.t2683 VDD VDD sg13_lv_pmos ad=0.34p pd=2.68u as=0 ps=0 w=1u l=1u
X485 VDD VSS.t2468 VDD VDD sg13_lv_pmos ad=0.34p pd=2.68u as=0 ps=0 w=1u l=1u
X486 VDD VSS.t501 VDD VDD sg13_lv_pmos ad=0.34p pd=2.68u as=0 ps=0 w=1u l=1u
X487 VDD VSS.t1265 VDD VDD sg13_lv_pmos ad=0.19p pd=1.38u as=0 ps=0 w=1u l=1u
X488 VDD VSS.t2074 VDD VDD sg13_lv_pmos ad=0.19p pd=1.38u as=0 ps=0 w=1u l=1u
X489 VSS.t72 VDD VSS.t44 VSS.t516 sg13_lv_nmos ad=79.8f pd=0.8u as=0 ps=0 w=0.42u l=1u
X490 VSS.t632 VDD VSS.t629 VSS.t631 sg13_lv_nmos ad=0.1428p pd=1.52u as=0 ps=0 w=0.42u l=1u
X491 VDD VSS.t2741 VDD VDD sg13_lv_pmos ad=0.19p pd=1.38u as=0 ps=0 w=1u l=1u
X492 VDD VSS.t2428 VDD VDD sg13_lv_pmos ad=0.34p pd=2.68u as=0 ps=0 w=1u l=1u
X493 VSS.t2454 VDD VSS.t2453 VSS.t2452 sg13_lv_nmos ad=0.1428p pd=1.52u as=0 ps=0 w=0.42u l=1u
X494 VSS.t44 a_6286_13911# sg13cmos5l_dlygate4sd3_1_0.X VSS.t3276 sg13_lv_nmos ad=0.1426p pd=1.16u as=0.2516p ps=2.16u w=0.74u l=0.13u
X495 VSS.t1253 VDD VSS.t1252 VSS.t1154 sg13_lv_nmos ad=0.1428p pd=1.52u as=0 ps=0 w=0.42u l=1u
X496 VSS.t274 VDD VSS.t274 VSS.t277 sg13_lv_nmos ad=79.8f pd=0.8u as=0 ps=0 w=0.42u l=1u
X497 VSS.t2942 VDD VSS.t2944 VSS.t2943 sg13_lv_nmos ad=79.8f pd=0.8u as=0 ps=0 w=0.42u l=1u
X498 VSS.t2037 VDD VSS.t2036 VSS.t2035 sg13_lv_nmos ad=0.1428p pd=1.52u as=0 ps=0 w=0.42u l=1u
X499 VSS.t1246 VDD VSS.t1247 VSS.t1154 sg13_lv_nmos ad=79.8f pd=0.8u as=0 ps=0 w=0.42u l=1u
X500 VSS.t1620 VDD VSS.t1619 VSS.t1618 sg13_lv_nmos ad=0.1428p pd=1.52u as=0 ps=0 w=0.42u l=1u
X501 VDD VSS.t150 VDD VDD sg13_lv_pmos ad=0.34p pd=2.68u as=0 ps=0 w=1u l=1u
X502 a_26638_15423# a_26753_15424# VDD VDD sg13_lv_pmos ad=0.34p pd=2.68u as=0.2254p ps=1.53u w=1u l=0.5u
X503 VDD VSS.t791 VDD VDD sg13_lv_pmos ad=0.19p pd=1.38u as=0 ps=0 w=1u l=1u
X504 VDD VSS.t2263 VDD VDD sg13_lv_pmos ad=0.34p pd=2.68u as=0 ps=0 w=1u l=1u
X505 VDD VSS.t599 VDD VDD sg13_lv_pmos ad=0.19p pd=1.38u as=0 ps=0 w=1u l=1u
X506 VDD VSS.t1587 VDD VDD sg13_lv_pmos ad=0.19p pd=1.38u as=0 ps=0 w=1u l=1u
X507 VDD VSS.t3046 VDD VDD sg13_lv_pmos ad=0.34p pd=2.68u as=0 ps=0 w=1u l=1u
X508 VSS.t593 VDD VSS.t593 VSS.t732 sg13_lv_nmos ad=0.1428p pd=1.52u as=0 ps=0 w=0.42u l=1u
X509 VDD VSS.t1230 VDD VDD sg13_lv_pmos ad=0.19p pd=1.38u as=0 ps=0 w=1u l=1u
X510 VSS.t1289 VDD VSS.t1290 VSS.t1154 sg13_lv_nmos ad=79.8f pd=0.8u as=0 ps=0 w=0.42u l=1u
X511 VDD a_26170_15202# a_25889_15424# VDD sg13_lv_pmos ad=0.1523p pd=1.38u as=0.34p ps=2.68u w=1u l=0.5u
X512 VDD VSS.t1869 VDD VDD sg13_lv_pmos ad=0.19p pd=1.38u as=0 ps=0 w=1u l=1u
X513 VDD VSS.t2648 VDD VDD sg13_lv_pmos ad=0.19p pd=1.38u as=0 ps=0 w=1u l=1u
X514 VDD VSS.t2703 VDD VDD sg13_lv_pmos ad=0.19p pd=1.38u as=0 ps=0 w=1u l=1u
X515 VSS.t1987 VDD VSS.t1986 VSS.t1985 sg13_lv_nmos ad=0.1428p pd=1.52u as=0 ps=0 w=0.42u l=1u
X516 VDD a_12010_15202# sg13cmos5l_dfrbpq_1_2.CLK VDD sg13_lv_pmos ad=0.2128p pd=1.5u as=0.2128p ps=1.5u w=1.12u l=0.13u
X517 a_6789_14495# sg13cmos5l_dfrbpq_1_2.CLK VSS.t11 VSS.t3180 sg13_lv_nmos ad=0.2516p pd=2.16u as=3.8707p ps=25.555u w=0.74u l=0.13u
X518 VSS.t1550 VDD VSS.t1549 VSS.t1548 sg13_lv_nmos ad=0.1428p pd=1.52u as=0 ps=0 w=0.42u l=1u
X519 VSS.t3067 VDD VSS.t3066 VSS.t3065 sg13_lv_nmos ad=0.1428p pd=1.52u as=0 ps=0 w=0.42u l=1u
X520 VSS.t2284 VDD VSS.t2283 VSS.t2282 sg13_lv_nmos ad=0.1428p pd=1.52u as=0 ps=0 w=0.42u l=1u
X521 VSS.t385 VDD VSS.t387 VSS.t386 sg13_lv_nmos ad=79.8f pd=0.8u as=0 ps=0 w=0.42u l=1u
X522 VDD VSS.t1192 VDD VDD sg13_lv_pmos ad=0.34p pd=2.68u as=0 ps=0 w=1u l=1u
X523 VDD VSS.t578 VDD VDD sg13_lv_pmos ad=0.34p pd=2.68u as=0 ps=0 w=1u l=1u
X524 VSS.t2359 VDD VSS.t2358 VSS.t2357 sg13_lv_nmos ad=0.1428p pd=1.52u as=0 ps=0 w=0.42u l=1u
X525 VDD VSS.t1157 VDD VDD sg13_lv_pmos ad=0.19p pd=1.38u as=0 ps=0 w=1u l=1u
X526 VDD VSS.t2752 VDD VDD sg13_lv_pmos ad=0.19p pd=1.38u as=0 ps=0 w=1u l=1u
X527 VDD VSS.t2461 VDD VDD sg13_lv_pmos ad=0.19p pd=1.38u as=0 ps=0 w=1u l=1u
X528 VDD VSS.t2059 VDD VDD sg13_lv_pmos ad=0.19p pd=1.38u as=0 ps=0 w=1u l=1u
X529 sg13cmos5l_buf_8_2.A a_15579_14854# VDD VDD sg13_lv_pmos ad=0.2128p pd=1.5u as=0.2128p ps=1.5u w=1.12u l=0.13u
X530 VSS.t103 sg13cmos5l_dlygate4sd3_1_17.A a_24824_14525# VSS.t4 sg13_lv_nmos ad=79.8f pd=0.8u as=0.1428p ps=1.52u w=0.42u l=0.13u
X531 VDD VSS.t998 VDD VDD sg13_lv_pmos ad=0.34p pd=2.68u as=0 ps=0 w=1u l=1u
X532 VDD VSS.t1256 VDD VDD sg13_lv_pmos ad=0.19p pd=1.38u as=0 ps=0 w=1u l=1u
X533 VSS.t2474 VDD VSS.t2473 VSS.t2472 sg13_lv_nmos ad=0.1428p pd=1.52u as=0 ps=0 w=0.42u l=1u
X534 VSS.t2294 VDD VSS.t2296 VSS.t2295 sg13_lv_nmos ad=79.8f pd=0.8u as=0 ps=0 w=0.42u l=1u
X535 a_22576_14726# sg13cmos5l_dfrbpq_1_6.RESET_B VDD VDD sg13_lv_pmos ad=79.8f pd=0.8u as=2.42015p ps=15.68u w=0.42u l=0.13u
X536 VDD VSS.t806 VDD VDD sg13_lv_pmos ad=0.19p pd=1.38u as=0 ps=0 w=1u l=1u
X537 VDD VSS.t2236 VDD VDD sg13_lv_pmos ad=0.19p pd=1.38u as=0 ps=0 w=1u l=1u
X538 a_27609_14037# a_26667_13844# a_27407_13799# VDD sg13_lv_pmos ad=93.45f pd=0.865u as=0.2048p ps=1.63u w=0.42u l=0.13u
X539 VSS.t2767 VDD VSS.t2768 VSS.t198 sg13_lv_nmos ad=79.8f pd=0.8u as=0 ps=0 w=0.42u l=1u
X540 VSS.t11 a_26373_14495# a_26475_14495# VSS.t230 sg13_lv_nmos ad=4.11262p pd=27.15u as=0.2516p ps=2.16u w=0.74u l=0.13u
X541 VSS.t1640 VDD VSS.t1639 VSS.t1638 sg13_lv_nmos ad=0.1428p pd=1.52u as=0 ps=0 w=0.42u l=1u
X542 VDD VSS.t2331 VDD VDD sg13_lv_pmos ad=0.19p pd=1.38u as=0 ps=0 w=1u l=1u
X543 VSS.t319 VDD VSS.t7 VSS.t320 sg13_lv_nmos ad=79.8f pd=0.8u as=0 ps=0 w=0.42u l=1u
X544 VDD sg13cmos5l_dfrbpq_1_1.RESET_B a_6086_14922# VDD sg13_lv_pmos ad=0.36237p pd=2.605u as=79.8f ps=0.8u w=0.42u l=0.13u
X545 VDD VSS.t23 VDD VDD sg13_lv_pmos ad=0.34p pd=2.68u as=0 ps=0 w=1u l=1u
X546 VSS.t1034 VDD VSS.t1033 VSS.t1032 sg13_lv_nmos ad=0.1428p pd=1.52u as=0 ps=0 w=0.42u l=1u
X547 VDD VSS.t1271 VDD VDD sg13_lv_pmos ad=0.34p pd=2.68u as=0 ps=0 w=1u l=1u
X548 VDD VSS.t2768 VDD VDD sg13_lv_pmos ad=0.34p pd=2.68u as=0 ps=0 w=1u l=1u
X549 VDD VSS.t2086 VDD VDD sg13_lv_pmos ad=0.34p pd=2.68u as=0 ps=0 w=1u l=1u
X550 VDD a_37484_15960# counter_value_o[7] VDD sg13_lv_pmos ad=0.2114p pd=1.54u as=0.42p ps=2.99u w=1.12u l=0.13u
X551 a_20774_14922# a_21579_14495# a_21034_14452# VDD sg13_lv_pmos ad=0.1428p pd=1.52u as=79.8f ps=0.8u w=0.42u l=0.13u
X552 VSS.t1431 VDD VSS.t1304 VSS.t1154 sg13_lv_nmos ad=79.8f pd=0.8u as=0 ps=0 w=0.42u l=1u
X553 VSS.t1937 VDD VSS.t1939 VSS.t1938 sg13_lv_nmos ad=79.8f pd=0.8u as=0 ps=0 w=0.42u l=1u
X554 VDD VSS.t543 VDD VDD sg13_lv_pmos ad=0.19p pd=1.38u as=0 ps=0 w=1u l=1u
X555 VDD VSS.t588 VDD VDD sg13_lv_pmos ad=0.34p pd=2.68u as=0 ps=0 w=1u l=1u
X556 VDD VSS.t2114 VDD VDD sg13_lv_pmos ad=0.19p pd=1.38u as=0 ps=0 w=1u l=1u
X557 VDD VSS.t1539 VDD VDD sg13_lv_pmos ad=0.34p pd=2.68u as=0 ps=0 w=1u l=1u
X558 VDD VSS.t1889 VDD VDD sg13_lv_pmos ad=0.19p pd=1.38u as=0 ps=0 w=1u l=1u
X559 VSS.t2760 VDD VSS.t2761 VSS.t198 sg13_lv_nmos ad=79.8f pd=0.8u as=0 ps=0 w=0.42u l=1u
X560 VDD VSS.t2715 VDD VDD sg13_lv_pmos ad=0.19p pd=1.38u as=0 ps=0 w=1u l=1u
X561 VSS.t429 VDD VSS.t428 VSS.t11 sg13_lv_nmos ad=0.1428p pd=1.52u as=0 ps=0 w=0.42u l=1u
X562 sg13cmos5l_dlygate4sd3_1_17.A sg13cmos5l_a21oi_1_3.B1 VSS.t16 VSS.t15 sg13_lv_nmos ad=0.1406p pd=1.12u as=0.2516p ps=2.16u w=0.74u l=0.13u
X563 VSS.t1223 VDD VSS.t1223 VSS.t1154 sg13_lv_nmos ad=79.8f pd=0.8u as=0 ps=0 w=0.42u l=1u
X564 VDD VSS.t626 VDD VDD sg13_lv_pmos ad=0.19p pd=1.38u as=0 ps=0 w=1u l=1u
X565 VDD VSS.t617 VDD VDD sg13_lv_pmos ad=0.19p pd=1.38u as=0 ps=0 w=1u l=1u
X566 VDD VSS.t1544 VDD VDD sg13_lv_pmos ad=0.34p pd=2.68u as=0 ps=0 w=1u l=1u
X567 VDD VSS.t2481 VDD VDD sg13_lv_pmos ad=0.19p pd=1.38u as=0 ps=0 w=1u l=1u
X568 VSS.t187 sg13cmos5l_buf_1_0.X a_2490_14447# VSS.t3204 sg13_lv_nmos ad=0.374p pd=2.46u as=0.17462p ps=1.185u w=0.55u l=0.13u
X569 VDD VSS.t961 VDD VDD sg13_lv_pmos ad=0.19p pd=1.38u as=0 ps=0 w=1u l=1u
X570 VSS.t1670 VDD VSS.t1672 VSS.t1671 sg13_lv_nmos ad=79.8f pd=0.8u as=0 ps=0 w=0.42u l=1u
X571 VDD VSS.t2730 VDD VDD sg13_lv_pmos ad=0.34p pd=2.68u as=0 ps=0 w=1u l=1u
X572 VSS.t2087 VDD VSS.t2089 VSS.t2088 sg13_lv_nmos ad=79.8f pd=0.8u as=0 ps=0 w=0.42u l=1u
X573 VSS.t2758 VDD VSS.t2759 VSS.t198 sg13_lv_nmos ad=79.8f pd=0.8u as=0 ps=0 w=0.42u l=1u
X574 VSS.t844 VDD VSS.t846 VSS.t845 sg13_lv_nmos ad=79.8f pd=0.8u as=0 ps=0 w=0.42u l=1u
X575 VSS.t2927 VDD VSS.t2929 VSS.t2928 sg13_lv_nmos ad=79.8f pd=0.8u as=0 ps=0 w=0.42u l=1u
X576 a_2916_15552# a_3435_15356# a_4175_15311# VSS.t105 sg13_lv_nmos ad=0.3473p pd=2.71u as=0.12665p ps=1.145u w=0.74u l=0.13u
X577 VDD a_22030_15423# sg13cmos5l_or3_1_2.A VDD sg13_lv_pmos ad=0.2254p pd=1.53u as=0.4256p ps=3u w=1.12u l=0.13u
X578 VSS.t1972 VDD VSS.t1974 VSS.t1973 sg13_lv_nmos ad=79.8f pd=0.8u as=0 ps=0 w=0.42u l=1u
X579 VDD VSS.t1929 VDD VDD sg13_lv_pmos ad=0.19p pd=1.38u as=0 ps=0 w=1u l=1u
X580 VDD VSS.t2661 VDD VDD sg13_lv_pmos ad=0.19p pd=1.38u as=0 ps=0 w=1u l=1u
X581 VSS.t2344 VDD VSS.t2343 VSS.t2342 sg13_lv_nmos ad=0.1428p pd=1.52u as=0 ps=0 w=0.42u l=1u
X582 VDD VSS.t635 VDD VDD sg13_lv_pmos ad=0.19p pd=1.38u as=0 ps=0 w=1u l=1u
X583 VDD VSS.t3031 VDD VDD sg13_lv_pmos ad=0.34p pd=2.68u as=0 ps=0 w=1u l=1u
X584 VDD VSS.t2248 VDD VDD sg13_lv_pmos ad=0.34p pd=2.68u as=0 ps=0 w=1u l=1u
X585 VSS.t1600 VDD VSS.t1602 VSS.t1601 sg13_lv_nmos ad=79.8f pd=0.8u as=0 ps=0 w=0.42u l=1u
X586 VSS.t3117 VDD VSS.t3119 VSS.t3118 sg13_lv_nmos ad=79.8f pd=0.8u as=0 ps=0 w=0.42u l=1u
X587 VDD VSS.t2276 VDD VDD sg13_lv_pmos ad=0.19p pd=1.38u as=0 ps=0 w=1u l=1u
X588 a_4175_15311# a_3333_15213# a_2916_15552# VDD sg13_lv_pmos ad=0.2048p pd=1.63u as=0.34p ps=2.68u w=1u l=0.13u
X589 VSS.t566 VDD VSS.t568 VSS.t567 sg13_lv_nmos ad=79.8f pd=0.8u as=0 ps=0 w=0.42u l=1u
X590 VDD VSS.t1612 VDD VDD sg13_lv_pmos ad=0.19p pd=1.38u as=0 ps=0 w=1u l=1u
X591 a_7532_15960# sg13cmos5l_dlygate4sd3_1_1.A VDD VDD sg13_lv_pmos ad=0.2856p pd=2.36u as=0.2114p ps=1.54u w=0.84u l=0.13u
X592 VSS.t1205 VDD VSS.t1204 VSS.t1154 sg13_lv_nmos ad=0.1428p pd=1.52u as=0 ps=0 w=0.42u l=1u
X593 a_26182_14909# sg13cmos5l_dfrbpq_1_7.RESET_B VSS.t42 VSS.t245 sg13_lv_nmos ad=37.8f pd=0.6u as=0.1701p ps=1.65u w=0.42u l=0.13u
X594 VSS.t1500 VDD VSS.t1502 VSS.t1501 sg13_lv_nmos ad=79.8f pd=0.8u as=0 ps=0 w=0.42u l=1u
X595 VSS.t2409 VDD VSS.t2411 VSS.t2410 sg13_lv_nmos ad=79.8f pd=0.8u as=0 ps=0 w=0.42u l=1u
X596 VSS.t1882 VDD VSS.t1884 VSS.t1883 sg13_lv_nmos ad=79.8f pd=0.8u as=0 ps=0 w=0.42u l=1u
X597 VDD VSS.t580 VDD VDD sg13_lv_pmos ad=0.34p pd=2.68u as=0 ps=0 w=1u l=1u
X598 VDD VSS.t928 VDD VDD sg13_lv_pmos ad=0.34p pd=2.68u as=0 ps=0 w=1u l=1u
X599 VSS.t227 VDD VSS.t227 VSS.t363 sg13_lv_nmos ad=0.1428p pd=1.52u as=0 ps=0 w=0.42u l=1u
X600 VSS.t799 VDD VSS.t798 VSS.t797 sg13_lv_nmos ad=0.1428p pd=1.52u as=0 ps=0 w=0.42u l=1u
X601 VDD VSS.t1247 VDD VDD sg13_lv_pmos ad=0.19p pd=1.38u as=0 ps=0 w=1u l=1u
X602 VDD VSS.t1901 VDD VDD sg13_lv_pmos ad=0.34p pd=2.68u as=0 ps=0 w=1u l=1u
X603 VDD VSS.t2743 VDD VDD sg13_lv_pmos ad=0.19p pd=1.38u as=0 ps=0 w=1u l=1u
X604 VSS.t2685 VDD VSS.t2687 VSS.t198 sg13_lv_nmos ad=79.8f pd=0.8u as=0 ps=0 w=0.42u l=1u
X605 VDD VSS.t2721 VDD VDD sg13_lv_pmos ad=0.34p pd=2.68u as=0 ps=0 w=1u l=1u
X606 VSS.t2459 VDD VSS.t2458 VSS.t2457 sg13_lv_nmos ad=0.1428p pd=1.52u as=0 ps=0 w=0.42u l=1u
X607 a_17318_14922# a_18123_14495# a_17578_14452# VDD sg13_lv_pmos ad=0.1428p pd=1.52u as=79.8f ps=0.8u w=0.42u l=0.13u
X608 VSS.t432 VDD VSS.t433 VSS.t11 sg13_lv_nmos ad=79.8f pd=0.8u as=0 ps=0 w=0.42u l=1u
X609 VSS.t2912 VDD VSS.t2914 VSS.t2913 sg13_lv_nmos ad=79.8f pd=0.8u as=0 ps=0 w=0.42u l=1u
X610 VDD VSS.t991 VDD VDD sg13_lv_pmos ad=0.19p pd=1.38u as=0 ps=0 w=1u l=1u
X611 VSS.t1034 VDD VSS.t1033 VSS.t1032 sg13_lv_nmos ad=0.1428p pd=1.52u as=0 ps=0 w=0.42u l=1u
X612 VSS.t1625 VDD VSS.t1624 VSS.t1623 sg13_lv_nmos ad=0.1428p pd=1.52u as=0 ps=0 w=0.42u l=1u
X613 VSS.t2733 VDD VSS.t2733 VSS.t198 sg13_lv_nmos ad=0.1428p pd=1.52u as=0 ps=0 w=0.42u l=1u
X614 VDD VSS.t2493 VDD VDD sg13_lv_pmos ad=0.34p pd=2.68u as=0 ps=0 w=1u l=1u
X615 VDD VSS.t2316 VDD VDD sg13_lv_pmos ad=0.19p pd=1.38u as=0 ps=0 w=1u l=1u
X616 VSS.t394 VDD VSS.t394 VSS.t393 sg13_lv_nmos ad=0.1428p pd=1.52u as=0 ps=0 w=0.42u l=1u
X617 VDD VSS.t2268 VDD VDD sg13_lv_pmos ad=0.34p pd=2.68u as=0 ps=0 w=1u l=1u
X618 a_16175_15238# a_16140_15424# sg13cmos5l_nor2_1_0.B VSS.t14 sg13_lv_nmos ad=0.1406p pd=1.12u as=0.2516p ps=2.16u w=0.74u l=0.13u
X619 VDD VSS.t543 VDD VDD sg13_lv_pmos ad=0.19p pd=1.38u as=0 ps=0 w=1u l=1u
X620 VDD VSS.t1592 VDD VDD sg13_lv_pmos ad=0.19p pd=1.38u as=0 ps=0 w=1u l=1u
X621 VDD VSS.t3051 VDD VDD sg13_lv_pmos ad=0.34p pd=2.68u as=0 ps=0 w=1u l=1u
X622 VSS.t2102 VDD VSS.t2101 VSS.t2100 sg13_lv_nmos ad=0.1428p pd=1.52u as=0 ps=0 w=0.42u l=1u
X623 VSS.t1922 VDD VSS.t1924 VSS.t1923 sg13_lv_nmos ad=79.8f pd=0.8u as=0 ps=0 w=0.42u l=1u
X624 VSS.t536 VDD VSS.t535 VSS.t534 sg13_lv_nmos ad=0.1428p pd=1.52u as=0 ps=0 w=0.42u l=1u
X625 VDD VSS.t2441 VDD VDD sg13_lv_pmos ad=0.19p pd=1.38u as=0 ps=0 w=1u l=1u
X626 VDD VSS.t2099 VDD VDD sg13_lv_pmos ad=0.19p pd=1.38u as=0 ps=0 w=1u l=1u
X627 VSS.t1181 VDD VSS.t1182 VSS.t1154 sg13_lv_nmos ad=79.8f pd=0.8u as=0 ps=0 w=0.42u l=1u
X628 VSS.t1219 VDD VSS.t1218 VSS.t1154 sg13_lv_nmos ad=0.1428p pd=1.52u as=0 ps=0 w=0.42u l=1u
X629 VDD VSS.t1597 VDD VDD sg13_lv_pmos ad=0.19p pd=1.38u as=0 ps=0 w=1u l=1u
X630 VDD VSS.t1874 VDD VDD sg13_lv_pmos ad=0.19p pd=1.38u as=0 ps=0 w=1u l=1u
X631 VDD VSS.t2651 VDD VDD sg13_lv_pmos ad=0.19p pd=1.38u as=0 ps=0 w=1u l=1u
X632 VDD VSS.t2706 VDD VDD sg13_lv_pmos ad=0.19p pd=1.38u as=0 ps=0 w=1u l=1u
X633 a_4175_15311# a_3333_15213# a_4081_15311# VSS.t256 sg13_lv_nmos ad=0.12665p pd=1.145u as=0.1428p ps=1.52u w=0.42u l=0.13u
X634 VDD VSS.t1312 VDD VDD sg13_lv_pmos ad=0.34p pd=2.68u as=0 ps=0 w=1u l=1u
X635 VSS.t1555 VDD VSS.t1554 VSS.t1553 sg13_lv_nmos ad=0.1428p pd=1.52u as=0 ps=0 w=0.42u l=1u
X636 VSS.t3072 VDD VSS.t3071 VSS.t3070 sg13_lv_nmos ad=0.1428p pd=1.52u as=0 ps=0 w=0.42u l=1u
X637 VSS.t2289 VDD VSS.t2288 VSS.t2287 sg13_lv_nmos ad=0.1428p pd=1.52u as=0 ps=0 w=0.42u l=1u
X638 VSS.t184 a_7888_14726# a_7537_14845# VSS.t234 sg13_lv_nmos ad=79.8f pd=0.8u as=0.1428p ps=1.52u w=0.42u l=0.13u
X639 VSS.t602 VDD VSS.t602 VSS.t603 sg13_lv_nmos ad=79.8f pd=0.8u as=0 ps=0 w=0.42u l=1u
X640 VSS.t954 VDD VSS.t953 VSS.t952 sg13_lv_nmos ad=0.1428p pd=1.52u as=0 ps=0 w=0.42u l=1u
X641 VDD VSS.t2466 VDD VDD sg13_lv_pmos ad=0.19p pd=1.38u as=0 ps=0 w=1u l=1u
X642 VSS.t2329 VDD VSS.t2328 VSS.t2327 sg13_lv_nmos ad=0.1428p pd=1.52u as=0 ps=0 w=0.42u l=1u
X643 VSS.t844 VDD VSS.t846 VSS.t845 sg13_lv_nmos ad=79.8f pd=0.8u as=0 ps=0 w=0.42u l=1u
X644 VDD VSS.t818 VDD VDD sg13_lv_pmos ad=0.34p pd=2.68u as=0 ps=0 w=1u l=1u
X645 VSS.t2677 VDD VSS.t2678 VSS.t198 sg13_lv_nmos ad=79.8f pd=0.8u as=0 ps=0 w=0.42u l=1u
X646 VSS.t414 VDD VSS.t413 VSS.t11 sg13_lv_nmos ad=0.1428p pd=1.52u as=0 ps=0 w=0.42u l=1u
X647 VSS.t2072 VDD VSS.t2074 VSS.t2073 sg13_lv_nmos ad=79.8f pd=0.8u as=0 ps=0 w=0.42u l=1u
X648 VSS.t2749 VDD VSS.t2750 VSS.t198 sg13_lv_nmos ad=79.8f pd=0.8u as=0 ps=0 w=0.42u l=1u
X649 VDD VSS.t366 VDD VDD sg13_lv_pmos ad=0.19p pd=1.38u as=0 ps=0 w=1u l=1u
X650 a_27826_13722# sg13cmos5l_dfrbpq_1_5.RESET_B VSS.t147 VSS.t146 sg13_lv_nmos ad=37.8f pd=0.6u as=79.8f ps=0.8u w=0.42u l=0.13u
X651 VSS.t72 VDD VSS.t44 VSS.t516 sg13_lv_nmos ad=79.8f pd=0.8u as=0 ps=0 w=0.42u l=1u
X652 VDD VSS.t1274 VDD VDD sg13_lv_pmos ad=0.34p pd=2.68u as=0 ps=0 w=1u l=1u
X653 VDD VSS.t2091 VDD VDD sg13_lv_pmos ad=0.34p pd=2.68u as=0 ps=0 w=1u l=1u
X654 VDD VSS.t343 VDD VDD sg13_lv_pmos ad=0.19p pd=1.38u as=0 ps=0 w=1u l=1u
X655 VSS.t1165 VDD VSS.t1164 VSS.t1154 sg13_lv_nmos ad=0.1428p pd=1.52u as=0 ps=0 w=0.42u l=1u
X656 VDD VSS.t2871 VDD VDD sg13_lv_pmos ad=0.34p pd=2.68u as=0 ps=0 w=1u l=1u
X657 VSS.t1942 VDD VSS.t1944 VSS.t1943 sg13_lv_nmos ad=79.8f pd=0.8u as=0 ps=0 w=0.42u l=1u
X658 VDD VSS.t881 VDD VDD sg13_lv_pmos ad=0.19p pd=1.38u as=0 ps=0 w=1u l=1u
X659 VSS.t969 VDD VSS.t968 VSS.t967 sg13_lv_nmos ad=0.1428p pd=1.52u as=0 ps=0 w=0.42u l=1u
X660 VSS.t1585 VDD VSS.t1587 VSS.t1586 sg13_lv_nmos ad=79.8f pd=0.8u as=0 ps=0 w=0.42u l=1u
X661 VSS.t3102 VDD VSS.t3104 VSS.t3103 sg13_lv_nmos ad=79.8f pd=0.8u as=0 ps=0 w=0.42u l=1u
X662 VDD VSS.t2261 VDD VDD sg13_lv_pmos ad=0.19p pd=1.38u as=0 ps=0 w=1u l=1u
X663 sg13cmos5l_a21oi_1_3.A1 a_25206_15302# VSS.t5 VSS.t64 sg13_lv_nmos ad=0.2516p pd=2.16u as=0.1426p ps=1.16u w=0.74u l=0.13u
X664 VDD VSS.t2643 VDD VDD sg13_lv_pmos ad=0.19p pd=1.38u as=0 ps=0 w=1u l=1u
X665 VSS.t1977 VDD VSS.t1976 VSS.t1975 sg13_lv_nmos ad=0.1428p pd=1.52u as=0 ps=0 w=0.42u l=1u
X666 VSS.t3057 VDD VSS.t3056 VSS.t3055 sg13_lv_nmos ad=0.1428p pd=1.52u as=0 ps=0 w=0.42u l=1u
X667 VSS.t2274 VDD VSS.t2273 VSS.t2272 sg13_lv_nmos ad=0.1428p pd=1.52u as=0 ps=0 w=0.42u l=1u
X668 VSS.t1485 VDD VSS.t1487 VSS.t1486 sg13_lv_nmos ad=79.8f pd=0.8u as=0 ps=0 w=0.42u l=1u
X669 VSS.t2394 VDD VSS.t2396 VSS.t2395 sg13_lv_nmos ad=79.8f pd=0.8u as=0 ps=0 w=0.42u l=1u
X670 a_6729_14531# a_6372_14488# VDD VDD sg13_lv_pmos ad=63f pd=0.72u as=0.1563p ps=1.22u w=0.42u l=0.13u
X671 VDD VSS.t1549 VDD VDD sg13_lv_pmos ad=0.34p pd=2.68u as=0 ps=0 w=1u l=1u
X672 VSS.t11 a_27034_15202# a_26753_15424# VSS.t84 sg13_lv_nmos ad=79.8f pd=0.8u as=0.1428p ps=1.52u w=0.42u l=0.5u
X673 VDD VSS.t1604 VDD VDD sg13_lv_pmos ad=0.34p pd=2.68u as=0 ps=0 w=1u l=1u
X674 VSS.t2349 VDD VSS.t2348 VSS.t2347 sg13_lv_nmos ad=0.1428p pd=1.52u as=0 ps=0 w=0.42u l=1u
X675 VSS.t799 VDD VSS.t798 VSS.t797 sg13_lv_nmos ad=0.1428p pd=1.52u as=0 ps=0 w=0.42u l=1u
X676 VDD VSS.t973 VDD VDD sg13_lv_pmos ad=0.34p pd=2.68u as=0 ps=0 w=1u l=1u
X677 VDD VSS.t2451 VDD VDD sg13_lv_pmos ad=0.19p pd=1.38u as=0 ps=0 w=1u l=1u
X678 VSS.t556 VDD VSS.t555 VSS.t554 sg13_lv_nmos ad=0.1428p pd=1.52u as=0 ps=0 w=0.42u l=1u
X679 VDD VSS.t1209 VDD VDD sg13_lv_pmos ad=0.19p pd=1.38u as=0 ps=0 w=1u l=1u
X680 VSS.t1675 VDD VSS.t1677 VSS.t1676 sg13_lv_nmos ad=79.8f pd=0.8u as=0 ps=0 w=0.42u l=1u
X681 VDD VSS.t1886 VDD VDD sg13_lv_pmos ad=0.34p pd=2.68u as=0 ps=0 w=1u l=1u
X682 VDD VSS.t2713 VDD VDD sg13_lv_pmos ad=0.34p pd=2.68u as=0 ps=0 w=1u l=1u
X683 VDD VSS.t911 VDD VDD sg13_lv_pmos ad=0.19p pd=1.38u as=0 ps=0 w=1u l=1u
X684 VSS.t2057 VDD VSS.t2059 VSS.t2058 sg13_lv_nmos ad=79.8f pd=0.8u as=0 ps=0 w=0.42u l=1u
X685 a_37484_15960# sg13cmos5l_dfrbpq_1_5.Q VSS.t3 VSS.t240 sg13_lv_nmos ad=0.187p pd=1.78u as=0.14875p ps=1.16u w=0.55u l=0.13u
X686 VDD VSS.t1295 VDD VDD sg13_lv_pmos ad=0.19p pd=1.38u as=0 ps=0 w=1u l=1u
X687 VSS.t2897 VDD VSS.t2899 VSS.t2898 sg13_lv_nmos ad=79.8f pd=0.8u as=0 ps=0 w=0.42u l=1u
X688 VDD a_26170_16237# sg13cmos5l_dfrbpq_1_7.RESET_B VDD sg13_lv_pmos ad=2.8961p pd=18.25u as=0.3927p ps=2.99u w=1.155u l=0.13u
X689 VSS.t1256 VDD VSS.t1255 VSS.t1154 sg13_lv_nmos ad=0.1428p pd=1.52u as=0 ps=0 w=0.42u l=1u
X690 VSS.t1177 VDD VSS.t1177 VSS.t1154 sg13_lv_nmos ad=0.1428p pd=1.52u as=0 ps=0 w=0.42u l=1u
X691 VDD VSS.t2478 VDD VDD sg13_lv_pmos ad=0.34p pd=2.68u as=0 ps=0 w=1u l=1u
X692 VDD sg13cmos5l_tiehi_1.L_HI a_9158_15234# VDD sg13_lv_pmos ad=0.36237p pd=2.605u as=79.8f ps=0.8u w=0.42u l=0.13u
X693 sg13cmos5l_and2_1_0.X a_1965_14832# VSS.t119 VSS.t3278 sg13_lv_nmos ad=0.2516p pd=2.16u as=0.1331p ps=1.12u w=0.74u l=0.13u
X694 VDD VSS.t848 VDD VDD sg13_lv_pmos ad=0.34p pd=2.68u as=0 ps=0 w=1u l=1u
X695 VDD VSS.t2663 VDD VDD sg13_lv_pmos ad=0.19p pd=1.38u as=0 ps=0 w=1u l=1u
X696 VSS.t2314 VDD VSS.t2313 VSS.t2312 sg13_lv_nmos ad=0.1428p pd=1.52u as=0 ps=0 w=0.42u l=1u
X697 VDD VSS.t3036 VDD VDD sg13_lv_pmos ad=0.34p pd=2.68u as=0 ps=0 w=1u l=1u
X698 VDD VSS.t2253 VDD VDD sg13_lv_pmos ad=0.34p pd=2.68u as=0 ps=0 w=1u l=1u
X699 VDD VSS.t2281 VDD VDD sg13_lv_pmos ad=0.19p pd=1.38u as=0 ps=0 w=1u l=1u
X700 VSS.t2087 VDD VSS.t2086 VSS.t2085 sg13_lv_nmos ad=0.1428p pd=1.52u as=0 ps=0 w=0.42u l=1u
X701 a_27898_15202# sg13cmos5l_dfrbpq_1_5.Q VSS.t241 VSS.t11 sg13_lv_nmos ad=0.1428p pd=1.52u as=79.8f ps=0.8u w=0.42u l=0.13u
X702 VSS.t1470 VDD VSS.t1472 VSS.t1471 sg13_lv_nmos ad=79.8f pd=0.8u as=0 ps=0 w=0.42u l=1u
X703 VSS.t2379 VDD VSS.t2381 VSS.t2380 sg13_lv_nmos ad=79.8f pd=0.8u as=0 ps=0 w=0.42u l=1u
X704 VSS.t1887 VDD VSS.t1889 VSS.t1888 sg13_lv_nmos ad=79.8f pd=0.8u as=0 ps=0 w=0.42u l=1u
X705 a_26633_16334# a_26757_16033# VDD VDD sg13_lv_pmos ad=0.2442p pd=2.06u as=2.8961p ps=18.25u w=0.66u l=0.13u
X706 VDD VSS.t2443 VDD VDD sg13_lv_pmos ad=0.34p pd=2.68u as=0 ps=0 w=1u l=1u
X707 a_18863_14845# a_18021_14495# a_18769_14845# VSS.t9 sg13_lv_nmos ad=0.12665p pd=1.145u as=0.1428p ps=1.52u w=0.42u l=0.13u
X708 VSS.t954 VDD VSS.t953 VSS.t952 sg13_lv_nmos ad=0.1428p pd=1.52u as=0 ps=0 w=0.42u l=1u
X709 a_3204_15247# a_2916_15552# a_3142_15247# VSS.t218 sg13_lv_nmos ad=0.1428p pd=1.52u as=37.8f ps=0.6u w=0.42u l=0.13u
X710 VSS.t999 VDD VSS.t998 VSS.t997 sg13_lv_nmos ad=0.1428p pd=1.52u as=0 ps=0 w=0.42u l=1u
X711 VDD VSS.t1954 VDD VDD sg13_lv_pmos ad=0.19p pd=1.38u as=0 ps=0 w=1u l=1u
X712 VSS.t1265 VDD VSS.t1264 VSS.t1154 sg13_lv_nmos ad=0.1428p pd=1.52u as=0 ps=0 w=0.42u l=1u
X713 a_10960_15454# sg13cmos5l_tiehi_1.L_HI VDD VDD sg13_lv_pmos ad=79.8f pd=0.8u as=2.8961p ps=18.25u w=0.42u l=0.13u
X714 VSS.t1837 VDD VSS.t1839 VSS.t1838 sg13_lv_nmos ad=79.8f pd=0.8u as=0 ps=0 w=0.42u l=1u
X715 VSS.t2917 VDD VSS.t2919 VSS.t2918 sg13_lv_nmos ad=79.8f pd=0.8u as=0 ps=0 w=0.42u l=1u
X716 VDD VSS.t318 VDD VDD sg13_lv_pmos ad=0.34p pd=2.68u as=0 ps=0 w=1u l=1u
X717 sg13cmos5l_nand4_1_0.Y sg13cmos5l_dlygate4sd3_1_8.X a_7262_15242# VSS.t3189 sg13_lv_nmos ad=0.2516p pd=2.16u as=0.1406p ps=1.12u w=0.74u l=0.13u
X718 VSS.t1630 VDD VSS.t1629 VSS.t1628 sg13_lv_nmos ad=0.1428p pd=1.52u as=0 ps=0 w=0.42u l=1u
X719 VDD VSS.t2321 VDD VDD sg13_lv_pmos ad=0.19p pd=1.38u as=0 ps=0 w=1u l=1u
X720 VDD VSS.t605 VDD VDD sg13_lv_pmos ad=0.19p pd=1.38u as=0 ps=0 w=1u l=1u
X721 VDD VSS.t811 VDD VDD sg13_lv_pmos ad=0.19p pd=1.38u as=0 ps=0 w=1u l=1u
X722 VSS.t969 VDD VSS.t968 VSS.t967 sg13_lv_nmos ad=0.1428p pd=1.52u as=0 ps=0 w=0.42u l=1u
X723 VSS.t1301 VDD VSS.t1301 VSS.t1154 sg13_lv_nmos ad=79.8f pd=0.8u as=0 ps=0 w=0.42u l=1u
X724 VDD VSS.t1266 VDD VDD sg13_lv_pmos ad=0.34p pd=2.68u as=0 ps=0 w=1u l=1u
X725 VDD VSS.t2238 VDD VDD sg13_lv_pmos ad=0.34p pd=2.68u as=0 ps=0 w=1u l=1u
X726 VSS.t2107 VDD VSS.t2106 VSS.t2105 sg13_lv_nmos ad=0.1428p pd=1.52u as=0 ps=0 w=0.42u l=1u
X727 VSS.t1927 VDD VSS.t1929 VSS.t1928 sg13_lv_nmos ad=79.8f pd=0.8u as=0 ps=0 w=0.42u l=1u
X728 VDD VSS.t56 VDD VDD sg13_lv_pmos ad=0.19p pd=1.38u as=0 ps=0 w=1u l=1u
X729 VDD VSS.t2104 VDD VDD sg13_lv_pmos ad=0.19p pd=1.38u as=0 ps=0 w=1u l=1u
X730 VDD VSS.t2636 VDD VDD sg13_lv_pmos ad=0.19p pd=1.38u as=0 ps=0 w=1u l=1u
X731 VDD VSS.t440 VDD VDD sg13_lv_pmos ad=0.34p pd=2.68u as=0 ps=0 w=1u l=1u
X732 VSS.t3042 VDD VSS.t3041 VSS.t3040 sg13_lv_nmos ad=0.1428p pd=1.52u as=0 ps=0 w=0.42u l=1u
X733 VSS.t2259 VDD VSS.t2258 VSS.t2257 sg13_lv_nmos ad=0.1428p pd=1.52u as=0 ps=0 w=0.42u l=1u
X734 VDD VSS.t1169 VDD VDD sg13_lv_pmos ad=0.19p pd=1.38u as=0 ps=0 w=1u l=1u
X735 VDD VSS.t1018 VDD VDD sg13_lv_pmos ad=0.34p pd=2.68u as=0 ps=0 w=1u l=1u
X736 VDD VSS.t1589 VDD VDD sg13_lv_pmos ad=0.34p pd=2.68u as=0 ps=0 w=1u l=1u
X737 VDD VSS.t2742 VDD VDD sg13_lv_pmos ad=0.19p pd=1.38u as=0 ps=0 w=1u l=1u
X738 VSS.t2057 VDD VSS.t2056 VSS.t2055 sg13_lv_nmos ad=0.1428p pd=1.52u as=0 ps=0 w=0.42u l=1u
X739 VSS.t269 VDD VSS.t269 VSS.t271 sg13_lv_nmos ad=0.1428p pd=1.52u as=0 ps=0 w=0.42u l=1u
X740 VSS.t2957 VDD VSS.t2959 VSS.t2958 sg13_lv_nmos ad=79.8f pd=0.8u as=0 ps=0 w=0.42u l=1u
X741 VDD VSS.t2293 VDD VDD sg13_lv_pmos ad=0.34p pd=2.68u as=0 ps=0 w=1u l=1u
X742 VSS.t2334 VDD VSS.t2333 VSS.t2332 sg13_lv_nmos ad=0.1428p pd=1.52u as=0 ps=0 w=0.42u l=1u
X743 VSS.t2680 VDD VSS.t2681 VSS.t198 sg13_lv_nmos ad=79.8f pd=0.8u as=0 ps=0 w=0.42u l=1u
X744 VDD VSS.t401 VDD VDD sg13_lv_pmos ad=0.34p pd=2.68u as=0 ps=0 w=1u l=1u
X745 VDD VSS.t623 VDD VDD sg13_lv_pmos ad=0.34p pd=2.68u as=0 ps=0 w=1u l=1u
X746 VSS.t1660 VDD VSS.t1662 VSS.t1661 sg13_lv_nmos ad=79.8f pd=0.8u as=0 ps=0 w=0.42u l=1u
X747 VSS.t2752 VDD VSS.t2753 VSS.t198 sg13_lv_nmos ad=79.8f pd=0.8u as=0 ps=0 w=0.42u l=1u
X748 VSS.t1902 VDD VSS.t1901 VSS.t1900 sg13_lv_nmos ad=0.1428p pd=1.52u as=0 ps=0 w=0.42u l=1u
X749 VDD VSS.t778 VDD VDD sg13_lv_pmos ad=0.34p pd=2.68u as=0 ps=0 w=1u l=1u
X750 VDD VSS.t3024 VDD VDD sg13_lv_pmos ad=0.19p pd=1.38u as=0 ps=0 w=1u l=1u
X751 VDD VSS.t1899 VDD VDD sg13_lv_pmos ad=0.19p pd=1.38u as=0 ps=0 w=1u l=1u
X752 VSS.t11 a_3333_15213# a_3435_15356# VSS.t255 sg13_lv_nmos ad=4.11262p pd=27.15u as=0.2516p ps=2.16u w=0.74u l=0.13u
X753 VSS.t111 a_14261_15238# sg13cmos5l_or3_1_1.B VSS.t205 sg13_lv_nmos ad=0.1406p pd=1.12u as=0.1406p ps=1.12u w=0.74u l=0.13u
X754 VDD VSS.t180 VDD VDD sg13_lv_pmos ad=0.34p pd=2.68u as=0 ps=0 w=1u l=1u
X755 VSS.t1615 VDD VSS.t1614 VSS.t1613 sg13_lv_nmos ad=0.1428p pd=1.52u as=0 ps=0 w=0.42u l=1u
X756 VSS.t1283 VDD VSS.t1282 VSS.t1154 sg13_lv_nmos ad=0.1428p pd=1.52u as=0 ps=0 w=0.42u l=1u
X757 VSS.t1315 VDD VSS.t1316 VSS.t1154 sg13_lv_nmos ad=79.8f pd=0.8u as=0 ps=0 w=0.42u l=1u
X758 VDD VSS.t1257 VDD VDD sg13_lv_pmos ad=0.34p pd=2.68u as=0 ps=0 w=1u l=1u
X759 VDD VSS.t2753 VDD VDD sg13_lv_pmos ad=0.34p pd=2.68u as=0 ps=0 w=1u l=1u
X760 VDD VSS.t2061 VDD VDD sg13_lv_pmos ad=0.34p pd=2.68u as=0 ps=0 w=1u l=1u
X761 VSS.t132 VDD VSS.t132 VSS.t462 sg13_lv_nmos ad=0.1428p pd=1.52u as=0 ps=0 w=0.42u l=1u
X762 VSS.t1590 VDD VSS.t1592 VSS.t1591 sg13_lv_nmos ad=79.8f pd=0.8u as=0 ps=0 w=0.42u l=1u
X763 VDD VSS.t2266 VDD VDD sg13_lv_pmos ad=0.19p pd=1.38u as=0 ps=0 w=1u l=1u
X764 a_2890_15457# a_3333_15213# a_3273_15625# VDD sg13_lv_pmos ad=79.8f pd=0.8u as=63f ps=0.72u w=0.42u l=0.13u
X765 VSS.t111 VDD VSS.t21 VSS.t466 sg13_lv_nmos ad=0.1428p pd=1.52u as=0 ps=0 w=0.42u l=1u
X766 VDD VSS.t629 VDD VDD sg13_lv_pmos ad=0.19p pd=1.38u as=0 ps=0 w=1u l=1u
X767 VDD VSS.t831 VDD VDD sg13_lv_pmos ad=0.19p pd=1.38u as=0 ps=0 w=1u l=1u
X768 VSS.t1235 VDD VSS.t1236 VSS.t1154 sg13_lv_nmos ad=79.8f pd=0.8u as=0 ps=0 w=0.42u l=1u
X769 VDD VSS.t1260 VDD VDD sg13_lv_pmos ad=0.19p pd=1.38u as=0 ps=0 w=1u l=1u
X770 VSS.t1455 VDD VSS.t1457 VSS.t1456 sg13_lv_nmos ad=79.8f pd=0.8u as=0 ps=0 w=0.42u l=1u
X771 VSS.t1872 VDD VSS.t1874 VSS.t1873 sg13_lv_nmos ad=79.8f pd=0.8u as=0 ps=0 w=0.42u l=1u
X772 VSS.t999 VDD VSS.t998 VSS.t997 sg13_lv_nmos ad=0.1428p pd=1.52u as=0 ps=0 w=0.42u l=1u
X773 VDD VSS.t1554 VDD VDD sg13_lv_pmos ad=0.34p pd=2.68u as=0 ps=0 w=1u l=1u
X774 VDD VSS.t1609 VDD VDD sg13_lv_pmos ad=0.34p pd=2.68u as=0 ps=0 w=1u l=1u
X775 VSS.t1162 VDD VSS.t1162 VSS.t1154 sg13_lv_nmos ad=79.8f pd=0.8u as=0 ps=0 w=0.42u l=1u
X776 VDD VSS.t1891 VDD VDD sg13_lv_pmos ad=0.34p pd=2.68u as=0 ps=0 w=1u l=1u
X777 VDD VSS.t2715 VDD VDD sg13_lv_pmos ad=0.34p pd=2.68u as=0 ps=0 w=1u l=1u
X778 VSS.t309 VDD VSS.t308 VSS.t307 sg13_lv_nmos ad=0.1428p pd=1.52u as=0 ps=0 w=0.42u l=1u
X779 VDD VSS.t286 VDD VDD sg13_lv_pmos ad=0.19p pd=1.38u as=0 ps=0 w=1u l=1u
X780 VSS.t1426 VDD VSS.t1295 VSS.t1154 sg13_lv_nmos ad=0.1428p pd=1.52u as=0 ps=0 w=0.42u l=1u
X781 VSS.t2904 VDD VSS.t2902 VSS.t2903 sg13_lv_nmos ad=79.8f pd=0.8u as=0 ps=0 w=0.42u l=1u
X782 VSS.t632 VDD VSS.t632 VSS.t758 sg13_lv_nmos ad=0.1428p pd=1.52u as=0 ps=0 w=0.42u l=1u
X783 VDD VSS.t1904 VDD VDD sg13_lv_pmos ad=0.19p pd=1.38u as=0 ps=0 w=1u l=1u
X784 VSS.t2728 VDD VSS.t2728 VSS.t198 sg13_lv_nmos ad=0.1428p pd=1.52u as=0 ps=0 w=0.42u l=1u
X785 VDD VSS.t2483 VDD VDD sg13_lv_pmos ad=0.34p pd=2.68u as=0 ps=0 w=1u l=1u
X786 VDD VSS.t576 VDD VDD sg13_lv_pmos ad=0.34p pd=2.68u as=0 ps=0 w=1u l=1u
X787 VDD VSS.t2666 VDD VDD sg13_lv_pmos ad=0.19p pd=1.38u as=0 ps=0 w=1u l=1u
X788 VSS.t2319 VDD VSS.t2318 VSS.t2317 sg13_lv_nmos ad=0.1428p pd=1.52u as=0 ps=0 w=0.42u l=1u
X789 VSS.t689 VDD VSS.t87 VSS.t690 sg13_lv_nmos ad=79.8f pd=0.8u as=0 ps=0 w=0.42u l=1u
X790 VDD VSS.t783 VDD VDD sg13_lv_pmos ad=0.34p pd=2.68u as=0 ps=0 w=1u l=1u
X791 VSS.t1217 VDD VSS.t1216 VSS.t1154 sg13_lv_nmos ad=0.1428p pd=1.52u as=0 ps=0 w=0.42u l=1u
X792 VSS.t2092 VDD VSS.t2091 VSS.t2090 sg13_lv_nmos ad=0.1428p pd=1.52u as=0 ps=0 w=0.42u l=1u
X793 a_3333_16033# a_3333_16033# VSS.t75 VSS.t74 sg13_lv_nmos ad=0.111p pd=1.34u as=7.70437p ps=50.66u w=0.3u l=0.13u
X794 VSS.t291 VDD VSS.t291 VSS.t293 sg13_lv_nmos ad=0.1428p pd=1.52u as=0 ps=0 w=0.42u l=1u
X795 VSS.t11 a_6789_14495# a_6891_14495# VSS.t61 sg13_lv_nmos ad=4.11262p pd=27.15u as=0.2516p ps=2.16u w=0.74u l=0.13u
X796 VSS.t551 VDD VSS.t553 VSS.t552 sg13_lv_nmos ad=79.8f pd=0.8u as=0 ps=0 w=0.42u l=1u
X797 VDD VSS.t608 VDD VDD sg13_lv_pmos ad=0.34p pd=2.68u as=0 ps=0 w=1u l=1u
X798 VSS.t129 a_10222_14751# sg13cmos5l_dlygate4sd3_1_8.X VSS.t159 sg13_lv_nmos ad=0.1426p pd=1.16u as=0.2516p ps=2.16u w=0.74u l=0.13u
X799 VDD VSS.t1587 VDD VDD sg13_lv_pmos ad=0.19p pd=1.38u as=0 ps=0 w=1u l=1u
X800 VDD a_21070_15423# sg13cmos5l_dlygate4sd3_1_9.X VDD sg13_lv_pmos ad=0.2254p pd=1.53u as=0.4256p ps=3u w=1.12u l=0.13u
X801 VDD VSS.t948 VDD VDD sg13_lv_pmos ad=0.34p pd=2.68u as=0 ps=0 w=1u l=1u
X802 VSS.t1475 VDD VSS.t1477 VSS.t1476 sg13_lv_nmos ad=79.8f pd=0.8u as=0 ps=0 w=0.42u l=1u
X803 VSS.t2384 VDD VSS.t2386 VSS.t2385 sg13_lv_nmos ad=79.8f pd=0.8u as=0 ps=0 w=0.42u l=1u
X804 VDD VSS.t227 VDD VDD sg13_lv_pmos ad=0.34p pd=2.68u as=0 ps=0 w=1u l=1u
X805 VSS.t819 VDD VSS.t818 VSS.t817 sg13_lv_nmos ad=0.1428p pd=1.52u as=0 ps=0 w=0.42u l=1u
X806 VDD VSS.t1176 VDD VDD sg13_lv_pmos ad=0.19p pd=1.38u as=0 ps=0 w=1u l=1u
X807 VDD VSS.t1959 VDD VDD sg13_lv_pmos ad=0.19p pd=1.38u as=0 ps=0 w=1u l=1u
X808 VSS.t1335 VDD VSS.t1176 VSS.t1154 sg13_lv_nmos ad=79.8f pd=0.8u as=0 ps=0 w=0.42u l=1u
X809 VSS.t1605 VDD VSS.t1604 VSS.t1603 sg13_lv_nmos ad=0.1428p pd=1.52u as=0 ps=0 w=0.42u l=1u
X810 VSS.t3122 VDD VSS.t3121 VSS.t3120 sg13_lv_nmos ad=0.1428p pd=1.52u as=0 ps=0 w=0.42u l=1u
X811 VDD VSS.t2278 VDD VDD sg13_lv_pmos ad=0.34p pd=2.68u as=0 ps=0 w=1u l=1u
X812 VSS.t2672 VDD VSS.t2673 VSS.t198 sg13_lv_nmos ad=79.8f pd=0.8u as=0 ps=0 w=0.42u l=1u
X813 VSS.t576 a_19323_13726# sg13cmos5l_buf_8_2.X VSS.t3258 sg13_lv_nmos ad=0.2516p pd=2.16u as=0.1406p ps=1.12u w=0.74u l=0.13u
X814 a_9418_15457# a_9861_15213# a_9158_15234# VSS.t92 sg13_lv_nmos ad=79.8f pd=0.8u as=0.1296p ps=1.52u w=0.42u l=0.13u
X815 VSS.t1887 VDD VSS.t1886 VSS.t1885 sg13_lv_nmos ad=0.1428p pd=1.52u as=0 ps=0 w=0.42u l=1u
X816 VSS.t605 VDD VSS.t605 VSS.t606 sg13_lv_nmos ad=79.8f pd=0.8u as=0 ps=0 w=0.42u l=1u
X817 VDD VSS.t1011 VDD VDD sg13_lv_pmos ad=0.19p pd=1.38u as=0 ps=0 w=1u l=1u
X818 VSS.t1600 VDD VSS.t1599 VSS.t1598 sg13_lv_nmos ad=0.1428p pd=1.52u as=0 ps=0 w=0.42u l=1u
X819 VDD VSS.t351 VDD VDD sg13_lv_pmos ad=0.19p pd=1.38u as=0 ps=0 w=1u l=1u
X820 VSS.t556 VDD VSS.t555 VSS.t554 sg13_lv_nmos ad=0.1428p pd=1.52u as=0 ps=0 w=0.42u l=1u
X821 VDD VSS.t938 VDD VDD sg13_lv_pmos ad=0.34p pd=2.68u as=0 ps=0 w=1u l=1u
X822 VSS.t1231 VDD VSS.t1230 VSS.t1154 sg13_lv_nmos ad=0.1428p pd=1.52u as=0 ps=0 w=0.42u l=1u
X823 VSS.t1515 VDD VSS.t1517 VSS.t1516 sg13_lv_nmos ad=79.8f pd=0.8u as=0 ps=0 w=0.42u l=1u
X824 VDD VSS.t3026 VDD VDD sg13_lv_pmos ad=0.34p pd=2.68u as=0 ps=0 w=1u l=1u
X825 VDD VSS.t2243 VDD VDD sg13_lv_pmos ad=0.34p pd=2.68u as=0 ps=0 w=1u l=1u
X826 VDD a_3333_15213# a_3435_15356# VDD sg13_lv_pmos ad=2.8961p pd=18.25u as=0.3864p ps=2.93u w=1.12u l=0.13u
X827 VDD sg13cmos5l_dfrbpq_1_2.RESET_B a_16042_13945# VDD sg13_lv_pmos ad=0.1563p pd=1.22u as=0.147p ps=1.54u w=0.42u l=0.13u
X828 VSS.t2671 VDD VSS.t2672 VSS.t198 sg13_lv_nmos ad=79.8f pd=0.8u as=0 ps=0 w=0.42u l=1u
X829 VDD VSS.t2416 VDD VDD sg13_lv_pmos ad=0.19p pd=1.38u as=0 ps=0 w=1u l=1u
X830 VDD VSS.t2642 VDD VDD sg13_lv_pmos ad=0.19p pd=1.38u as=0 ps=0 w=1u l=1u
X831 VDD VSS.t16 VDD VDD sg13_lv_pmos ad=0.19p pd=1.38u as=0 ps=0 w=1u l=1u
X832 VDD VSS.t1951 VDD VDD sg13_lv_pmos ad=0.34p pd=2.68u as=0 ps=0 w=1u l=1u
X833 VSS.t704 VDD VSS.t578 VSS.t705 sg13_lv_nmos ad=79.8f pd=0.8u as=0 ps=0 w=0.42u l=1u
X834 VSS.t974 VDD VSS.t973 VSS.t972 sg13_lv_nmos ad=0.1428p pd=1.52u as=0 ps=0 w=0.42u l=1u
X835 VDD VSS.t1539 VDD VDD sg13_lv_pmos ad=0.34p pd=2.68u as=0 ps=0 w=1u l=1u
X836 VSS.t1158 VDD VSS.t1157 VSS.t1154 sg13_lv_nmos ad=0.1428p pd=1.52u as=0 ps=0 w=0.42u l=1u
X837 VSS.t1266 VDD VSS.t1268 VSS.t1154 sg13_lv_nmos ad=79.8f pd=0.8u as=0 ps=0 w=0.42u l=1u
X838 VDD VSS.t1594 VDD VDD sg13_lv_pmos ad=0.34p pd=2.68u as=0 ps=0 w=1u l=1u
X839 VSS.t426 VDD VSS.t425 VSS.t11 sg13_lv_nmos ad=0.1428p pd=1.52u as=0 ps=0 w=0.42u l=1u
X840 VSS.t2962 VDD VSS.t2964 VSS.t2963 sg13_lv_nmos ad=79.8f pd=0.8u as=0 ps=0 w=0.42u l=1u
X841 VSS.t2339 VDD VSS.t2338 VSS.t2337 sg13_lv_nmos ad=0.1428p pd=1.52u as=0 ps=0 w=0.42u l=1u
X842 VSS.t909 VDD VSS.t911 VSS.t910 sg13_lv_nmos ad=79.8f pd=0.8u as=0 ps=0 w=0.42u l=1u
X843 VSS.t2682 VDD VSS.t2684 VSS.t198 sg13_lv_nmos ad=79.8f pd=0.8u as=0 ps=0 w=0.42u l=1u
X844 a_21460_14020# sg13cmos5l_or3_1_2.A VDD VDD sg13_lv_pmos ad=0.1575p pd=1.315u as=0.3822p ps=1.84u w=1u l=0.13u
X845 VDD VSS.t978 VDD VDD sg13_lv_pmos ad=0.34p pd=2.68u as=0 ps=0 w=1u l=1u
X846 VDD VSS.t2652 VDD VDD sg13_lv_pmos ad=0.34p pd=2.68u as=0 ps=0 w=1u l=1u
X847 VSS.t698 a_19323_13726# sg13cmos5l_buf_8_2.X VSS.t3254 sg13_lv_nmos ad=0.1406p pd=1.12u as=0.1406p ps=1.12u w=0.74u l=0.13u
X848 VSS.t2755 VDD VSS.t2756 VSS.t198 sg13_lv_nmos ad=79.8f pd=0.8u as=0 ps=0 w=0.42u l=1u
X849 VSS.t252 VDD VSS.t252 VSS.t655 sg13_lv_nmos ad=79.8f pd=0.8u as=0 ps=0 w=0.42u l=1u
X850 VDD VSS.t1212 VDD VDD sg13_lv_pmos ad=0.19p pd=1.38u as=0 ps=0 w=1u l=1u
X851 VDD a_12524_15960# counter_value_o[2] VDD sg13_lv_pmos ad=0.2114p pd=1.54u as=0.42p ps=2.99u w=1.12u l=0.13u
X852 VSS.t508 VDD VSS.t508 VSS.t510 sg13_lv_nmos ad=79.8f pd=0.8u as=0 ps=0 w=0.42u l=1u
X853 VSS.t586 VDD VSS.t588 VSS.t711 sg13_lv_nmos ad=79.8f pd=0.8u as=0 ps=0 w=0.42u l=1u
X854 VDD VSS.t901 VDD VDD sg13_lv_pmos ad=0.19p pd=1.38u as=0 ps=0 w=1u l=1u
X855 VDD VSS.t1260 VDD VDD sg13_lv_pmos ad=0.34p pd=2.68u as=0 ps=0 w=1u l=1u
X856 VDD VSS.t2658 VDD VDD sg13_lv_pmos ad=0.19p pd=1.38u as=0 ps=0 w=1u l=1u
X857 VDD VSS.t2756 VDD VDD sg13_lv_pmos ad=0.34p pd=2.68u as=0 ps=0 w=1u l=1u
X858 VSS.t2304 VDD VSS.t2303 VSS.t2302 sg13_lv_nmos ad=0.1428p pd=1.52u as=0 ps=0 w=0.42u l=1u
X859 VDD VSS.t2066 VDD VDD sg13_lv_pmos ad=0.34p pd=2.68u as=0 ps=0 w=1u l=1u
X860 VSS.t1244 VDD VSS.t1243 VSS.t1154 sg13_lv_nmos ad=0.1428p pd=1.52u as=0 ps=0 w=0.42u l=1u
X861 VSS.t1917 VDD VSS.t1919 VSS.t1918 sg13_lv_nmos ad=79.8f pd=0.8u as=0 ps=0 w=0.42u l=1u
X862 VSS.t269 VDD VSS.t269 VSS.t270 sg13_lv_nmos ad=79.8f pd=0.8u as=0 ps=0 w=0.42u l=1u
X863 sg13cmos5l_o21ai_1_2.A2 sg13cmos5l_dfrbpq_1_2.Q VDD VDD sg13_lv_pmos ad=0.2128p pd=1.5u as=0.3808p ps=2.92u w=1.12u l=0.13u
X864 VDD VSS.t2635 VDD VDD sg13_lv_pmos ad=0.19p pd=1.38u as=0 ps=0 w=1u l=1u
X865 VSS.t1857 VDD VSS.t1856 VSS.t1855 sg13_lv_nmos ad=0.1428p pd=1.52u as=0 ps=0 w=0.42u l=1u
X866 VSS.t11 a_4474_14448# a_4193_14750# VSS.t91 sg13_lv_nmos ad=79.8f pd=0.8u as=0.1428p ps=1.52u w=0.42u l=0.5u
X867 a_24263_14508# sg13cmos5l_o21ai_1_2.A2 a_24169_14508# VDD sg13_lv_pmos ad=0.19p pd=1.38u as=0.34p ps=2.68u w=1u l=0.13u
X868 a_21060_14488# a_21034_14452# VDD VDD sg13_lv_pmos ad=0.34p pd=2.68u as=0.36237p ps=2.605u w=1u l=0.13u
X869 VSS.t1460 VDD VSS.t1462 VSS.t1461 sg13_lv_nmos ad=79.8f pd=0.8u as=0 ps=0 w=0.42u l=1u
X870 VSS.t819 VDD VSS.t818 VSS.t817 sg13_lv_nmos ad=0.1428p pd=1.52u as=0 ps=0 w=0.42u l=1u
X871 VSS.t1249 VDD VSS.t1248 VSS.t1154 sg13_lv_nmos ad=0.1428p pd=1.52u as=0 ps=0 w=0.42u l=1u
X872 VSS.t2643 VDD VSS.t2644 VSS.t198 sg13_lv_nmos ad=79.8f pd=0.8u as=0 ps=0 w=0.42u l=1u
X873 VSS.t2369 VDD VSS.t2371 VSS.t2370 sg13_lv_nmos ad=79.8f pd=0.8u as=0 ps=0 w=0.42u l=1u
X874 VDD VSS.t776 VDD VDD sg13_lv_pmos ad=0.19p pd=1.38u as=0 ps=0 w=1u l=1u
X875 VDD VSS.t1220 VDD VDD sg13_lv_pmos ad=0.19p pd=1.38u as=0 ps=0 w=1u l=1u
X876 VDD VSS.t2889 VDD VDD sg13_lv_pmos ad=0.19p pd=1.38u as=0 ps=0 w=1u l=1u
X877 VDD VSS.t1944 VDD VDD sg13_lv_pmos ad=0.19p pd=1.38u as=0 ps=0 w=1u l=1u
X878 VSS.t21 sg13cmos5l_or3_1_2.B a_16175_15238# VSS.t3290 sg13_lv_nmos ad=0.1898p pd=1.36u as=0.1406p ps=1.12u w=0.74u l=0.13u
X879 VSS.t573 VDD VSS.t573 VSS.t574 sg13_lv_nmos ad=79.8f pd=0.8u as=0 ps=0 w=0.42u l=1u
X880 VDD VSS.t1896 VDD VDD sg13_lv_pmos ad=0.34p pd=2.68u as=0 ps=0 w=1u l=1u
X881 VDD VSS.t2719 VDD VDD sg13_lv_pmos ad=0.34p pd=2.68u as=0 ps=0 w=1u l=1u
X882 VSS.t2766 VDD VSS.t2765 VSS.t198 sg13_lv_nmos ad=0.1428p pd=1.52u as=0 ps=0 w=0.42u l=1u
X883 VDD VSS.t2644 VDD VDD sg13_lv_pmos ad=0.34p pd=2.68u as=0 ps=0 w=1u l=1u
X884 VSS.t30 VDD VSS.t35 VSS.t461 sg13_lv_nmos ad=79.8f pd=0.8u as=0 ps=0 w=0.42u l=1u
X885 sg13cmos5l_buf_1_10.X a_1192_9948# VSS.t1155 VSS.t1154 sg13_lv_nmos ad=0.2886p pd=2.26u as=0.14875p ps=1.16u w=0.74u l=0.13u
X886 VDD VSS.t1183 VDD VDD sg13_lv_pmos ad=0.34p pd=2.68u as=0 ps=0 w=1u l=1u
X887 VSS.t2907 VDD VSS.t2909 VSS.t2908 sg13_lv_nmos ad=79.8f pd=0.8u as=0 ps=0 w=0.42u l=1u
X888 sg13cmos5l_dfrbpq_1_5.Q a_28074_14020# VSS.t180 VSS.t179 sg13_lv_nmos ad=0.2516p pd=2.16u as=0.1406p ps=1.12u w=0.74u l=0.13u
X889 VDD VSS.t868 VDD VDD sg13_lv_pmos ad=0.34p pd=2.68u as=0 ps=0 w=1u l=1u
X890 VSS.t1188 VDD VSS.t1188 VSS.t1154 sg13_lv_nmos ad=0.1428p pd=1.52u as=0 ps=0 w=0.42u l=1u
X891 VDD VSS.t2453 VDD VDD sg13_lv_pmos ad=0.34p pd=2.68u as=0 ps=0 w=1u l=1u
X892 sg13cmos5l_or3_1_2.B a_16168_15996# VDD VDD sg13_lv_pmos ad=0.42p pd=2.99u as=0.2114p ps=1.54u w=1.12u l=0.13u
X893 VDD VSS.t983 VDD VDD sg13_lv_pmos ad=0.34p pd=2.68u as=0 ps=0 w=1u l=1u
X894 VDD VSS.t2668 VDD VDD sg13_lv_pmos ad=0.19p pd=1.38u as=0 ps=0 w=1u l=1u
X895 VSS.t2691 VDD VSS.t2691 VSS.t198 sg13_lv_nmos ad=0.1428p pd=1.52u as=0 ps=0 w=0.42u l=1u
X896 VSS.t2324 VDD VSS.t2323 VSS.t2322 sg13_lv_nmos ad=0.1428p pd=1.52u as=0 ps=0 w=0.42u l=1u
X897 VDD VSS.t2228 VDD VDD sg13_lv_pmos ad=0.34p pd=2.68u as=0 ps=0 w=1u l=1u
X898 VSS.t1680 VDD VSS.t1679 VSS.t1678 sg13_lv_nmos ad=0.1428p pd=1.52u as=0 ps=0 w=0.42u l=1u
X899 VSS.t2062 VDD VSS.t2061 VSS.t2060 sg13_lv_nmos ad=0.1428p pd=1.52u as=0 ps=0 w=0.42u l=1u
X900 VDD a_7680_15549# sg13cmos5l_xnor2_1_0.Y VDD sg13_lv_pmos ad=0.3808p pd=2.92u as=0.2408p ps=1.55u w=1.12u l=0.13u
X901 VDD VSS.t1582 VDD VDD sg13_lv_pmos ad=0.19p pd=1.38u as=0 ps=0 w=1u l=1u
X902 VSS.t2764 VDD VSS.t2763 VSS.t198 sg13_lv_nmos ad=0.1428p pd=1.52u as=0 ps=0 w=0.42u l=1u
X903 VSS.t2663 VDD VSS.t2664 VSS.t198 sg13_lv_nmos ad=79.8f pd=0.8u as=0 ps=0 w=0.42u l=1u
X904 VDD VSS.t1592 VDD VDD sg13_lv_pmos ad=0.19p pd=1.38u as=0 ps=0 w=1u l=1u
X905 VSS.t75 a_3209_16334# a_3130_16237# VSS.t3187 sg13_lv_nmos ad=7.70437p pd=50.66u as=0.27427p ps=2.28u w=0.795u l=0.13u
X906 VSS.t974 VDD VSS.t973 VSS.t972 sg13_lv_nmos ad=0.1428p pd=1.52u as=0 ps=0 w=0.42u l=1u
X907 VSS.t1019 VDD VSS.t1018 VSS.t1017 sg13_lv_nmos ad=0.1428p pd=1.52u as=0 ps=0 w=0.42u l=1u
X908 VSS.t909 VDD VSS.t911 VSS.t910 sg13_lv_nmos ad=79.8f pd=0.8u as=0 ps=0 w=0.42u l=1u
X909 VDD VSS.t1201 VDD VDD sg13_lv_pmos ad=0.34p pd=2.68u as=0 ps=0 w=1u l=1u
X910 VSS.t1423 VDD VSS.t1295 VSS.t1154 sg13_lv_nmos ad=79.8f pd=0.8u as=0 ps=0 w=0.42u l=1u
X911 VDD VSS.t1179 VDD VDD sg13_lv_pmos ad=0.19p pd=1.38u as=0 ps=0 w=1u l=1u
X912 VDD VSS.t2737 VDD VDD sg13_lv_pmos ad=0.19p pd=1.38u as=0 ps=0 w=1u l=1u
X913 VDD VSS.t1964 VDD VDD sg13_lv_pmos ad=0.19p pd=1.38u as=0 ps=0 w=1u l=1u
X914 VSS.t1610 VDD VSS.t1609 VSS.t1608 sg13_lv_nmos ad=0.1428p pd=1.52u as=0 ps=0 w=0.42u l=1u
X915 VSS.t3127 VDD VSS.t3126 VSS.t3125 sg13_lv_nmos ad=0.1428p pd=1.52u as=0 ps=0 w=0.42u l=1u
X916 VDD VSS.t2283 VDD VDD sg13_lv_pmos ad=0.34p pd=2.68u as=0 ps=0 w=1u l=1u
X917 a_27215_14845# a_26373_14495# a_27121_14845# VSS.t11 sg13_lv_nmos ad=0.12665p pd=1.145u as=0.1428p ps=1.52u w=0.42u l=0.13u
X918 VSS.t2675 VDD VSS.t2676 VSS.t198 sg13_lv_nmos ad=79.8f pd=0.8u as=0 ps=0 w=0.42u l=1u
X919 VDD VSS.t1023 VDD VDD sg13_lv_pmos ad=0.34p pd=2.68u as=0 ps=0 w=1u l=1u
X920 VSS.t1892 VDD VSS.t1891 VSS.t1890 sg13_lv_nmos ad=0.1428p pd=1.52u as=0 ps=0 w=0.42u l=1u
X921 VDD VSS.t608 VDD VDD sg13_lv_pmos ad=0.19p pd=1.38u as=0 ps=0 w=1u l=1u
X922 VSS.t2892 VDD VSS.t2894 VSS.t2893 sg13_lv_nmos ad=79.8f pd=0.8u as=0 ps=0 w=0.42u l=1u
X923 VSS.t2746 VDD VSS.t2747 VSS.t198 sg13_lv_nmos ad=79.8f pd=0.8u as=0 ps=0 w=0.42u l=1u
X924 VDD VSS.t1239 VDD VDD sg13_lv_pmos ad=0.19p pd=1.38u as=0 ps=0 w=1u l=1u
X925 VSS.t1313 VDD VSS.t1314 VSS.t1154 sg13_lv_nmos ad=79.8f pd=0.8u as=0 ps=0 w=0.42u l=1u
X926 VDD VSS.t2296 VDD VDD sg13_lv_pmos ad=0.19p pd=1.38u as=0 ps=0 w=1u l=1u
X927 VSS.t333 VDD VSS.t332 VSS.t331 sg13_lv_nmos ad=0.1428p pd=1.52u as=0 ps=0 w=0.42u l=1u
X928 VDD VSS.t946 VDD VDD sg13_lv_pmos ad=0.19p pd=1.38u as=0 ps=0 w=1u l=1u
X929 VDD sg13cmos5l_dfrbpq_1_2.Q a_16552_15996# VDD sg13_lv_pmos ad=0.2114p pd=1.54u as=0.2856p ps=2.36u w=0.84u l=0.13u
X930 VDD VSS.t1251 VDD VDD sg13_lv_pmos ad=0.34p pd=2.68u as=0 ps=0 w=1u l=1u
X931 VSS.t1520 VDD VSS.t1522 VSS.t1521 sg13_lv_nmos ad=79.8f pd=0.8u as=0 ps=0 w=0.42u l=1u
X932 VDD VSS.t2747 VDD VDD sg13_lv_pmos ad=0.34p pd=2.68u as=0 ps=0 w=1u l=1u
X933 VSS.t2673 VDD VSS.t2674 VSS.t198 sg13_lv_nmos ad=79.8f pd=0.8u as=0 ps=0 w=0.42u l=1u
X934 VDD VSS.t2421 VDD VDD sg13_lv_pmos ad=0.19p pd=1.38u as=0 ps=0 w=1u l=1u
X935 VSS.t2082 VDD VSS.t2081 VSS.t2080 sg13_lv_nmos ad=0.1428p pd=1.52u as=0 ps=0 w=0.42u l=1u
X936 VSS.t1902 VDD VSS.t1904 VSS.t1903 sg13_lv_nmos ad=79.8f pd=0.8u as=0 ps=0 w=0.42u l=1u
X937 VSS.t829 VDD VSS.t831 VSS.t830 sg13_lv_nmos ad=79.8f pd=0.8u as=0 ps=0 w=0.42u l=1u
X938 VDD VSS.t2627 VDD VDD sg13_lv_pmos ad=0.19p pd=1.38u as=0 ps=0 w=1u l=1u
X939 VSS.t1842 VDD VSS.t1841 VSS.t1840 sg13_lv_nmos ad=0.1428p pd=1.52u as=0 ps=0 w=0.42u l=1u
X940 a_21417_14531# a_21060_14488# VDD VDD sg13_lv_pmos ad=63f pd=0.72u as=0.1563p ps=1.22u w=0.42u l=0.13u
X941 VSS.t1318 VDD VSS.t1319 VSS.t1154 sg13_lv_nmos ad=79.8f pd=0.8u as=0 ps=0 w=0.42u l=1u
X942 VSS.t2922 VDD VSS.t2921 VSS.t2920 sg13_lv_nmos ad=0.1428p pd=1.52u as=0 ps=0 w=0.42u l=1u
X943 VDD VSS.t1308 VDD VDD sg13_lv_pmos ad=0.34p pd=2.68u as=0 ps=0 w=1u l=1u
X944 VDD VSS.t1038 VDD VDD sg13_lv_pmos ad=0.34p pd=2.68u as=0 ps=0 w=1u l=1u
X945 VDD VSS.t2674 VDD VDD sg13_lv_pmos ad=0.34p pd=2.68u as=0 ps=0 w=1u l=1u
X946 VDD VSS.t1921 VDD VDD sg13_lv_pmos ad=0.34p pd=2.68u as=0 ps=0 w=1u l=1u
X947 a_3204_15247# a_3435_15356# a_2890_15457# VSS.t104 sg13_lv_nmos ad=0.2373p pd=1.97u as=79.8f ps=0.8u w=0.42u l=0.13u
X948 VDD VSS.t2106 VDD VDD sg13_lv_pmos ad=0.34p pd=2.68u as=0 ps=0 w=1u l=1u
X949 a_3142_15247# sg13cmos5l_dfrbpq_1_0.RESET_B VSS.t187 VSS.t3231 sg13_lv_nmos ad=37.8f pd=0.6u as=0.1701p ps=1.65u w=0.42u l=0.13u
X950 VSS.t551 VDD VSS.t553 VSS.t552 sg13_lv_nmos ad=79.8f pd=0.8u as=0 ps=0 w=0.42u l=1u
X951 VDD VSS.t1604 VDD VDD sg13_lv_pmos ad=0.34p pd=2.68u as=0 ps=0 w=1u l=1u
X952 VDD VSS.t1881 VDD VDD sg13_lv_pmos ad=0.34p pd=2.68u as=0 ps=0 w=1u l=1u
X953 VDD VSS.t2709 VDD VDD sg13_lv_pmos ad=0.34p pd=2.68u as=0 ps=0 w=1u l=1u
X954 VSS.t252 a_8218_13690# a_7937_13912# VSS.t251 sg13_lv_nmos ad=79.8f pd=0.8u as=0.1428p ps=1.52u w=0.42u l=0.5u
X955 VSS.t2738 VDD VSS.t2739 VSS.t198 sg13_lv_nmos ad=79.8f pd=0.8u as=0 ps=0 w=0.42u l=1u
X956 VDD VSS.t913 VDD VDD sg13_lv_pmos ad=0.34p pd=2.68u as=0 ps=0 w=1u l=1u
X957 VSS.t21 clock_i a_15579_14854# VSS.t3237 sg13_lv_nmos ad=0.1406p pd=1.12u as=0.2553p ps=2.17u w=0.74u l=0.13u
X958 VSS.t2682 VDD VSS.t2682 VSS.t198 sg13_lv_nmos ad=0.1428p pd=1.52u as=0 ps=0 w=0.42u l=1u
X959 VSS.t2309 VDD VSS.t2308 VSS.t2307 sg13_lv_nmos ad=0.1428p pd=1.52u as=0 ps=0 w=0.42u l=1u
X960 VDD VSS.t286 VDD VDD sg13_lv_pmos ad=0.19p pd=1.38u as=0 ps=0 w=1u l=1u
X961 VDD sg13cmos5l_dfrbpq_1_1.RESET_B a_6346_14452# VDD sg13_lv_pmos ad=0.1563p pd=1.22u as=0.147p ps=1.54u w=0.42u l=0.13u
X962 VDD VSS.t520 VDD VDD sg13_lv_pmos ad=0.34p pd=2.68u as=0 ps=0 w=1u l=1u
X963 VSS.t2755 VDD VSS.t2754 VSS.t198 sg13_lv_nmos ad=0.1428p pd=1.52u as=0 ps=0 w=0.42u l=1u
X964 VSS.t2032 VDD VSS.t2034 VSS.t2033 sg13_lv_nmos ad=79.8f pd=0.8u as=0 ps=0 w=0.42u l=1u
X965 VSS.t1019 VDD VSS.t1018 VSS.t1017 sg13_lv_nmos ad=0.1428p pd=1.52u as=0 ps=0 w=0.42u l=1u
X966 VSS.t1465 VDD VSS.t1467 VSS.t1466 sg13_lv_nmos ad=79.8f pd=0.8u as=0 ps=0 w=0.42u l=1u
X967 VDD VSS.t2343 VDD VDD sg13_lv_pmos ad=0.34p pd=2.68u as=0 ps=0 w=1u l=1u
X968 VSS.t2646 VDD VSS.t2647 VSS.t198 sg13_lv_nmos ad=79.8f pd=0.8u as=0 ps=0 w=0.42u l=1u
X969 VSS.t2374 VDD VSS.t2376 VSS.t2375 sg13_lv_nmos ad=79.8f pd=0.8u as=0 ps=0 w=0.42u l=1u
X970 VSS.t402 VDD VSS.t401 VSS.t11 sg13_lv_nmos ad=0.1428p pd=1.52u as=0 ps=0 w=0.42u l=1u
X971 a_6575_13342# a_6540_13238# sg13cmos5l_dlygate4sd3_1_0.A VSS.t165 sg13_lv_nmos ad=0.1406p pd=1.12u as=0.2516p ps=2.16u w=0.74u l=0.13u
X972 VDD VSS.t1584 VDD VDD sg13_lv_pmos ad=0.34p pd=2.68u as=0 ps=0 w=1u l=1u
X973 VSS.t1952 VDD VSS.t1951 VSS.t1950 sg13_lv_nmos ad=0.1428p pd=1.52u as=0 ps=0 w=0.42u l=1u
X974 VDD VSS.t1171 VDD VDD sg13_lv_pmos ad=0.19p pd=1.38u as=0 ps=0 w=1u l=1u
X975 VDD VSS.t1949 VDD VDD sg13_lv_pmos ad=0.19p pd=1.38u as=0 ps=0 w=1u l=1u
X976 VSS.t1210 VDD VSS.t1361 VSS.t1154 sg13_lv_nmos ad=0.1428p pd=1.52u as=0 ps=0 w=0.42u l=1u
X977 VSS.t1595 VDD VSS.t1594 VSS.t1593 sg13_lv_nmos ad=0.1428p pd=1.52u as=0 ps=0 w=0.42u l=1u
X978 sg13cmos5l_o21ai_1_1.Y sg13cmos5l_or3_1_2.C a_20376_14464# VDD sg13_lv_pmos ad=0.2128p pd=1.5u as=0.2128p ps=1.5u w=1.12u l=0.15u
X979 VDD VSS.t1866 VDD VDD sg13_lv_pmos ad=0.34p pd=2.68u as=0 ps=0 w=1u l=1u
X980 VDD VSS.t1303 VDD VDD sg13_lv_pmos ad=0.34p pd=2.68u as=0 ps=0 w=1u l=1u
X981 VDD VSS.t2647 VDD VDD sg13_lv_pmos ad=0.34p pd=2.68u as=0 ps=0 w=1u l=1u
X982 VDD VSS.t2701 VDD VDD sg13_lv_pmos ad=0.34p pd=2.68u as=0 ps=0 w=1u l=1u
X983 a_12524_15960# sg13cmos5l_dlygate4sd3_1_8.A VSS.t150 VSS.t149 sg13_lv_nmos ad=0.187p pd=1.78u as=0.14875p ps=1.16u w=0.55u l=0.13u
X984 VDD VSS.t1283 VDD VDD sg13_lv_pmos ad=0.19p pd=1.38u as=0 ps=0 w=1u l=1u
X985 VDD VSS.t2657 VDD VDD sg13_lv_pmos ad=0.19p pd=1.38u as=0 ps=0 w=1u l=1u
X986 VSS.t939 VDD VSS.t938 VSS.t937 sg13_lv_nmos ad=0.1428p pd=1.52u as=0 ps=0 w=0.42u l=1u
X987 VDD VSS.t2458 VDD VDD sg13_lv_pmos ad=0.34p pd=2.68u as=0 ps=0 w=1u l=1u
X988 VSS.t829 VDD VSS.t831 VSS.t830 sg13_lv_nmos ad=79.8f pd=0.8u as=0 ps=0 w=0.42u l=1u
X989 VSS.t1229 VDD VSS.t1228 VSS.t1154 sg13_lv_nmos ad=0.1428p pd=1.52u as=0 ps=0 w=0.42u l=1u
X990 sg13cmos5l_or3_1_1.C sg13cmos5l_dfrbpq_1_2.Q VDD VDD sg13_lv_pmos ad=0.2128p pd=1.5u as=0.3808p ps=2.92u w=1.12u l=0.13u
X991 a_24408_15552# sg13cmos5l_or3_1_2.B VDD VDD sg13_lv_pmos ad=0.2128p pd=1.5u as=0.3808p ps=2.92u w=1.12u l=0.15u
X992 VDD VSS.t620 VDD VDD sg13_lv_pmos ad=0.34p pd=2.68u as=0 ps=0 w=1u l=1u
X993 VSS.t1685 VDD VSS.t1684 VSS.t1683 sg13_lv_nmos ad=0.1428p pd=1.52u as=0 ps=0 w=0.42u l=1u
X994 VSS.t2666 VDD VSS.t2667 VSS.t198 sg13_lv_nmos ad=79.8f pd=0.8u as=0 ps=0 w=0.42u l=1u
X995 VSS.t2067 VDD VSS.t2066 VSS.t2065 sg13_lv_nmos ad=0.1428p pd=1.52u as=0 ps=0 w=0.42u l=1u
X996 VSS.t11 a_27502_15423# sg13cmos5l_or3_1_1.A VSS.t11 sg13_lv_nmos ad=0.1426p pd=1.16u as=0.2516p ps=2.16u w=0.74u l=0.13u
X997 VSS.t2767 VDD VSS.t2766 VSS.t198 sg13_lv_nmos ad=0.1428p pd=1.52u as=0 ps=0 w=0.42u l=1u
X998 VSS.t3 VDD VSS.t3 VSS.t381 sg13_lv_nmos ad=79.8f pd=0.8u as=0 ps=0 w=0.42u l=1u
X999 a_7058_15242# sg13cmos5l_xor2_1_0.B VSS.t184 VSS.t183 sg13_lv_nmos ad=0.1406p pd=1.12u as=0.2516p ps=2.16u w=0.74u l=0.13u
X1000 VSS.t1450 VDD VSS.t1452 VSS.t1451 sg13_lv_nmos ad=79.8f pd=0.8u as=0 ps=0 w=0.42u l=1u
X1001 VDD VSS.t2501 VDD VDD sg13_lv_pmos ad=0.19p pd=1.38u as=0 ps=0 w=1u l=1u
X1002 VDD VSS.t366 VDD VDD sg13_lv_pmos ad=0.34p pd=2.68u as=0 ps=0 w=1u l=1u
X1003 VSS.t508 VDD VSS.t508 VSS.t510 sg13_lv_nmos ad=79.8f pd=0.8u as=0 ps=0 w=0.42u l=1u
X1004 VSS.t1156 VDD VSS.t1155 VSS.t1154 sg13_lv_nmos ad=0.1428p pd=1.52u as=0 ps=0 w=0.42u l=1u
X1005 VDD VSS.t1906 VDD VDD sg13_lv_pmos ad=0.34p pd=2.68u as=0 ps=0 w=1u l=1u
X1006 VDD VSS.t2667 VDD VDD sg13_lv_pmos ad=0.34p pd=2.68u as=0 ps=0 w=1u l=1u
X1007 VDD VSS.t440 VDD VDD sg13_lv_pmos ad=0.34p pd=2.68u as=0 ps=0 w=1u l=1u
X1008 a_25862_13722# sg13cmos5l_dfrbpq_1_5.D VDD VDD sg13_lv_pmos ad=79.8f pd=0.8u as=0.1428p ps=1.52u w=0.42u l=0.13u
X1009 VSS.t1265 VDD VSS.t1266 VSS.t1154 sg13_lv_nmos ad=79.8f pd=0.8u as=0 ps=0 w=0.42u l=1u
X1010 VSS.t1185 VDD VSS.t1187 VSS.t1154 sg13_lv_nmos ad=79.8f pd=0.8u as=0 ps=0 w=0.42u l=1u
X1011 VDD VSS.t1934 VDD VDD sg13_lv_pmos ad=0.19p pd=1.38u as=0 ps=0 w=1u l=1u
X1012 a_7822_13911# a_7937_13912# VDD VDD sg13_lv_pmos ad=0.34p pd=2.68u as=0.2254p ps=1.53u w=1u l=0.5u
X1013 VDD VSS.t1162 VDD VDD sg13_lv_pmos ad=0.19p pd=1.38u as=0 ps=0 w=1u l=1u
X1014 VDD VSS.t2288 VDD VDD sg13_lv_pmos ad=0.34p pd=2.68u as=0 ps=0 w=1u l=1u
X1015 a_6286_13911# a_6401_13912# VDD VDD sg13_lv_pmos ad=0.34p pd=2.68u as=0.2254p ps=1.53u w=1u l=0.5u
X1016 VSS.t617 VDD VSS.t617 VSS.t618 sg13_lv_nmos ad=79.8f pd=0.8u as=0 ps=0 w=0.42u l=1u
X1017 VDD VSS.t1031 VDD VDD sg13_lv_pmos ad=0.19p pd=1.38u as=0 ps=0 w=1u l=1u
X1018 VDD VSS.t1589 VDD VDD sg13_lv_pmos ad=0.34p pd=2.68u as=0 ps=0 w=1u l=1u
X1019 a_26249_16334# a_26373_16033# VDD VDD sg13_lv_pmos ad=0.2442p pd=2.06u as=2.8961p ps=18.25u w=0.66u l=0.13u
X1020 VSS.t1480 VDD VSS.t1479 VSS.t1478 sg13_lv_nmos ad=0.1428p pd=1.52u as=0 ps=0 w=0.42u l=1u
X1021 VSS.t1897 VDD VSS.t1896 VSS.t1895 sg13_lv_nmos ad=0.1428p pd=1.52u as=0 ps=0 w=0.42u l=1u
X1022 VSS.t370 VDD VSS.t370 VSS.t371 sg13_lv_nmos ad=79.8f pd=0.8u as=0 ps=0 w=0.42u l=1u
X1023 VSS.t429 VDD VSS.t430 VSS.t11 sg13_lv_nmos ad=79.8f pd=0.8u as=0 ps=0 w=0.42u l=1u
X1024 VDD VSS.t3019 VDD VDD sg13_lv_pmos ad=0.19p pd=1.38u as=0 ps=0 w=1u l=1u
X1025 VSS.t2653 VDD VSS.t2653 VSS.t198 sg13_lv_nmos ad=0.1428p pd=1.52u as=0 ps=0 w=0.42u l=1u
X1026 VSS.t2389 VDD VSS.t2388 VSS.t2387 sg13_lv_nmos ad=0.1428p pd=1.52u as=0 ps=0 w=0.42u l=1u
X1027 a_12010_15202# sg13cmos5l_buf_8_2.A VSS.t132 VSS.t133 sg13_lv_nmos ad=0.2553p pd=2.17u as=0.1406p ps=1.12u w=0.74u l=0.13u
X1028 VSS.t680 VDD VSS.t49 VSS.t679 sg13_lv_nmos ad=0.1428p pd=1.52u as=0 ps=0 w=0.42u l=1u
X1029 VSS.t2713 VDD VSS.t2714 VSS.t198 sg13_lv_nmos ad=79.8f pd=0.8u as=0 ps=0 w=0.42u l=1u
X1030 VDD a_14261_15238# sg13cmos5l_or3_1_1.B VDD sg13_lv_pmos ad=0.2128p pd=1.5u as=0.2128p ps=1.5u w=1.12u l=0.13u
X1031 VDD VSS.t958 VDD VDD sg13_lv_pmos ad=0.34p pd=2.68u as=0 ps=0 w=1u l=1u
X1032 VSS.t283 VDD VSS.t283 VSS.t284 sg13_lv_nmos ad=79.8f pd=0.8u as=0 ps=0 w=0.42u l=1u
X1033 VSS.t541 VDD VSS.t540 VSS.t539 sg13_lv_nmos ad=0.1428p pd=1.52u as=0 ps=0 w=0.42u l=1u
X1034 VDD VSS.t1447 VDD VDD sg13_lv_pmos ad=0.19p pd=1.38u as=0 ps=0 w=1u l=1u
X1035 VDD VSS.t269 VDD VDD sg13_lv_pmos ad=0.34p pd=2.68u as=0 ps=0 w=1u l=1u
X1036 a_9737_14822# a_9861_14521# VDD VDD sg13_lv_pmos ad=0.2442p pd=2.06u as=2.42015p ps=15.68u w=0.66u l=0.13u
X1037 a_17604_14488# a_17578_14452# VDD VDD sg13_lv_pmos ad=0.34p pd=2.68u as=0.36237p ps=2.605u w=1u l=0.13u
X1038 VDD VSS.t520 VDD VDD sg13_lv_pmos ad=0.34p pd=2.68u as=0 ps=0 w=1u l=1u
X1039 VDD VSS.t2630 VDD VDD sg13_lv_pmos ad=0.19p pd=1.38u as=0 ps=0 w=1u l=1u
X1040 sg13cmos5l_dfrbpq_1_3.D a_17238_15302# VDD VDD sg13_lv_pmos ad=0.4256p pd=3u as=0.2254p ps=1.53u w=1.12u l=0.13u
X1041 VDD a_27472_14726# a_27417_14607# VDD sg13_lv_pmos ad=2.42015p pd=15.68u as=93.45f ps=0.865u w=0.42u l=0.13u
X1042 a_19323_13726# sg13cmos5l_buf_8_2.A VSS.t135 VSS.t136 sg13_lv_nmos ad=0.1406p pd=1.12u as=0.1406p ps=1.12u w=0.74u l=0.13u
X1043 VSS.t2927 VDD VSS.t2926 VSS.t2925 sg13_lv_nmos ad=0.1428p pd=1.52u as=0 ps=0 w=0.42u l=1u
X1044 VSS.t713 VDD VSS.t590 VSS.t714 sg13_lv_nmos ad=79.8f pd=0.8u as=0 ps=0 w=0.42u l=1u
X1045 VDD VSS.t1290 VDD VDD sg13_lv_pmos ad=0.34p pd=2.68u as=0 ps=0 w=1u l=1u
X1046 VSS.t1580 VDD VSS.t1582 VSS.t1581 sg13_lv_nmos ad=79.8f pd=0.8u as=0 ps=0 w=0.42u l=1u
X1047 VSS.t3097 VDD VSS.t3099 VSS.t3098 sg13_lv_nmos ad=79.8f pd=0.8u as=0 ps=0 w=0.42u l=1u
X1048 VSS.t1247 VDD VSS.t1246 VSS.t1154 sg13_lv_nmos ad=0.1428p pd=1.52u as=0 ps=0 w=0.42u l=1u
X1049 VSS.t1169 VDD VSS.t1169 VSS.t1154 sg13_lv_nmos ad=0.1428p pd=1.52u as=0 ps=0 w=0.42u l=1u
X1050 VSS.t1972 VDD VSS.t1971 VSS.t1970 sg13_lv_nmos ad=0.1428p pd=1.52u as=0 ps=0 w=0.42u l=1u
X1051 VDD VSS.t833 VDD VDD sg13_lv_pmos ad=0.34p pd=2.68u as=0 ps=0 w=1u l=1u
X1052 VSS.t1279 VDD VSS.t1280 VSS.t1154 sg13_lv_nmos ad=79.8f pd=0.8u as=0 ps=0 w=0.42u l=1u
X1053 VSS.t2638 VDD VSS.t2639 VSS.t198 sg13_lv_nmos ad=79.8f pd=0.8u as=0 ps=0 w=0.42u l=1u
X1054 VDD VSS.t1926 VDD VDD sg13_lv_pmos ad=0.34p pd=2.68u as=0 ps=0 w=1u l=1u
X1055 VDD VSS.t2111 VDD VDD sg13_lv_pmos ad=0.34p pd=2.68u as=0 ps=0 w=1u l=1u
X1056 VSS.t2504 VDD VSS.t2506 VSS.t2505 sg13_lv_nmos ad=79.8f pd=0.8u as=0 ps=0 w=0.42u l=1u
X1057 VDD VSS.t1609 VDD VDD sg13_lv_pmos ad=0.34p pd=2.68u as=0 ps=0 w=1u l=1u
X1058 VDD VSS.t2639 VDD VDD sg13_lv_pmos ad=0.34p pd=2.68u as=0 ps=0 w=1u l=1u
X1059 sg13cmos5l_buf_8_2.A a_15579_14854# VDD VDD sg13_lv_pmos ad=0.2128p pd=1.5u as=0.2128p ps=1.5u w=1.12u l=0.13u
X1060 VSS.t728 VDD VSS.t180 VSS.t729 sg13_lv_nmos ad=79.8f pd=0.8u as=0 ps=0 w=0.42u l=1u
X1061 VSS.t1882 VDD VSS.t1881 VSS.t1880 sg13_lv_nmos ad=0.1428p pd=1.52u as=0 ps=0 w=0.42u l=1u
X1062 VSS.t939 VDD VSS.t938 VSS.t937 sg13_lv_nmos ad=0.1428p pd=1.52u as=0 ps=0 w=0.42u l=1u
X1063 counter_value_o[3] a_16552_15996# VSS.t83 VSS.t3166 sg13_lv_nmos ad=0.2886p pd=2.26u as=0.14875p ps=1.16u w=0.74u l=0.13u
X1064 a_26757_16033# a_26757_16033# VSS.t75 VSS.t3286 sg13_lv_nmos ad=0.111p pd=1.34u as=7.70437p ps=50.66u w=0.3u l=0.13u
X1065 VDD VSS.t2745 VDD VDD sg13_lv_pmos ad=0.34p pd=2.68u as=0 ps=0 w=1u l=1u
X1066 VSS.t2685 VDD VSS.t2685 VSS.t198 sg13_lv_nmos ad=0.1428p pd=1.52u as=0 ps=0 w=0.42u l=1u
X1067 VDD VSS.t576 VDD VDD sg13_lv_pmos ad=0.19p pd=1.38u as=0 ps=0 w=1u l=1u
X1068 VSS.t98 VDD VSS.t98 VSS.t517 sg13_lv_nmos ad=0.1428p pd=1.52u as=0 ps=0 w=0.42u l=1u
X1069 VSS.t698 VDD VSS.t698 VSS.t697 sg13_lv_nmos ad=0.1428p pd=1.52u as=0 ps=0 w=0.42u l=1u
X1070 VSS.t2758 VDD VSS.t2757 VSS.t198 sg13_lv_nmos ad=0.1428p pd=1.52u as=0 ps=0 w=0.42u l=1u
X1071 VSS.t2037 VDD VSS.t2039 VSS.t2038 sg13_lv_nmos ad=79.8f pd=0.8u as=0 ps=0 w=0.42u l=1u
X1072 VDD VSS.t303 VDD VDD sg13_lv_pmos ad=0.34p pd=2.68u as=0 ps=0 w=1u l=1u
X1073 VDD VSS.t988 VDD VDD sg13_lv_pmos ad=0.34p pd=2.68u as=0 ps=0 w=1u l=1u
X1074 VSS.t1396 VDD VSS.t1260 VSS.t1154 sg13_lv_nmos ad=0.1428p pd=1.52u as=0 ps=0 w=0.42u l=1u
X1075 VDD VSS.t1196 VDD VDD sg13_lv_pmos ad=0.19p pd=1.38u as=0 ps=0 w=1u l=1u
X1076 VDD VSS.t2696 VDD VDD sg13_lv_pmos ad=0.19p pd=1.38u as=0 ps=0 w=1u l=1u
X1077 VSS.t2374 VDD VSS.t2373 VSS.t2372 sg13_lv_nmos ad=0.1428p pd=1.52u as=0 ps=0 w=0.42u l=1u
X1078 VDD VSS.t796 VDD VDD sg13_lv_pmos ad=0.19p pd=1.38u as=0 ps=0 w=1u l=1u
X1079 VDD VSS.t2313 VDD VDD sg13_lv_pmos ad=0.34p pd=2.68u as=0 ps=0 w=1u l=1u
X1080 VDD VSS.t2486 VDD VDD sg13_lv_pmos ad=0.19p pd=1.38u as=0 ps=0 w=1u l=1u
X1081 VDD VSS.t605 VDD VDD sg13_lv_pmos ad=0.34p pd=2.68u as=0 ps=0 w=1u l=1u
X1082 VDD VSS.t1233 VDD VDD sg13_lv_pmos ad=0.19p pd=1.38u as=0 ps=0 w=1u l=1u
X1083 VSS.t323 VDD VSS.t322 VSS.t321 sg13_lv_nmos ad=0.1428p pd=1.52u as=0 ps=0 w=0.42u l=1u
X1084 VDD VSS.t2438 VDD VDD sg13_lv_pmos ad=0.34p pd=2.68u as=0 ps=0 w=1u l=1u
X1085 VDD VSS.t1919 VDD VDD sg13_lv_pmos ad=0.19p pd=1.38u as=0 ps=0 w=1u l=1u
X1086 VSS.t1922 VDD VSS.t1921 VSS.t1920 sg13_lv_nmos ad=0.1428p pd=1.52u as=0 ps=0 w=0.42u l=1u
X1087 VDD VSS.t2096 VDD VDD sg13_lv_pmos ad=0.34p pd=2.68u as=0 ps=0 w=1u l=1u
X1088 VDD VSS.t458 VDD VDD sg13_lv_pmos ad=0.34p pd=2.68u as=0 ps=0 w=1u l=1u
X1089 VDD VSS.t2273 VDD VDD sg13_lv_pmos ad=0.34p pd=2.68u as=0 ps=0 w=1u l=1u
X1090 VSS.t1024 VDD VSS.t1023 VSS.t1022 sg13_lv_nmos ad=0.1428p pd=1.52u as=0 ps=0 w=0.42u l=1u
X1091 VDD VSS.t2649 VDD VDD sg13_lv_pmos ad=0.34p pd=2.68u as=0 ps=0 w=1u l=1u
X1092 VDD VSS.t533 VDD VDD sg13_lv_pmos ad=0.19p pd=1.38u as=0 ps=0 w=1u l=1u
X1093 VSS.t1426 VDD VSS.t1298 VSS.t1154 sg13_lv_nmos ad=79.8f pd=0.8u as=0 ps=0 w=0.42u l=1u
X1094 VDD VSS.t2044 VDD VDD sg13_lv_pmos ad=0.19p pd=1.38u as=0 ps=0 w=1u l=1u
X1095 a_17063_16020# sg13cmos5l_or3_1_2.B a_16969_16020# VDD sg13_lv_pmos ad=0.19p pd=1.38u as=0.34p ps=2.68u w=1u l=0.13u
X1096 VDD sg13cmos5l_dlygate4sd3_1_4.X sg13cmos5l_dlygate4sd3_1_5.A VDD sg13_lv_pmos ad=0.3808p pd=2.92u as=0.2128p ps=1.5u w=1.12u l=0.15u
X1097 VSS.t52 a_19450_15202# a_19169_15424# VSS.t18 sg13_lv_nmos ad=79.8f pd=0.8u as=0.1428p ps=1.52u w=0.42u l=0.5u
X1098 VDD VSS.t888 VDD VDD sg13_lv_pmos ad=0.34p pd=2.68u as=0 ps=0 w=1u l=1u
X1099 VDD VSS.t1160 VDD VDD sg13_lv_pmos ad=0.19p pd=1.38u as=0 ps=0 w=1u l=1u
X1100 VSS.t11 a_4175_15311# a_4842_15532# VSS.t46 sg13_lv_nmos ad=0.1406p pd=1.12u as=0.2516p ps=2.16u w=0.74u l=0.13u
X1101 sg13cmos5l_xnor2_1_0.Y sg13cmos5l_nand3_1_0.Y a_7923_15532# VDD sg13_lv_pmos ad=0.2408p pd=1.55u as=0.1428p ps=1.375u w=1.12u l=0.13u
X1102 VDD VSS.t866 VDD VDD sg13_lv_pmos ad=0.19p pd=1.38u as=0 ps=0 w=1u l=1u
X1103 VSS.t2646 VDD VSS.t2645 VSS.t198 sg13_lv_nmos ad=0.1428p pd=1.52u as=0 ps=0 w=0.42u l=1u
X1104 VDD VSS.t2659 VDD VDD sg13_lv_pmos ad=0.19p pd=1.38u as=0 ps=0 w=1u l=1u
X1105 VSS.t2703 VDD VSS.t2705 VSS.t198 sg13_lv_nmos ad=79.8f pd=0.8u as=0 ps=0 w=0.42u l=1u
X1106 VDD a_8582_15238# a_8694_15302# VDD sg13_lv_pmos ad=0.2254p pd=1.53u as=0.34p ps=2.68u w=1u l=0.5u
X1107 VDD VSS.t2891 VDD VDD sg13_lv_pmos ad=0.34p pd=2.68u as=0 ps=0 w=1u l=1u
X1108 VDD sg13cmos5l_xor2_1_0.X a_1965_14832# VDD sg13_lv_pmos ad=0.1918p pd=1.5u as=0.1596p ps=1.22u w=0.84u l=0.13u
X1109 VSS.t605 VDD VSS.t608 VSS.t741 sg13_lv_nmos ad=79.8f pd=0.8u as=0 ps=0 w=0.42u l=1u
X1110 a_17318_14922# sg13cmos5l_dfrbpq_1_3.D VDD VDD sg13_lv_pmos ad=79.8f pd=0.8u as=0.1428p ps=1.52u w=0.42u l=0.13u
X1111 VDD VSS.t763 VDD VDD sg13_lv_pmos ad=0.34p pd=2.68u as=0 ps=0 w=1u l=1u
X1112 VDD VSS.t951 VDD VDD sg13_lv_pmos ad=0.19p pd=1.38u as=0 ps=0 w=1u l=1u
X1113 VSS.t2912 VDD VSS.t2911 VSS.t2910 sg13_lv_nmos ad=0.1428p pd=1.52u as=0 ps=0 w=0.42u l=1u
X1114 VSS.t1039 VDD VSS.t1038 VSS.t1037 sg13_lv_nmos ad=0.1428p pd=1.52u as=0 ps=0 w=0.42u l=1u
X1115 VSS.t1306 VDD VSS.t1307 VSS.t1154 sg13_lv_nmos ad=79.8f pd=0.8u as=0 ps=0 w=0.42u l=1u
X1116 VDD VSS.t2471 VDD VDD sg13_lv_pmos ad=0.19p pd=1.38u as=0 ps=0 w=1u l=1u
X1117 VSS.t83 a_17710_16263# sg13cmos5l_a21oi_1_0.A1 VSS.t3259 sg13_lv_nmos ad=0.1426p pd=1.16u as=0.2516p ps=2.16u w=0.74u l=0.13u
X1118 VSS.t5 a_25094_14484# a_25206_14508# VSS.t4 sg13_lv_nmos ad=0.1426p pd=1.16u as=0.1428p ps=1.52u w=0.42u l=0.5u
X1119 sg13cmos5l_or3_1_1.X a_24841_13726# VSS.t67 VSS.t246 sg13_lv_nmos ad=0.2516p pd=2.16u as=0.13395p ps=1.12u w=0.74u l=0.13u
X1120 VDD VSS.t1911 VDD VDD sg13_lv_pmos ad=0.34p pd=2.68u as=0 ps=0 w=1u l=1u
X1121 VDD VSS.t2669 VDD VDD sg13_lv_pmos ad=0.34p pd=2.68u as=0 ps=0 w=1u l=1u
X1122 sg13cmos5l_dfrbpq_1_2.D sg13cmos5l_nor2_1_0.B a_15338_14484# VDD sg13_lv_pmos ad=0.3808p pd=2.92u as=0.1176p ps=1.33u w=1.12u l=0.13u
X1123 VSS.t455 VDD VSS.t129 VSS.t454 sg13_lv_nmos ad=0.1428p pd=1.52u as=0 ps=0 w=0.42u l=1u
X1124 VDD VSS.t1165 VDD VDD sg13_lv_pmos ad=0.19p pd=1.38u as=0 ps=0 w=1u l=1u
X1125 a_25109_12972# sg13cmos5l_a21oi_1_3.A1 VDD VDD sg13_lv_pmos ad=0.2128p pd=1.5u as=0.2128p ps=1.5u w=1.12u l=0.13u
X1126 VSS.t1585 VDD VSS.t1584 VSS.t1583 sg13_lv_nmos ad=0.1428p pd=1.52u as=0 ps=0 w=0.42u l=1u
X1127 VSS.t3102 VDD VSS.t3101 VSS.t3100 sg13_lv_nmos ad=0.1428p pd=1.52u as=0 ps=0 w=0.42u l=1u
X1128 VDD VSS.t2258 VDD VDD sg13_lv_pmos ad=0.34p pd=2.68u as=0 ps=0 w=1u l=1u
X1129 VSS.t2489 VDD VSS.t2491 VSS.t2490 sg13_lv_nmos ad=79.8f pd=0.8u as=0 ps=0 w=0.42u l=1u
X1130 VDD VSS.t508 VDD VDD sg13_lv_pmos ad=0.34p pd=2.68u as=0 ps=0 w=1u l=1u
X1131 VDD VSS.t1594 VDD VDD sg13_lv_pmos ad=0.34p pd=2.68u as=0 ps=0 w=1u l=1u
X1132 VSS.t138 a_19323_13726# sg13cmos5l_buf_8_2.X VSS.t3252 sg13_lv_nmos ad=0.1406p pd=1.12u as=0.1406p ps=1.12u w=0.74u l=0.13u
X1133 VDD VSS.t1251 VDD VDD sg13_lv_pmos ad=0.19p pd=1.38u as=0 ps=0 w=1u l=1u
X1134 VSS.t1485 VDD VSS.t1484 VSS.t1483 sg13_lv_nmos ad=0.1428p pd=1.52u as=0 ps=0 w=0.42u l=1u
X1135 VSS.t2394 VDD VSS.t2393 VSS.t2392 sg13_lv_nmos ad=0.1428p pd=1.52u as=0 ps=0 w=0.42u l=1u
X1136 VSS.t1867 VDD VSS.t1866 VSS.t1865 sg13_lv_nmos ad=0.1428p pd=1.52u as=0 ps=0 w=0.42u l=1u
X1137 VSS.t1655 VDD VSS.t1657 VSS.t1656 sg13_lv_nmos ad=79.8f pd=0.8u as=0 ps=0 w=0.42u l=1u
X1138 VSS.t1199 VDD VSS.t1200 VSS.t1154 sg13_lv_nmos ad=79.8f pd=0.8u as=0 ps=0 w=0.42u l=1u
X1139 VDD VSS.t1966 VDD VDD sg13_lv_pmos ad=0.34p pd=2.68u as=0 ps=0 w=1u l=1u
X1140 VDD VSS.t2738 VDD VDD sg13_lv_pmos ad=0.34p pd=2.68u as=0 ps=0 w=1u l=1u
X1141 VSS.t2359 VDD VSS.t2361 VSS.t2360 sg13_lv_nmos ad=79.8f pd=0.8u as=0 ps=0 w=0.42u l=1u
X1142 VDD VSS.t3084 VDD VDD sg13_lv_pmos ad=0.19p pd=1.38u as=0 ps=0 w=1u l=1u
X1143 a_16485_13701# sg13cmos5l_dfrbpq_1_2.CLK VDD VDD sg13_lv_pmos ad=0.4088p pd=2.97u as=2.3367p ps=15.135u w=1.12u l=0.13u
X1144 VDD VSS.t918 VDD VDD sg13_lv_pmos ad=0.34p pd=2.68u as=0 ps=0 w=1u l=1u
X1145 VSS.t2661 VDD VSS.t2662 VSS.t198 sg13_lv_nmos ad=79.8f pd=0.8u as=0 ps=0 w=0.42u l=1u
X1146 VDD VSS.t2632 VDD VDD sg13_lv_pmos ad=0.19p pd=1.38u as=0 ps=0 w=1u l=1u
X1147 VDD VSS.t330 VDD VDD sg13_lv_pmos ad=0.19p pd=1.38u as=0 ps=0 w=1u l=1u
X1148 VSS.t1288 VDD VSS.t1287 VSS.t1154 sg13_lv_nmos ad=0.1428p pd=1.52u as=0 ps=0 w=0.42u l=1u
X1149 VSS.t2897 VDD VSS.t2896 VSS.t2895 sg13_lv_nmos ad=0.1428p pd=1.52u as=0 ps=0 w=0.42u l=1u
X1150 VDD a_4474_14448# a_4193_14750# VDD sg13_lv_pmos ad=0.1523p pd=1.38u as=0.34p ps=2.68u w=1u l=0.5u
X1151 VDD VSS.t1292 VDD VDD sg13_lv_pmos ad=0.34p pd=2.68u as=0 ps=0 w=1u l=1u
X1152 VDD VSS.t2298 VDD VDD sg13_lv_pmos ad=0.34p pd=2.68u as=0 ps=0 w=1u l=1u
X1153 VDD VSS.t2662 VDD VDD sg13_lv_pmos ad=0.34p pd=2.68u as=0 ps=0 w=1u l=1u
X1154 VDD sg13cmos5l_buf_1_0.X a_2942_14484# VDD sg13_lv_pmos ad=0.36p pd=2.72u as=0.1225p ps=1.245u w=1u l=0.13u
X1155 a_6540_13238# sg13cmos5l_xnor2_1_2.B VDD VDD sg13_lv_pmos ad=0.1596p pd=1.22u as=0.2891p ps=1.695u w=0.84u l=0.13u
X1156 VSS.t1024 VDD VSS.t1023 VSS.t1022 sg13_lv_nmos ad=0.1428p pd=1.52u as=0 ps=0 w=0.42u l=1u
X1157 VDD VSS.t2423 VDD VDD sg13_lv_pmos ad=0.34p pd=2.68u as=0 ps=0 w=1u l=1u
X1158 VDD VSS.t599 VDD VDD sg13_lv_pmos ad=0.34p pd=2.68u as=0 ps=0 w=1u l=1u
X1159 VDD VSS.t2081 VDD VDD sg13_lv_pmos ad=0.34p pd=2.68u as=0 ps=0 w=1u l=1u
X1160 VDD VSS.t533 VDD VDD sg13_lv_pmos ad=0.19p pd=1.38u as=0 ps=0 w=1u l=1u
X1161 VDD VSS.t2642 VDD VDD sg13_lv_pmos ad=0.34p pd=2.68u as=0 ps=0 w=1u l=1u
X1162 VDD VSS.t933 VDD VDD sg13_lv_pmos ad=0.34p pd=2.68u as=0 ps=0 w=1u l=1u
X1163 a_21034_14452# a_21477_14495# a_20774_14922# VSS.t3282 sg13_lv_nmos ad=79.8f pd=0.8u as=0.1296p ps=1.52u w=0.42u l=0.13u
X1164 VDD VSS.t2748 VDD VDD sg13_lv_pmos ad=0.34p pd=2.68u as=0 ps=0 w=1u l=1u
X1165 VDD VSS.t1172 VDD VDD sg13_lv_pmos ad=0.34p pd=2.68u as=0 ps=0 w=1u l=1u
X1166 VSS.t2688 VDD VSS.t2688 VSS.t198 sg13_lv_nmos ad=0.1428p pd=1.52u as=0 ps=0 w=0.42u l=1u
X1167 VSS.t1445 VDD VSS.t1447 VSS.t1446 sg13_lv_nmos ad=79.8f pd=0.8u as=0 ps=0 w=0.42u l=1u
X1168 VSS.t1039 VDD VSS.t1038 VSS.t1037 sg13_lv_nmos ad=0.1428p pd=1.52u as=0 ps=0 w=0.42u l=1u
X1169 sg13cmos5l_a21oi_1_3.A2 a_24169_14508# VSS.t3221 VSS.t4 sg13_lv_nmos ad=0.2516p pd=2.16u as=0.13395p ps=1.12u w=0.74u l=0.13u
X1170 VDD VSS.t996 VDD VDD sg13_lv_pmos ad=0.19p pd=1.38u as=0 ps=0 w=1u l=1u
X1171 VSS.t944 VDD VSS.t946 VSS.t945 sg13_lv_nmos ad=79.8f pd=0.8u as=0 ps=0 w=0.42u l=1u
X1172 VDD reset_n_i a_1192_9948# VDD sg13_lv_pmos ad=0.2114p pd=1.54u as=0.2856p ps=2.36u w=0.84u l=0.13u
X1173 VDD VSS.t1577 VDD VDD sg13_lv_pmos ad=0.19p pd=1.38u as=0 ps=0 w=1u l=1u
X1174 VSS.t2741 VDD VSS.t2740 VSS.t198 sg13_lv_nmos ad=0.1428p pd=1.52u as=0 ps=0 w=0.42u l=1u
X1175 VSS.t2007 VDD VSS.t2009 VSS.t2008 sg13_lv_nmos ad=79.8f pd=0.8u as=0 ps=0 w=0.42u l=1u
X1176 VSS.t408 VDD VSS.t409 VSS.t11 sg13_lv_nmos ad=79.8f pd=0.8u as=0 ps=0 w=0.42u l=1u
X1177 VDD VSS.t2318 VDD VDD sg13_lv_pmos ad=0.34p pd=2.68u as=0 ps=0 w=1u l=1u
X1178 a_16969_16020# sg13cmos5l_inv_1_0.Y VSS.t83 VSS.t3271 sg13_lv_nmos ad=0.198p pd=1.27u as=0.1045p ps=0.93u w=0.55u l=0.13u
X1179 VDD VSS.t351 VDD VDD sg13_lv_pmos ad=0.34p pd=2.68u as=0 ps=0 w=1u l=1u
X1180 VSS.t541 VDD VSS.t540 VSS.t539 sg13_lv_nmos ad=0.1428p pd=1.52u as=0 ps=0 w=0.42u l=1u
X1181 VDD VSS.t1582 VDD VDD sg13_lv_pmos ad=0.19p pd=1.38u as=0 ps=0 w=1u l=1u
X1182 VDD VSS.t111 VDD VDD sg13_lv_pmos ad=0.34p pd=2.68u as=0 ps=0 w=1u l=1u
X1183 VSS.t1927 VDD VSS.t1926 VSS.t1925 sg13_lv_nmos ad=0.1428p pd=1.52u as=0 ps=0 w=0.42u l=1u
X1184 a_25774_15423# a_25889_15424# VDD VDD sg13_lv_pmos ad=0.34p pd=2.68u as=0.2254p ps=1.53u w=1u l=0.5u
X1185 VDD VSS.t1315 VDD VDD sg13_lv_pmos ad=0.34p pd=2.68u as=0 ps=0 w=1u l=1u
X1186 VDD VSS.t2638 VDD VDD sg13_lv_pmos ad=0.34p pd=2.68u as=0 ps=0 w=1u l=1u
X1187 VDD VSS.t508 VDD VDD sg13_lv_pmos ad=0.34p pd=2.68u as=0 ps=0 w=1u l=1u
X1188 a_18552_15976# sg13cmos5l_inv_1_0.Y VDD VDD sg13_lv_pmos ad=0.2128p pd=1.5u as=0.3808p ps=2.92u w=1.12u l=0.15u
X1189 VSS.t355 VDD VSS.t355 VSS.t356 sg13_lv_nmos ad=79.8f pd=0.8u as=0 ps=0 w=0.42u l=1u
X1190 VSS.t1665 VDD VSS.t1664 VSS.t1663 sg13_lv_nmos ad=0.1428p pd=1.52u as=0 ps=0 w=0.42u l=1u
X1191 VSS.t1470 VDD VSS.t1469 VSS.t1468 sg13_lv_nmos ad=0.1428p pd=1.52u as=0 ps=0 w=0.42u l=1u
X1192 VSS.t2379 VDD VSS.t2378 VSS.t2377 sg13_lv_nmos ad=0.1428p pd=1.52u as=0 ps=0 w=0.42u l=1u
X1193 VSS.t2648 VDD VSS.t2648 VSS.t198 sg13_lv_nmos ad=0.1428p pd=1.52u as=0 ps=0 w=0.42u l=1u
X1194 VDD VSS.t11 VDD VDD sg13_lv_pmos ad=0.19p pd=1.38u as=0 ps=0 w=1u l=1u
X1195 VSS.t2707 VDD VSS.t2708 VSS.t198 sg13_lv_nmos ad=79.8f pd=0.8u as=0 ps=0 w=0.42u l=1u
X1196 VSS.t2957 VDD VSS.t2956 VSS.t2955 sg13_lv_nmos ad=0.1428p pd=1.52u as=0 ps=0 w=0.42u l=1u
X1197 a_22319_14845# a_21477_14495# a_21060_14488# VDD sg13_lv_pmos ad=0.2048p pd=1.63u as=0.34p ps=2.68u w=1u l=0.13u
X1198 VSS.t2344 VDD VSS.t2346 VSS.t2345 sg13_lv_nmos ad=79.8f pd=0.8u as=0 ps=0 w=0.42u l=1u
X1199 VDD VSS.t3069 VDD VDD sg13_lv_pmos ad=0.19p pd=1.38u as=0 ps=0 w=1u l=1u
X1200 VDD VSS.t2286 VDD VDD sg13_lv_pmos ad=0.19p pd=1.38u as=0 ps=0 w=1u l=1u
X1201 a_24062_15242# sg13cmos5l_dfrbpq_1_6.Q a_23960_15242# VSS.t64 sg13_lv_nmos ad=0.1406p pd=1.12u as=0.1406p ps=1.12u w=0.74u l=0.13u
X1202 VSS.t1660 VDD VSS.t1659 VSS.t1658 sg13_lv_nmos ad=0.1428p pd=1.52u as=0 ps=0 w=0.42u l=1u
X1203 VDD VSS.t966 VDD VDD sg13_lv_pmos ad=0.19p pd=1.38u as=0 ps=0 w=1u l=1u
X1204 VDD VSS.t3021 VDD VDD sg13_lv_pmos ad=0.34p pd=2.68u as=0 ps=0 w=1u l=1u
X1205 VSS.t2752 VDD VSS.t2750 VSS.t198 sg13_lv_nmos ad=0.1428p pd=1.52u as=0 ps=0 w=0.42u l=1u
X1206 VSS.t2653 VDD VSS.t2654 VSS.t198 sg13_lv_nmos ad=79.8f pd=0.8u as=0 ps=0 w=0.42u l=1u
X1207 VDD VSS.t2624 VDD VDD sg13_lv_pmos ad=0.19p pd=1.38u as=0 ps=0 w=1u l=1u
X1208 a_8779_14832# sg13cmos5l_buf_1_10.X a_8685_14832# VSS.t109 sg13_lv_nmos ad=0.1216p pd=1.02u as=0.2176p ps=1.96u w=0.64u l=0.13u
X1209 VDD VSS.t1203 VDD VDD sg13_lv_pmos ad=0.19p pd=1.38u as=0 ps=0 w=1u l=1u
X1210 VDD VSS.t1284 VDD VDD sg13_lv_pmos ad=0.34p pd=2.68u as=0 ps=0 w=1u l=1u
X1211 VDD VSS.t2476 VDD VDD sg13_lv_pmos ad=0.19p pd=1.38u as=0 ps=0 w=1u l=1u
X1212 VDD VSS.t2654 VDD VDD sg13_lv_pmos ad=0.34p pd=2.68u as=0 ps=0 w=1u l=1u
X1213 VSS.t1962 VDD VSS.t1961 VSS.t1960 sg13_lv_nmos ad=0.1428p pd=1.52u as=0 ps=0 w=0.42u l=1u
X1214 VDD VSS.t1916 VDD VDD sg13_lv_pmos ad=0.34p pd=2.68u as=0 ps=0 w=1u l=1u
X1215 a_15579_14854# clock_i VSS.t21 VSS.t3238 sg13_lv_nmos ad=0.1406p pd=1.12u as=0.1406p ps=1.12u w=0.74u l=0.13u
X1216 VSS.t142 sg13cmos5l_dfrbpq_1_6.RESET_B a_20868_14922# VSS.t213 sg13_lv_nmos ad=0.1626p pd=1.415u as=60.89999f ps=0.71u w=0.42u l=0.13u
X1217 VSS.t508 VDD VSS.t508 VSS.t511 sg13_lv_nmos ad=0.1428p pd=1.52u as=0 ps=0 w=0.42u l=1u
X1218 a_17578_14452# a_18021_14495# a_17318_14922# VSS.t50 sg13_lv_nmos ad=79.8f pd=0.8u as=0.1296p ps=1.52u w=0.42u l=0.13u
X1219 VSS.t2494 VDD VSS.t2496 VSS.t2495 sg13_lv_nmos ad=79.8f pd=0.8u as=0 ps=0 w=0.42u l=1u
X1220 a_25956_14488# a_25930_14452# VSS.t42 VSS.t232 sg13_lv_nmos ad=0.2516p pd=2.16u as=0.1626p ps=1.415u w=0.74u l=0.13u
X1221 VSS.t441 VDD VSS.t442 VSS.t11 sg13_lv_nmos ad=79.8f pd=0.8u as=0 ps=0 w=0.42u l=1u
X1222 VDD VSS.t841 VDD VDD sg13_lv_pmos ad=0.19p pd=1.38u as=0 ps=0 w=1u l=1u
X1223 VDD VSS.t2436 VDD VDD sg13_lv_pmos ad=0.19p pd=1.38u as=0 ps=0 w=1u l=1u
X1224 VSS.t1240 VDD VSS.t1239 VSS.t1154 sg13_lv_nmos ad=0.1428p pd=1.52u as=0 ps=0 w=0.42u l=1u
X1225 VSS.t1455 VDD VSS.t1454 VSS.t1453 sg13_lv_nmos ad=0.1428p pd=1.52u as=0 ps=0 w=0.42u l=1u
X1226 VSS.t59 VDD VSS.t59 VSS.t348 sg13_lv_nmos ad=0.1428p pd=1.52u as=0 ps=0 w=0.42u l=1u
X1227 VDD VSS.t274 VDD VDD sg13_lv_pmos ad=0.34p pd=2.68u as=0 ps=0 w=1u l=1u
X1228 a_6372_14488# a_6891_14495# a_7631_14845# VSS.t225 sg13_lv_nmos ad=0.3473p pd=2.71u as=0.12665p ps=1.145u w=0.74u l=0.13u
X1229 VSS.t2697 VDD VSS.t2699 VSS.t198 sg13_lv_nmos ad=79.8f pd=0.8u as=0 ps=0 w=0.42u l=1u
X1230 VDD VSS.t450 VDD VDD sg13_lv_pmos ad=0.19p pd=1.38u as=0 ps=0 w=1u l=1u
X1231 a_20278_14862# sg13cmos5l_or3_1_2.C VSS.t19 VSS.t9 sg13_lv_nmos ad=0.1406p pd=1.12u as=0.1406p ps=1.12u w=0.74u l=0.15u
X1232 a_27634_14922# sg13cmos5l_dfrbpq_1_7.RESET_B VSS.t11 VSS.t11 sg13_lv_nmos ad=37.8f pd=0.6u as=79.8f ps=0.8u w=0.42u l=0.13u
X1233 VSS.t44 sg13cmos5l_xnor2_1_2.B a_6575_13342# VSS.t3192 sg13_lv_nmos ad=0.1898p pd=1.36u as=0.1406p ps=1.12u w=0.74u l=0.13u
X1234 VDD VSS.t1162 VDD VDD sg13_lv_pmos ad=0.34p pd=2.68u as=0 ps=0 w=1u l=1u
X1235 VDD VSS.t1936 VDD VDD sg13_lv_pmos ad=0.34p pd=2.68u as=0 ps=0 w=1u l=1u
X1236 VSS.t180 VDD VSS.t593 VSS.t731 sg13_lv_nmos ad=79.8f pd=0.8u as=0 ps=0 w=0.42u l=1u
X1237 VDD VSS.t1222 VDD VDD sg13_lv_pmos ad=0.34p pd=2.68u as=0 ps=0 w=1u l=1u
X1238 VDD VSS.t3089 VDD VDD sg13_lv_pmos ad=0.19p pd=1.38u as=0 ps=0 w=1u l=1u
X1239 VSS.t944 VDD VSS.t946 VSS.t945 sg13_lv_nmos ad=79.8f pd=0.8u as=0 ps=0 w=0.42u l=1u
X1240 VSS.t989 VDD VSS.t988 VSS.t987 sg13_lv_nmos ad=0.1428p pd=1.52u as=0 ps=0 w=0.42u l=1u
X1241 VSS.t2902 VDD VSS.t2901 VSS.t2900 sg13_lv_nmos ad=0.1428p pd=1.52u as=0 ps=0 w=0.42u l=1u
X1242 VSS.t441 VDD VSS.t440 VSS.t11 sg13_lv_nmos ad=0.1428p pd=1.52u as=0 ps=0 w=0.42u l=1u
X1243 a_7888_14726# a_7631_14845# a_8050_14922# VSS.t140 sg13_lv_nmos ad=0.1428p pd=1.52u as=37.8f ps=0.6u w=0.42u l=0.13u
X1244 VSS.t1180 VDD VSS.t1180 VSS.t1154 sg13_lv_nmos ad=0.1428p pd=1.52u as=0 ps=0 w=0.42u l=1u
X1245 VSS.t3072 VDD VSS.t3074 VSS.t3073 sg13_lv_nmos ad=79.8f pd=0.8u as=0 ps=0 w=0.42u l=1u
X1246 VSS.t2289 VDD VSS.t2291 VSS.t2290 sg13_lv_nmos ad=79.8f pd=0.8u as=0 ps=0 w=0.42u l=1u
X1247 VSS.t11 a_18665_15180# a_18586_15455# VSS.t253 sg13_lv_nmos ad=4.11262p pd=27.15u as=0.27427p ps=2.28u w=0.795u l=0.13u
X1248 VDD VSS.t427 VDD VDD sg13_lv_pmos ad=0.19p pd=1.38u as=0 ps=0 w=1u l=1u
X1249 VDD VSS.t2303 VDD VDD sg13_lv_pmos ad=0.34p pd=2.68u as=0 ps=0 w=1u l=1u
X1250 VDD VSS.t1449 VDD VDD sg13_lv_pmos ad=0.34p pd=2.68u as=0 ps=0 w=1u l=1u
X1251 VDD a_10703_15311# a_11370_15532# VDD sg13_lv_pmos ad=0.2128p pd=1.5u as=0.3864p ps=2.93u w=1.12u l=0.13u
X1252 VSS.t132 sg13cmos5l_buf_8_2.A a_12010_15202# VSS.t131 sg13_lv_nmos ad=0.1406p pd=1.12u as=0.1406p ps=1.12u w=0.74u l=0.13u
X1253 VSS.t2364 VDD VSS.t2366 VSS.t2365 sg13_lv_nmos ad=79.8f pd=0.8u as=0 ps=0 w=0.42u l=1u
X1254 VDD VSS.t2428 VDD VDD sg13_lv_pmos ad=0.34p pd=2.68u as=0 ps=0 w=1u l=1u
X1255 VSS.t1912 VDD VSS.t1911 VSS.t1910 sg13_lv_nmos ad=0.1428p pd=1.52u as=0 ps=0 w=0.42u l=1u
X1256 VSS.t2678 VDD VSS.t2678 VSS.t198 sg13_lv_nmos ad=0.1428p pd=1.52u as=0 ps=0 w=0.42u l=1u
X1257 VDD VSS.t2631 VDD VDD sg13_lv_pmos ad=0.34p pd=2.68u as=0 ps=0 w=1u l=1u
X1258 VSS.t583 VDD VSS.t583 VSS.t584 sg13_lv_nmos ad=0.1428p pd=1.52u as=0 ps=0 w=0.42u l=1u
X1259 VDD VSS.t1584 VDD VDD sg13_lv_pmos ad=0.34p pd=2.68u as=0 ps=0 w=1u l=1u
X1260 VSS.t341 VDD VSS.t340 VSS.t339 sg13_lv_nmos ad=0.1428p pd=1.52u as=0 ps=0 w=0.42u l=1u
X1261 a_25862_13722# a_26667_13844# a_26122_13945# VDD sg13_lv_pmos ad=0.1428p pd=1.52u as=79.8f ps=0.8u w=0.42u l=0.13u
X1262 VSS.t864 VDD VSS.t866 VSS.t865 sg13_lv_nmos ad=79.8f pd=0.8u as=0 ps=0 w=0.42u l=1u
X1263 VDD VSS.t2004 VDD VDD sg13_lv_pmos ad=0.19p pd=1.38u as=0 ps=0 w=1u l=1u
X1264 VSS.t1 VDD VSS.t1 VSS.t92 sg13_lv_nmos ad=0.1428p pd=1.52u as=0 ps=0 w=0.42u l=1u
X1265 VDD VSS.t30 VDD VDD sg13_lv_pmos ad=0.34p pd=2.68u as=0 ps=0 w=1u l=1u
X1266 VDD VSS.t1174 VDD VDD sg13_lv_pmos ad=0.34p pd=2.68u as=0 ps=0 w=1u l=1u
X1267 VDD VSS.t1277 VDD VDD sg13_lv_pmos ad=0.19p pd=1.38u as=0 ps=0 w=1u l=1u
X1268 VDD a_27664_13942# a_27609_14037# VDD sg13_lv_pmos ad=2.42015p pd=15.68u as=93.45f ps=0.865u w=0.42u l=0.13u
X1269 VSS.t2672 VDD VSS.t2672 VSS.t198 sg13_lv_nmos ad=0.1428p pd=1.52u as=0 ps=0 w=0.42u l=1u
X1270 VDD VSS.t1008 VDD VDD sg13_lv_pmos ad=0.34p pd=2.68u as=0 ps=0 w=1u l=1u
X1271 VDD VSS.t3006 VDD VDD sg13_lv_pmos ad=0.34p pd=2.68u as=0 ps=0 w=1u l=1u
X1272 VSS.t2743 VDD VSS.t2743 VSS.t198 sg13_lv_nmos ad=0.1428p pd=1.52u as=0 ps=0 w=0.42u l=1u
X1273 VSS.t2012 VDD VSS.t2014 VSS.t2013 sg13_lv_nmos ad=79.8f pd=0.8u as=0 ps=0 w=0.42u l=1u
X1274 VSS.t87 a_17327_13799# a_17994_14020# VSS.t86 sg13_lv_nmos ad=0.1406p pd=1.12u as=0.2516p ps=2.16u w=0.74u l=0.13u
X1275 VSS.t3092 VDD VSS.t3094 VSS.t3093 sg13_lv_nmos ad=79.8f pd=0.8u as=0 ps=0 w=0.42u l=1u
X1276 sg13cmos5l_and2_1_2.B a_8694_15302# VSS.t1 VSS.t3285 sg13_lv_nmos ad=0.2516p pd=2.16u as=0.1426p ps=1.16u w=0.74u l=0.13u
X1277 VDD VSS.t617 VDD VDD sg13_lv_pmos ad=0.34p pd=2.68u as=0 ps=0 w=1u l=1u
X1278 VDD VSS.t2461 VDD VDD sg13_lv_pmos ad=0.19p pd=1.38u as=0 ps=0 w=1u l=1u
X1279 VSS.t1316 VDD VSS.t1315 VSS.t1154 sg13_lv_nmos ad=0.1428p pd=1.52u as=0 ps=0 w=0.42u l=1u
X1280 VDD VSS.t1642 VDD VDD sg13_lv_pmos ad=0.19p pd=1.38u as=0 ps=0 w=1u l=1u
X1281 VSS.t1515 VDD VSS.t1514 VSS.t1513 sg13_lv_nmos ad=0.1428p pd=1.52u as=0 ps=0 w=0.42u l=1u
X1282 VSS.t1932 VDD VSS.t1931 VSS.t1930 sg13_lv_nmos ad=0.1428p pd=1.52u as=0 ps=0 w=0.42u l=1u
X1283 VSS.t719 VDD VSS.t145 VSS.t718 sg13_lv_nmos ad=0.1428p pd=1.52u as=0 ps=0 w=0.42u l=1u
X1284 VDD VSS.t2640 VDD VDD sg13_lv_pmos ad=0.34p pd=2.68u as=0 ps=0 w=1u l=1u
X1285 VSS.t75 a_22025_16334# a_21946_16237# VSS.t168 sg13_lv_nmos ad=7.70437p pd=50.66u as=0.27427p ps=2.28u w=0.795u l=0.13u
X1286 VSS.t1309 VDD VSS.t1310 VSS.t1154 sg13_lv_nmos ad=79.8f pd=0.8u as=0 ps=0 w=0.42u l=1u
X1287 VDD VSS.t2734 VDD VDD sg13_lv_pmos ad=0.19p pd=1.38u as=0 ps=0 w=1u l=1u
X1288 VSS.t2042 VDD VSS.t2041 VSS.t2040 sg13_lv_nmos ad=0.1428p pd=1.52u as=0 ps=0 w=0.42u l=1u
X1289 VSS.t227 VDD VSS.t227 VSS.t361 sg13_lv_nmos ad=0.1428p pd=1.52u as=0 ps=0 w=0.42u l=1u
X1290 VSS.t834 VDD VSS.t833 VSS.t832 sg13_lv_nmos ad=0.1428p pd=1.52u as=0 ps=0 w=0.42u l=1u
X1291 VDD VSS.t886 VDD VDD sg13_lv_pmos ad=0.19p pd=1.38u as=0 ps=0 w=1u l=1u
X1292 VDD VSS.t2331 VDD VDD sg13_lv_pmos ad=0.19p pd=1.38u as=0 ps=0 w=1u l=1u
X1293 VDD VSS.t1989 VDD VDD sg13_lv_pmos ad=0.19p pd=1.38u as=0 ps=0 w=1u l=1u
X1294 VDD a_27215_14845# a_27882_14484# VDD sg13_lv_pmos ad=0.2128p pd=1.5u as=0.3864p ps=2.93u w=1.12u l=0.13u
X1295 VSS.t2651 VDD VSS.t2650 VSS.t198 sg13_lv_nmos ad=0.1428p pd=1.52u as=0 ps=0 w=0.42u l=1u
X1296 VSS.t267 a_2540_15960# counter_value_o[0] VSS.t3275 sg13_lv_nmos ad=0.14875p pd=1.16u as=0.2886p ps=2.26u w=0.74u l=0.13u
X1297 a_12010_15202# sg13cmos5l_buf_8_2.A VDD VDD sg13_lv_pmos ad=0.3808p pd=2.92u as=0.2128p ps=1.5u w=1.12u l=0.13u
X1298 VSS.t617 VDD VSS.t620 VSS.t749 sg13_lv_nmos ad=79.8f pd=0.8u as=0 ps=0 w=0.42u l=1u
X1299 VSS.t2349 VDD VSS.t2351 VSS.t2350 sg13_lv_nmos ad=79.8f pd=0.8u as=0 ps=0 w=0.42u l=1u
X1300 VDD VSS.t2114 VDD VDD sg13_lv_pmos ad=0.19p pd=1.38u as=0 ps=0 w=1u l=1u
X1301 a_25670_14922# a_26475_14495# a_25930_14452# VDD sg13_lv_pmos ad=0.1428p pd=1.52u as=79.8f ps=0.8u w=0.42u l=0.13u
X1302 VDD a_19323_13726# sg13cmos5l_buf_8_2.X VDD sg13_lv_pmos ad=0.3864p pd=2.93u as=0.2128p ps=1.5u w=1.12u l=0.13u
X1303 VSS.t989 VDD VSS.t988 VSS.t987 sg13_lv_nmos ad=0.1428p pd=1.52u as=0 ps=0 w=0.42u l=1u
X1304 VDD VSS.t971 VDD VDD sg13_lv_pmos ad=0.19p pd=1.38u as=0 ps=0 w=1u l=1u
X1305 VSS.t199 enable_i a_1192_3900# VSS.t198 sg13_lv_nmos ad=0.14875p pd=1.16u as=0.187p ps=1.78u w=0.55u l=0.13u
X1306 VSS.t1202 VDD VSS.t1203 VSS.t1154 sg13_lv_nmos ad=79.8f pd=0.8u as=0 ps=0 w=0.42u l=1u
X1307 VDD VSS.t1447 VDD VDD sg13_lv_pmos ad=0.19p pd=1.38u as=0 ps=0 w=1u l=1u
X1308 VSS.t263 VDD VSS.t262 VSS.t261 sg13_lv_nmos ad=0.1428p pd=1.52u as=0 ps=0 w=0.42u l=1u
X1309 VSS.t11 VDD VSS.t11 VSS.t390 sg13_lv_nmos ad=0.1428p pd=1.52u as=0 ps=0 w=0.42u l=1u
X1310 VSS.t2887 VDD VSS.t2886 VSS.t2885 sg13_lv_nmos ad=0.1428p pd=1.52u as=0 ps=0 w=0.42u l=1u
X1311 VDD VSS.t366 VDD VDD sg13_lv_pmos ad=0.19p pd=1.38u as=0 ps=0 w=1u l=1u
X1312 sg13cmos5l_dfrbpq_1_5.D a_25206_14508# VDD VDD sg13_lv_pmos ad=0.4256p pd=3u as=0.2254p ps=1.53u w=1.12u l=0.13u
X1313 VDD sg13cmos5l_or3_1_1.A a_25037_14020# VDD sg13_lv_pmos ad=0.3822p pd=1.84u as=0.1575p ps=1.315u w=1u l=0.13u
X1314 VDD VSS.t1287 VDD VDD sg13_lv_pmos ad=0.34p pd=2.68u as=0 ps=0 w=1u l=1u
X1315 VDD VSS.t2481 VDD VDD sg13_lv_pmos ad=0.19p pd=1.38u as=0 ps=0 w=1u l=1u
X1316 VSS.t3221 sg13cmos5l_o21ai_1_2.B1 a_24169_14508# VSS.t4 sg13_lv_nmos ad=0.13395p pd=1.12u as=0.198p ps=1.27u w=0.55u l=0.13u
X1317 VDD VSS.t580 VDD VDD sg13_lv_pmos ad=0.19p pd=1.38u as=0 ps=0 w=1u l=1u
X1318 VDD VSS.t2657 VDD VDD sg13_lv_pmos ad=0.34p pd=2.68u as=0 ps=0 w=1u l=1u
X1319 VSS.t13 sg13cmos5l_a21oi_1_0.A2 a_17057_14832# VSS.t3261 sg13_lv_nmos ad=0.2516p pd=2.16u as=0.1406p ps=1.12u w=0.74u l=0.13u
X1320 VSS.t1465 VDD VSS.t1464 VSS.t1463 sg13_lv_nmos ad=0.1428p pd=1.52u as=0 ps=0 w=0.42u l=1u
X1321 VSS.t794 VDD VSS.t796 VSS.t795 sg13_lv_nmos ad=79.8f pd=0.8u as=0 ps=0 w=0.42u l=1u
X1322 VSS.t2027 VDD VSS.t2026 VSS.t2025 sg13_lv_nmos ad=0.1428p pd=1.52u as=0 ps=0 w=0.42u l=1u
X1323 a_4594_15234# sg13cmos5l_dfrbpq_1_0.RESET_B VSS.t11 VSS.t3232 sg13_lv_nmos ad=37.8f pd=0.6u as=79.8f ps=0.8u w=0.42u l=0.13u
X1324 VSS.t13 a_17806_15423# sg13cmos5l_inv_1_0.A VSS.t258 sg13_lv_nmos ad=0.1426p pd=1.16u as=0.2516p ps=2.16u w=0.74u l=0.13u
X1325 a_5707_14832# sg13cmos5l_buf_1_10.X a_5613_14832# VSS.t108 sg13_lv_nmos ad=0.1216p pd=1.02u as=0.2176p ps=1.96u w=0.64u l=0.13u
X1326 VSS.t864 VDD VSS.t866 VSS.t865 sg13_lv_nmos ad=79.8f pd=0.8u as=0 ps=0 w=0.42u l=1u
X1327 VDD VSS.t853 VDD VDD sg13_lv_pmos ad=0.34p pd=2.68u as=0 ps=0 w=1u l=1u
X1328 sg13cmos5l_and2_1_2.X a_8685_14832# VDD VDD sg13_lv_pmos ad=0.3808p pd=2.92u as=0.1918p ps=1.5u w=1.12u l=0.13u
X1329 VSS.t1460 VDD VSS.t1459 VSS.t1458 sg13_lv_nmos ad=0.1428p pd=1.52u as=0 ps=0 w=0.42u l=1u
X1330 VSS.t2369 VDD VSS.t2368 VSS.t2367 sg13_lv_nmos ad=0.1428p pd=1.52u as=0 ps=0 w=0.42u l=1u
X1331 a_6598_14909# sg13cmos5l_dfrbpq_1_1.RESET_B VSS.t11 VSS.t212 sg13_lv_nmos ad=37.8f pd=0.6u as=0.1701p ps=1.65u w=0.42u l=0.13u
X1332 VSS.t599 VDD VSS.t599 VSS.t736 sg13_lv_nmos ad=0.1428p pd=1.52u as=0 ps=0 w=0.42u l=1u
X1333 VSS.t1630 VDD VSS.t1632 VSS.t1631 sg13_lv_nmos ad=79.8f pd=0.8u as=0 ps=0 w=0.42u l=1u
X1334 VSS.t2643 VDD VSS.t2643 VSS.t198 sg13_lv_nmos ad=0.1428p pd=1.52u as=0 ps=0 w=0.42u l=1u
X1335 VDD VSS.t3 VDD VDD sg13_lv_pmos ad=0.19p pd=1.38u as=0 ps=0 w=1u l=1u
X1336 VDD VSS.t1327 VDD VDD sg13_lv_pmos ad=0.34p pd=2.68u as=0 ps=0 w=1u l=1u
X1337 VDD VSS.t1941 VDD VDD sg13_lv_pmos ad=0.34p pd=2.68u as=0 ps=0 w=1u l=1u
X1338 a_9444_15552# a_9418_15457# VDD VDD sg13_lv_pmos ad=0.34p pd=2.68u as=0.36237p ps=2.605u w=1u l=0.13u
X1339 VSS.t42 a_26170_15202# a_25889_15424# VSS.t3281 sg13_lv_nmos ad=79.8f pd=0.8u as=0.1428p ps=1.52u w=0.42u l=0.5u
X1340 VDD VSS.t3059 VDD VDD sg13_lv_pmos ad=0.19p pd=1.38u as=0 ps=0 w=1u l=1u
X1341 VDD VSS.t2276 VDD VDD sg13_lv_pmos ad=0.19p pd=1.38u as=0 ps=0 w=1u l=1u
X1342 VDD a_19323_13726# sg13cmos5l_buf_8_2.X VDD sg13_lv_pmos ad=0.2128p pd=1.5u as=0.2128p ps=1.5u w=1.12u l=0.13u
X1343 VDD VSS.t916 VDD VDD sg13_lv_pmos ad=0.19p pd=1.38u as=0 ps=0 w=1u l=1u
X1344 VSS.t1176 VDD VSS.t1175 VSS.t1154 sg13_lv_nmos ad=0.1428p pd=1.52u as=0 ps=0 w=0.42u l=1u
X1345 VSS.t3077 VDD VSS.t3079 VSS.t3078 sg13_lv_nmos ad=79.8f pd=0.8u as=0 ps=0 w=0.42u l=1u
X1346 VSS.t1997 VDD VSS.t1999 VSS.t1998 sg13_lv_nmos ad=79.8f pd=0.8u as=0 ps=0 w=0.42u l=1u
X1347 VSS.t2719 VDD VSS.t2718 VSS.t198 sg13_lv_nmos ad=0.1428p pd=1.52u as=0 ps=0 w=0.42u l=1u
X1348 VDD VSS.t2308 VDD VDD sg13_lv_pmos ad=0.34p pd=2.68u as=0 ps=0 w=1u l=1u
X1349 VDD VSS.t1627 VDD VDD sg13_lv_pmos ad=0.19p pd=1.38u as=0 ps=0 w=1u l=1u
X1350 VSS.t834 VDD VSS.t833 VSS.t832 sg13_lv_nmos ad=0.1428p pd=1.52u as=0 ps=0 w=0.42u l=1u
X1351 VDD VSS.t816 VDD VDD sg13_lv_pmos ad=0.19p pd=1.38u as=0 ps=0 w=1u l=1u
X1352 VSS.t1917 VDD VSS.t1916 VSS.t1915 sg13_lv_nmos ad=0.1428p pd=1.52u as=0 ps=0 w=0.42u l=1u
X1353 sg13cmos5l_nand4_1_0.Y sg13cmos5l_buf_1_0.X VDD VDD sg13_lv_pmos ad=0.2128p pd=1.5u as=0.2128p ps=1.5u w=1.12u l=0.13u
X1354 a_6578_15242# sg13cmos5l_dlygate4sd3_1_3.A VSS.t11 VSS.t3236 sg13_lv_nmos ad=0.1406p pd=1.12u as=0.2886p ps=2.26u w=0.74u l=0.13u
X1355 VSS.t411 VDD VSS.t412 VSS.t11 sg13_lv_nmos ad=79.8f pd=0.8u as=0 ps=0 w=0.42u l=1u
X1356 VDD VSS.t1579 VDD VDD sg13_lv_pmos ad=0.34p pd=2.68u as=0 ps=0 w=1u l=1u
X1357 VSS.t2663 VDD VSS.t2663 VSS.t198 sg13_lv_nmos ad=0.1428p pd=1.52u as=0 ps=0 w=0.42u l=1u
X1358 VDD VSS.t2633 VDD VDD sg13_lv_pmos ad=0.34p pd=2.68u as=0 ps=0 w=1u l=1u
X1359 VDD a_18106_15960# a_17825_16262# VDD sg13_lv_pmos ad=0.1523p pd=1.38u as=0.34p ps=2.68u w=1u l=0.5u
X1360 VDD VSS.t351 VDD VDD sg13_lv_pmos ad=0.34p pd=2.68u as=0 ps=0 w=1u l=1u
X1361 VDD VSS.t931 VDD VDD sg13_lv_pmos ad=0.19p pd=1.38u as=0 ps=0 w=1u l=1u
X1362 a_18863_14845# a_18021_14495# a_17604_14488# VDD sg13_lv_pmos ad=0.2048p pd=1.63u as=0.34p ps=2.68u w=1u l=0.13u
X1363 VSS.t1225 VDD VSS.t1223 VSS.t1154 sg13_lv_nmos ad=0.1428p pd=1.52u as=0 ps=0 w=0.42u l=1u
X1364 VDD VSS.t2493 VDD VDD sg13_lv_pmos ad=0.34p pd=2.68u as=0 ps=0 w=1u l=1u
X1365 VDD VSS.t2316 VDD VDD sg13_lv_pmos ad=0.19p pd=1.38u as=0 ps=0 w=1u l=1u
X1366 VSS.t1650 VDD VSS.t1652 VSS.t1651 sg13_lv_nmos ad=79.8f pd=0.8u as=0 ps=0 w=0.42u l=1u
X1367 VSS.t508 VDD VSS.t508 VSS.t511 sg13_lv_nmos ad=0.1428p pd=1.52u as=0 ps=0 w=0.42u l=1u
X1368 VSS.t241 a_27215_14845# a_27882_14484# VSS.t11 sg13_lv_nmos ad=0.1406p pd=1.12u as=0.2516p ps=2.16u w=0.74u l=0.13u
X1369 VDD VSS.t2735 VDD VDD sg13_lv_pmos ad=0.34p pd=2.68u as=0 ps=0 w=1u l=1u
X1370 VSS.t1268 VDD VSS.t1267 VSS.t1154 sg13_lv_nmos ad=0.1428p pd=1.52u as=0 ps=0 w=0.42u l=1u
X1371 VDD VSS.t1280 VDD VDD sg13_lv_pmos ad=0.19p pd=1.38u as=0 ps=0 w=1u l=1u
X1372 VDD VSS.t2099 VDD VDD sg13_lv_pmos ad=0.19p pd=1.38u as=0 ps=0 w=1u l=1u
X1373 VSS.t98 VDD VSS.t209 VSS.t518 sg13_lv_nmos ad=79.8f pd=0.8u as=0 ps=0 w=0.42u l=1u
X1374 VSS.t608 VDD VSS.t608 VSS.t609 sg13_lv_nmos ad=79.8f pd=0.8u as=0 ps=0 w=0.42u l=1u
X1375 sg13cmos5l_a21oi_1_3.Y sg13cmos5l_a21oi_1_3.B1 a_25109_12972# VDD sg13_lv_pmos ad=0.3808p pd=2.92u as=0.2128p ps=1.5u w=1.12u l=0.13u
X1376 VSS.t964 VDD VSS.t966 VSS.t965 sg13_lv_nmos ad=79.8f pd=0.8u as=0 ps=0 w=0.42u l=1u
X1377 a_26373_16033# a_26373_16033# VSS.t75 VSS.t222 sg13_lv_nmos ad=0.111p pd=1.34u as=7.70437p ps=50.66u w=0.3u l=0.13u
X1378 a_4377_15549# a_3435_15356# a_4175_15311# VDD sg13_lv_pmos ad=93.45f pd=0.865u as=0.2048p ps=1.63u w=0.42u l=0.13u
X1379 VSS.t420 VDD VSS.t421 VSS.t11 sg13_lv_nmos ad=79.8f pd=0.8u as=0 ps=0 w=0.42u l=1u
X1380 VDD VSS.t3011 VDD VDD sg13_lv_pmos ad=0.34p pd=2.68u as=0 ps=0 w=1u l=1u
X1381 VSS.t2229 VDD VSS.t2231 VSS.t2230 sg13_lv_nmos ad=79.8f pd=0.8u as=0 ps=0 w=0.42u l=1u
X1382 VDD VSS.t2466 VDD VDD sg13_lv_pmos ad=0.19p pd=1.38u as=0 ps=0 w=1u l=1u
X1383 VSS.t794 VDD VSS.t796 VSS.t795 sg13_lv_nmos ad=79.8f pd=0.8u as=0 ps=0 w=0.42u l=1u
X1384 VDD VSS.t1647 VDD VDD sg13_lv_pmos ad=0.19p pd=1.38u as=0 ps=0 w=1u l=1u
X1385 VSS.t286 VDD VSS.t283 VSS.t285 sg13_lv_nmos ad=0.1428p pd=1.52u as=0 ps=0 w=0.42u l=1u
X1386 VDD VSS.t27 VDD VDD sg13_lv_pmos ad=0.19p pd=1.38u as=0 ps=0 w=1u l=1u
X1387 VSS.t1450 VDD VSS.t1449 VSS.t1448 sg13_lv_nmos ad=0.1428p pd=1.52u as=0 ps=0 w=0.42u l=1u
X1388 a_7680_15549# sg13cmos5l_nand3_1_0.Y a_7643_15280# VSS.t3178 sg13_lv_nmos ad=0.2176p pd=1.96u as=78.39999f ps=0.885u w=0.64u l=0.13u
X1389 sg13cmos5l_dfrbpq_1_6.Q a_22986_14484# VDD VDD sg13_lv_pmos ad=0.3808p pd=2.92u as=0.2128p ps=1.5u w=1.12u l=0.13u
X1390 VSS.t1277 VDD VSS.t1276 VSS.t1154 sg13_lv_nmos ad=0.1428p pd=1.52u as=0 ps=0 w=0.42u l=1u
X1391 VDD VSS.t2624 VDD VDD sg13_lv_pmos ad=0.34p pd=2.68u as=0 ps=0 w=1u l=1u
X1392 VDD VSS.t1200 VDD VDD sg13_lv_pmos ad=0.34p pd=2.68u as=0 ps=0 w=1u l=1u
X1393 VSS.t2012 VDD VSS.t2011 VSS.t2010 sg13_lv_nmos ad=0.1428p pd=1.52u as=0 ps=0 w=0.42u l=1u
X1394 VSS.t1445 VDD VSS.t1444 VSS.t1443 sg13_lv_nmos ad=0.1428p pd=1.52u as=0 ps=0 w=0.42u l=1u
X1395 VDD VSS.t1172 VDD VDD sg13_lv_pmos ad=0.19p pd=1.38u as=0 ps=0 w=1u l=1u
X1396 VSS.t2636 VDD VSS.t2636 VSS.t198 sg13_lv_nmos ad=0.1428p pd=1.52u as=0 ps=0 w=0.42u l=1u
X1397 VSS.t274 VDD VSS.t269 VSS.t273 sg13_lv_nmos ad=0.1428p pd=1.52u as=0 ps=0 w=0.42u l=1u
X1398 sg13cmos5l_dfrbpq_1_3.D a_17238_15302# VSS.t13 VSS.t12 sg13_lv_nmos ad=0.2516p pd=2.16u as=0.1426p ps=1.16u w=0.74u l=0.13u
X1399 VSS.t1282 VDD VSS.t1281 VSS.t1154 sg13_lv_nmos ad=0.1428p pd=1.52u as=0 ps=0 w=0.42u l=1u
X1400 VSS.t2691 VDD VSS.t2693 VSS.t198 sg13_lv_nmos ad=79.8f pd=0.8u as=0 ps=0 w=0.42u l=1u
X1401 VSS.t2354 VDD VSS.t2356 VSS.t2355 sg13_lv_nmos ad=79.8f pd=0.8u as=0 ps=0 w=0.42u l=1u
X1402 VDD VSS.t3044 VDD VDD sg13_lv_pmos ad=0.19p pd=1.38u as=0 ps=0 w=1u l=1u
X1403 VSS.t2449 VDD VSS.t2448 VSS.t2447 sg13_lv_nmos ad=0.1428p pd=1.52u as=0 ps=0 w=0.42u l=1u
X1404 VDD VSS.t2261 VDD VDD sg13_lv_pmos ad=0.19p pd=1.38u as=0 ps=0 w=1u l=1u
X1405 a_9444_15552# a_9418_15457# VSS.t1 VSS.t92 sg13_lv_nmos ad=0.2516p pd=2.16u as=0.1626p ps=1.415u w=0.74u l=0.13u
X1406 VSS.t23 VDD VSS.t145 VSS.t717 sg13_lv_nmos ad=79.8f pd=0.8u as=0 ps=0 w=0.42u l=1u
X1407 VDD VSS.t593 VDD VDD sg13_lv_pmos ad=0.34p pd=2.68u as=0 ps=0 w=1u l=1u
X1408 VSS.t397 VDD VSS.t123 VSS.t64 sg13_lv_nmos ad=0.1428p pd=1.52u as=0 ps=0 w=0.42u l=1u
X1409 sg13cmos5l_a21oi_1_3.B1 sg13cmos5l_buf_1_10.X VSS.t111 VSS.t110 sg13_lv_nmos ad=0.2516p pd=2.16u as=0.2516p ps=2.16u w=0.74u l=0.13u
X1410 VSS.t2709 VDD VSS.t2841 VSS.t198 sg13_lv_nmos ad=0.1428p pd=1.52u as=0 ps=0 w=0.42u l=1u
X1411 VDD VSS.t568 VDD VDD sg13_lv_pmos ad=0.19p pd=1.38u as=0 ps=0 w=1u l=1u
X1412 VSS.t994 VDD VSS.t996 VSS.t995 sg13_lv_nmos ad=79.8f pd=0.8u as=0 ps=0 w=0.42u l=1u
X1413 VDD VSS.t2451 VDD VDD sg13_lv_pmos ad=0.19p pd=1.38u as=0 ps=0 w=1u l=1u
X1414 VSS.t21 sg13cmos5l_nor2_1_0.B sg13cmos5l_dfrbpq_1_2.D VSS.t3277 sg13_lv_nmos ad=0.2516p pd=2.16u as=0.1406p ps=1.12u w=0.74u l=0.13u
X1415 VDD VSS.t1180 VDD VDD sg13_lv_pmos ad=0.19p pd=1.38u as=0 ps=0 w=1u l=1u
X1416 VDD sg13cmos5l_xor2_1_0.B a_2516_14484# VDD sg13_lv_pmos ad=0.2128p pd=1.5u as=0.2128p ps=1.5u w=1.12u l=0.13u
X1417 a_20774_14922# sg13cmos5l_dfrbpq_1_6.D VDD VDD sg13_lv_pmos ad=79.8f pd=0.8u as=0.1428p ps=1.52u w=0.42u l=0.13u
X1418 VSS.t1640 VDD VSS.t1642 VSS.t1641 sg13_lv_nmos ad=79.8f pd=0.8u as=0 ps=0 w=0.42u l=1u
X1419 VSS.t3157 VDD VSS.t3159 VSS.t3158 sg13_lv_nmos ad=79.8f pd=0.8u as=0 ps=0 w=0.42u l=1u
X1420 VDD VSS.t1564 VDD VDD sg13_lv_pmos ad=0.34p pd=2.68u as=0 ps=0 w=1u l=1u
X1421 VSS.t2032 VDD VSS.t2031 VSS.t2030 sg13_lv_nmos ad=0.1428p pd=1.52u as=0 ps=0 w=0.42u l=1u
X1422 a_17327_13799# a_16485_13701# a_17233_13799# VSS.t3197 sg13_lv_nmos ad=0.12665p pd=1.145u as=0.1428p ps=1.52u w=0.42u l=0.13u
X1423 VDD VSS.t59 VDD VDD sg13_lv_pmos ad=0.34p pd=2.68u as=0 ps=0 w=1u l=1u
X1424 VDD VSS.t2478 VDD VDD sg13_lv_pmos ad=0.34p pd=2.68u as=0 ps=0 w=1u l=1u
X1425 VDD VSS.t798 VDD VDD sg13_lv_pmos ad=0.34p pd=2.68u as=0 ps=0 w=1u l=1u
X1426 VSS.t1635 VDD VSS.t1637 VSS.t1636 sg13_lv_nmos ad=79.8f pd=0.8u as=0 ps=0 w=0.42u l=1u
X1427 VSS.t1295 VDD VSS.t1294 VSS.t1154 sg13_lv_nmos ad=0.1428p pd=1.52u as=0 ps=0 w=0.42u l=1u
X1428 VDD VSS.t2506 VDD VDD sg13_lv_pmos ad=0.19p pd=1.38u as=0 ps=0 w=1u l=1u
X1429 VSS.t964 VDD VSS.t966 VSS.t965 sg13_lv_nmos ad=79.8f pd=0.8u as=0 ps=0 w=0.42u l=1u
X1430 VDD VSS.t1169 VDD VDD sg13_lv_pmos ad=0.34p pd=2.68u as=0 ps=0 w=1u l=1u
X1431 VDD VSS.t1946 VDD VDD sg13_lv_pmos ad=0.34p pd=2.68u as=0 ps=0 w=1u l=1u
X1432 VSS.t236 a_21562_15960# a_21281_16262# VSS.t237 sg13_lv_nmos ad=79.8f pd=0.8u as=0.1428p ps=1.52u w=0.42u l=0.5u
X1433 VSS.t346 VDD VSS.t345 VSS.t344 sg13_lv_nmos ad=0.1428p pd=1.52u as=0 ps=0 w=0.42u l=1u
X1434 a_2490_14447# sg13cmos5l_xor2_1_0.B VSS.t187 VSS.t186 sg13_lv_nmos ad=0.17462p pd=1.185u as=0.15245p ps=1.17u w=0.55u l=0.13u
X1435 VDD VSS.t3064 VDD VDD sg13_lv_pmos ad=0.19p pd=1.38u as=0 ps=0 w=1u l=1u
X1436 VDD VSS.t2281 VDD VDD sg13_lv_pmos ad=0.19p pd=1.38u as=0 ps=0 w=1u l=1u
X1437 VSS.t2112 VDD VSS.t2114 VSS.t2113 sg13_lv_nmos ad=79.8f pd=0.8u as=0 ps=0 w=0.42u l=1u
X1438 VSS.t314 VDD VSS.t313 VSS.t312 sg13_lv_nmos ad=0.1428p pd=1.52u as=0 ps=0 w=0.42u l=1u
X1439 sg13cmos5l_and2_1_1.X a_5613_14832# VDD VDD sg13_lv_pmos ad=0.3808p pd=2.92u as=0.1918p ps=1.5u w=1.12u l=0.13u
X1440 VDD VSS.t439 VDD VDD sg13_lv_pmos ad=0.19p pd=1.38u as=0 ps=0 w=1u l=1u
X1441 VDD VSS.t851 VDD VDD sg13_lv_pmos ad=0.19p pd=1.38u as=0 ps=0 w=1u l=1u
X1442 VSS.t2701 VDD VSS.t2700 VSS.t198 sg13_lv_nmos ad=0.1428p pd=1.52u as=0 ps=0 w=0.42u l=1u
X1443 VSS.t59 a_27500_15960# counter_value_o[5] VSS.t58 sg13_lv_nmos ad=0.14875p pd=1.16u as=0.2886p ps=2.26u w=0.74u l=0.13u
X1444 VDD VSS.t1016 VDD VDD sg13_lv_pmos ad=0.19p pd=1.38u as=0 ps=0 w=1u l=1u
X1445 VDD VSS.t1271 VDD VDD sg13_lv_pmos ad=0.19p pd=1.38u as=0 ps=0 w=1u l=1u
X1446 VDD VSS.t1577 VDD VDD sg13_lv_pmos ad=0.19p pd=1.38u as=0 ps=0 w=1u l=1u
X1447 VDD VSS.t1954 VDD VDD sg13_lv_pmos ad=0.19p pd=1.38u as=0 ps=0 w=1u l=1u
X1448 VDD VSS.t3091 VDD VDD sg13_lv_pmos ad=0.34p pd=2.68u as=0 ps=0 w=1u l=1u
X1449 VSS.t3142 VDD VSS.t3144 VSS.t3143 sg13_lv_nmos ad=79.8f pd=0.8u as=0 ps=0 w=0.42u l=1u
X1450 VSS.t2062 VDD VSS.t2064 VSS.t2063 sg13_lv_nmos ad=79.8f pd=0.8u as=0 ps=0 w=0.42u l=1u
X1451 VSS.t2666 VDD VSS.t2665 VSS.t198 sg13_lv_nmos ad=0.1428p pd=1.52u as=0 ps=0 w=0.42u l=1u
X1452 a_4432_15454# a_4175_15311# a_4594_15234# VSS.t45 sg13_lv_nmos ad=0.1428p pd=1.52u as=37.8f ps=0.6u w=0.42u l=0.13u
X1453 VSS.t884 VDD VSS.t886 VSS.t885 sg13_lv_nmos ad=79.8f pd=0.8u as=0 ps=0 w=0.42u l=1u
X1454 sg13cmos5l_dfrbpq_1_6.Q a_22986_14484# VSS.t123 VSS.t4 sg13_lv_nmos ad=0.2516p pd=2.16u as=0.1406p ps=1.12u w=0.74u l=0.13u
X1455 a_6202_15238# sg13cmos5l_dlygate4sd3_1_3.A VSS.t11 VSS.t3233 sg13_lv_nmos ad=0.1406p pd=1.12u as=0.2516p ps=2.16u w=0.74u l=0.13u
X1456 a_7829_15238# sg13cmos5l_nand3_1_0.Y VSS.t184 VSS.t3179 sg13_lv_nmos ad=0.1406p pd=1.12u as=0.1898p ps=1.36u w=0.74u l=0.13u
X1457 VSS.t129 a_10618_14448# a_10337_14750# VSS.t3199 sg13_lv_nmos ad=79.8f pd=0.8u as=0.1428p ps=1.52u w=0.42u l=0.5u
X1458 VDD VSS.t953 VDD VDD sg13_lv_pmos ad=0.34p pd=2.68u as=0 ps=0 w=1u l=1u
X1459 VDD VSS.t2321 VDD VDD sg13_lv_pmos ad=0.19p pd=1.38u as=0 ps=0 w=1u l=1u
X1460 VSS.t1982 VDD VSS.t1981 VSS.t1980 sg13_lv_nmos ad=0.1428p pd=1.52u as=0 ps=0 w=0.42u l=1u
X1461 VDD VSS.t1979 VDD VDD sg13_lv_pmos ad=0.19p pd=1.38u as=0 ps=0 w=1u l=1u
X1462 VDD sg13cmos5l_or3_1_2.A sg13cmos5l_o21ai_1_1.Y VDD sg13_lv_pmos ad=0.3808p pd=2.92u as=0.2128p ps=1.5u w=1.12u l=0.15u
X1463 VSS.t1309 VDD VSS.t1308 VSS.t1154 sg13_lv_nmos ad=0.1428p pd=1.52u as=0 ps=0 w=0.42u l=1u
X1464 a_2630_15234# sg13cmos5l_and2_1_0.X VDD VDD sg13_lv_pmos ad=79.8f pd=0.8u as=0.1428p ps=1.52u w=0.42u l=0.13u
X1465 VSS.t2339 VDD VSS.t2341 VSS.t2340 sg13_lv_nmos ad=79.8f pd=0.8u as=0 ps=0 w=0.42u l=1u
X1466 VDD VSS.t2104 VDD VDD sg13_lv_pmos ad=0.19p pd=1.38u as=0 ps=0 w=1u l=1u
X1467 a_6372_14488# a_6346_14452# VSS.t11 VSS.t177 sg13_lv_nmos ad=0.2516p pd=2.16u as=0.1626p ps=1.415u w=0.74u l=0.13u
X1468 VDD VSS.t419 VDD VDD sg13_lv_pmos ad=0.34p pd=2.68u as=0 ps=0 w=1u l=1u
X1469 VSS.t1892 VDD VSS.t1894 VSS.t1893 sg13_lv_nmos ad=79.8f pd=0.8u as=0 ps=0 w=0.42u l=1u
X1470 VSS.t2737 VDD VSS.t2738 VSS.t198 sg13_lv_nmos ad=79.8f pd=0.8u as=0 ps=0 w=0.42u l=1u
X1471 VDD VSS.t629 VDD VDD sg13_lv_pmos ad=0.34p pd=2.68u as=0 ps=0 w=1u l=1u
X1472 VDD VSS.t1252 VDD VDD sg13_lv_pmos ad=0.34p pd=2.68u as=0 ps=0 w=1u l=1u
X1473 VSS.t75 a_26249_16334# a_26170_16237# VSS.t219 sg13_lv_nmos ad=7.70437p pd=50.66u as=0.27427p ps=2.28u w=0.795u l=0.13u
X1474 VDD VSS.t351 VDD VDD sg13_lv_pmos ad=0.19p pd=1.38u as=0 ps=0 w=1u l=1u
X1475 VDD VSS.t568 VDD VDD sg13_lv_pmos ad=0.19p pd=1.38u as=0 ps=0 w=1u l=1u
X1476 VSS.t994 VDD VSS.t996 VSS.t995 sg13_lv_nmos ad=79.8f pd=0.8u as=0 ps=0 w=0.42u l=1u
X1477 a_8050_14922# sg13cmos5l_dfrbpq_1_1.RESET_B VSS.t184 VSS.t210 sg13_lv_nmos ad=37.8f pd=0.6u as=79.8f ps=0.8u w=0.42u l=0.13u
X1478 VDD VSS.t968 VDD VDD sg13_lv_pmos ad=0.34p pd=2.68u as=0 ps=0 w=1u l=1u
X1479 VDD VSS.t1617 VDD VDD sg13_lv_pmos ad=0.19p pd=1.38u as=0 ps=0 w=1u l=1u
X1480 VDD VSS.t3076 VDD VDD sg13_lv_pmos ad=0.34p pd=2.68u as=0 ps=0 w=1u l=1u
X1481 VDD VSS.t2293 VDD VDD sg13_lv_pmos ad=0.34p pd=2.68u as=0 ps=0 w=1u l=1u
X1482 VSS.t854 VDD VSS.t853 VSS.t852 sg13_lv_nmos ad=0.1428p pd=1.52u as=0 ps=0 w=0.42u l=1u
X1483 VSS.t1195 VDD VSS.t1196 VSS.t1154 sg13_lv_nmos ad=79.8f pd=0.8u as=0 ps=0 w=0.42u l=1u
X1484 VDD VSS.t2628 VDD VDD sg13_lv_pmos ad=0.34p pd=2.68u as=0 ps=0 w=1u l=1u
X1485 VDD VSS.t1290 VDD VDD sg13_lv_pmos ad=0.19p pd=1.38u as=0 ps=0 w=1u l=1u
X1486 VDD VSS.t1899 VDD VDD sg13_lv_pmos ad=0.19p pd=1.38u as=0 ps=0 w=1u l=1u
X1487 VDD VSS.t2721 VDD VDD sg13_lv_pmos ad=0.19p pd=1.38u as=0 ps=0 w=1u l=1u
X1488 VSS.t2017 VDD VSS.t2016 VSS.t2015 sg13_lv_nmos ad=0.1428p pd=1.52u as=0 ps=0 w=0.42u l=1u
X1489 VSS.t1580 VDD VSS.t1579 VSS.t1578 sg13_lv_nmos ad=0.1428p pd=1.52u as=0 ps=0 w=0.42u l=1u
X1490 VSS.t3097 VDD VSS.t3096 VSS.t3095 sg13_lv_nmos ad=0.1428p pd=1.52u as=0 ps=0 w=0.42u l=1u
X1491 VSS.t629 VDD VSS.t632 VSS.t757 sg13_lv_nmos ad=79.8f pd=0.8u as=0 ps=0 w=0.42u l=1u
X1492 VDD VSS.t2491 VDD VDD sg13_lv_pmos ad=0.19p pd=1.38u as=0 ps=0 w=1u l=1u
X1493 sg13cmos5l_dlygate4sd3_1_8.A a_11370_15532# VDD VDD sg13_lv_pmos ad=0.3808p pd=2.92u as=0.2128p ps=1.5u w=1.12u l=0.13u
X1494 sg13cmos5l_a21oi_1_1.Y sg13cmos5l_a21oi_1_3.B1 VSS.t19 VSS.t18 sg13_lv_nmos ad=0.1406p pd=1.12u as=0.2516p ps=2.16u w=0.74u l=0.13u
X1495 VSS.t914 VDD VSS.t916 VSS.t915 sg13_lv_nmos ad=79.8f pd=0.8u as=0 ps=0 w=0.42u l=1u
X1496 VDD VSS.t1931 VDD VDD sg13_lv_pmos ad=0.34p pd=2.68u as=0 ps=0 w=1u l=1u
X1497 VDD VSS.t781 VDD VDD sg13_lv_pmos ad=0.19p pd=1.38u as=0 ps=0 w=1u l=1u
X1498 VDD VSS.t3049 VDD VDD sg13_lv_pmos ad=0.19p pd=1.38u as=0 ps=0 w=1u l=1u
X1499 VSS.t2324 VDD VSS.t2326 VSS.t2325 sg13_lv_nmos ad=79.8f pd=0.8u as=0 ps=0 w=0.42u l=1u
X1500 VDD VSS.t2266 VDD VDD sg13_lv_pmos ad=0.19p pd=1.38u as=0 ps=0 w=1u l=1u
X1501 VSS.t291 VDD VSS.t291 VSS.t292 sg13_lv_nmos ad=79.8f pd=0.8u as=0 ps=0 w=0.42u l=1u
X1502 VSS.t1715 VDD VSS.t1717 VSS.t1716 sg13_lv_nmos ad=79.8f pd=0.8u as=0 ps=0 w=0.42u l=1u
X1503 VSS.t2097 VDD VSS.t2099 VSS.t2098 sg13_lv_nmos ad=79.8f pd=0.8u as=0 ps=0 w=0.42u l=1u
X1504 VDD VSS.t3 VDD VDD sg13_lv_pmos ad=0.19p pd=1.38u as=0 ps=0 w=1u l=1u
X1505 VSS.t814 VDD VSS.t816 VSS.t815 sg13_lv_nmos ad=79.8f pd=0.8u as=0 ps=0 w=0.42u l=1u
X1506 VSS.t1967 VDD VSS.t1969 VSS.t1968 sg13_lv_nmos ad=79.8f pd=0.8u as=0 ps=0 w=0.42u l=1u
X1507 VDD VSS.t427 VDD VDD sg13_lv_pmos ad=0.19p pd=1.38u as=0 ps=0 w=1u l=1u
X1508 VSS.t884 VDD VSS.t886 VSS.t885 sg13_lv_nmos ad=79.8f pd=0.8u as=0 ps=0 w=0.42u l=1u
X1509 VDD VSS.t873 VDD VDD sg13_lv_pmos ad=0.34p pd=2.68u as=0 ps=0 w=1u l=1u
X1510 VSS.t1645 VDD VSS.t1647 VSS.t1646 sg13_lv_nmos ad=79.8f pd=0.8u as=0 ps=0 w=0.42u l=1u
X1511 a_19323_13726# sg13cmos5l_buf_8_2.A VDD VDD sg13_lv_pmos ad=0.2128p pd=1.5u as=0.2128p ps=1.5u w=1.12u l=0.13u
X1512 VSS.t929 VDD VSS.t931 VSS.t930 sg13_lv_nmos ad=79.8f pd=0.8u as=0 ps=0 w=0.42u l=1u
X1513 VDD VSS.t1569 VDD VDD sg13_lv_pmos ad=0.34p pd=2.68u as=0 ps=0 w=1u l=1u
X1514 VDD VSS.t1449 VDD VDD sg13_lv_pmos ad=0.34p pd=2.68u as=0 ps=0 w=1u l=1u
X1515 VSS.t3127 VDD VSS.t3129 VSS.t3128 sg13_lv_nmos ad=79.8f pd=0.8u as=0 ps=0 w=0.42u l=1u
X1516 VSS.t2658 VDD VSS.t2658 VSS.t198 sg13_lv_nmos ad=0.1428p pd=1.52u as=0 ps=0 w=0.42u l=1u
X1517 VDD sg13cmos5l_buf_8_2.A a_12010_15202# VDD sg13_lv_pmos ad=0.2128p pd=1.5u as=0.2128p ps=1.5u w=1.12u l=0.13u
X1518 VSS.t576 VDD VSS.t576 VSS.t575 sg13_lv_nmos ad=0.1428p pd=1.52u as=0 ps=0 w=0.42u l=1u
X1519 VDD VSS.t998 VDD VDD sg13_lv_pmos ad=0.34p pd=2.68u as=0 ps=0 w=1u l=1u
X1520 VSS.t2249 VDD VSS.t2248 VSS.t2247 sg13_lv_nmos ad=0.1428p pd=1.52u as=0 ps=0 w=0.42u l=1u
X1521 VDD a_22426_15202# a_22145_15424# VDD sg13_lv_pmos ad=0.1523p pd=1.38u as=0.34p ps=2.68u w=1u l=0.5u
X1522 VSS.t611 VDD VSS.t611 VSS.t744 sg13_lv_nmos ad=0.1428p pd=1.52u as=0 ps=0 w=0.42u l=1u
X1523 VDD VSS.t2483 VDD VDD sg13_lv_pmos ad=0.34p pd=2.68u as=0 ps=0 w=1u l=1u
X1524 a_22508_15960# sg13cmos5l_dfrbpq_1_3.Q VDD VDD sg13_lv_pmos ad=0.2856p pd=2.36u as=0.2114p ps=1.54u w=0.84u l=0.13u
X1525 VDD VSS.t936 VDD VDD sg13_lv_pmos ad=0.19p pd=1.38u as=0 ps=0 w=1u l=1u
X1526 VDD VSS.t1223 VDD VDD sg13_lv_pmos ad=0.19p pd=1.38u as=0 ps=0 w=1u l=1u
X1527 VSS.t1187 VDD VSS.t1186 VSS.t1154 sg13_lv_nmos ad=0.1428p pd=1.52u as=0 ps=0 w=0.42u l=1u
X1528 VSS.t1228 VDD VSS.t1229 VSS.t1154 sg13_lv_nmos ad=79.8f pd=0.8u as=0 ps=0 w=0.42u l=1u
X1529 sg13cmos5l_dfrbpq_1_2.CLK a_12010_15202# VSS.t30 VSS.t33 sg13_lv_nmos ad=0.1406p pd=1.12u as=0.1406p ps=1.12u w=0.74u l=0.13u
X1530 VDD VSS.t23 VDD VDD sg13_lv_pmos ad=0.34p pd=2.68u as=0 ps=0 w=1u l=1u
X1531 VDD VSS.t1274 VDD VDD sg13_lv_pmos ad=0.19p pd=1.38u as=0 ps=0 w=1u l=1u
X1532 VDD VSS.t2770 VDD VDD sg13_lv_pmos ad=0.19p pd=1.38u as=0 ps=0 w=1u l=1u
X1533 VSS.t1700 VDD VSS.t1702 VSS.t1701 sg13_lv_nmos ad=79.8f pd=0.8u as=0 ps=0 w=0.42u l=1u
X1534 VSS.t2504 VDD VSS.t2503 VSS.t2502 sg13_lv_nmos ad=0.1428p pd=1.52u as=0 ps=0 w=0.42u l=1u
X1535 VSS.t1877 VDD VSS.t1879 VSS.t1878 sg13_lv_nmos ad=79.8f pd=0.8u as=0 ps=0 w=0.42u l=1u
X1536 VDD VSS.t101 VDD VDD sg13_lv_pmos ad=0.34p pd=2.68u as=0 ps=0 w=1u l=1u
X1537 VDD a_18863_14845# a_19120_14726# VDD sg13_lv_pmos ad=2.42015p pd=15.68u as=79.8f ps=0.8u w=0.42u l=0.13u
X1538 VSS.t1192 VDD VSS.t1191 VSS.t1154 sg13_lv_nmos ad=0.1428p pd=1.52u as=0 ps=0 w=0.42u l=1u
X1539 VSS.t355 VDD VSS.t355 VSS.t357 sg13_lv_nmos ad=0.1428p pd=1.52u as=0 ps=0 w=0.42u l=1u
X1540 a_20218_15238# sg13cmos5l_dfrbpq_1_2.Q VSS.t3225 VSS.t18 sg13_lv_nmos ad=0.1406p pd=1.12u as=0.2516p ps=2.16u w=0.74u l=0.13u
X1541 sg13cmos5l_o21ai_1_2.A2 sg13cmos5l_dfrbpq_1_6.Q a_23480_15242# VSS.t64 sg13_lv_nmos ad=0.2516p pd=2.16u as=0.1406p ps=1.12u w=0.74u l=0.13u
X1542 a_15338_14484# sg13cmos5l_a21oi_1_3.B1 VDD VDD sg13_lv_pmos ad=0.1176p pd=1.33u as=0.4032p ps=2.96u w=1.12u l=0.13u
X1543 VSS.t2703 VDD VSS.t2703 VSS.t198 sg13_lv_nmos ad=0.1428p pd=1.52u as=0 ps=0 w=0.42u l=1u
X1544 VDD VSS.t400 VDD VDD sg13_lv_pmos ad=0.19p pd=1.38u as=0 ps=0 w=1u l=1u
X1545 VSS.t854 VDD VSS.t853 VSS.t852 sg13_lv_nmos ad=0.1428p pd=1.52u as=0 ps=0 w=0.42u l=1u
X1546 VSS.t969 VDD VSS.t971 VSS.t970 sg13_lv_nmos ad=79.8f pd=0.8u as=0 ps=0 w=0.42u l=1u
X1547 VDD VSS.t1959 VDD VDD sg13_lv_pmos ad=0.19p pd=1.38u as=0 ps=0 w=1u l=1u
X1548 sg13cmos5l_dlygate4sd3_1_5.A sg13cmos5l_dlygate4sd3_1_4.X a_18454_16374# VSS.t3263 sg13_lv_nmos ad=0.2516p pd=2.16u as=0.1406p ps=1.12u w=0.74u l=0.15u
X1549 VSS.t414 VDD VSS.t415 VSS.t11 sg13_lv_nmos ad=79.8f pd=0.8u as=0 ps=0 w=0.42u l=1u
X1550 VDD VSS.t3061 VDD VDD sg13_lv_pmos ad=0.34p pd=2.68u as=0 ps=0 w=1u l=1u
X1551 VDD VSS.t2278 VDD VDD sg13_lv_pmos ad=0.34p pd=2.68u as=0 ps=0 w=1u l=1u
X1552 VDD sg13cmos5l_dlygate4sd3_1_9.X a_20603_15532# VDD sg13_lv_pmos ad=0.2128p pd=1.5u as=0.2128p ps=1.5u w=1.12u l=0.13u
X1553 VDD VSS.t1602 VDD VDD sg13_lv_pmos ad=0.19p pd=1.38u as=0 ps=0 w=1u l=1u
X1554 VSS.t2067 VDD VSS.t2069 VSS.t2068 sg13_lv_nmos ad=79.8f pd=0.8u as=0 ps=0 w=0.42u l=1u
X1555 VSS.t2668 VDD VSS.t2668 VSS.t198 sg13_lv_nmos ad=0.1428p pd=1.52u as=0 ps=0 w=0.42u l=1u
X1556 VDD VSS.t1642 VDD VDD sg13_lv_pmos ad=0.19p pd=1.38u as=0 ps=0 w=1u l=1u
X1557 VDD VSS.t199 VDD VDD sg13_lv_pmos ad=0.34p pd=2.68u as=0 ps=0 w=1u l=1u
X1558 a_20376_14464# sg13cmos5l_or3_1_2.B VDD VDD sg13_lv_pmos ad=0.2128p pd=1.5u as=0.3808p ps=2.92u w=1.12u l=0.15u
X1559 sg13cmos5l_dfrbpq_1_5.D a_25206_14508# VSS.t5 VSS.t4 sg13_lv_nmos ad=0.2516p pd=2.16u as=0.1426p ps=1.16u w=0.74u l=0.13u
X1560 VDD VSS.t1204 VDD VDD sg13_lv_pmos ad=0.34p pd=2.68u as=0 ps=0 w=1u l=1u
X1561 VDD VSS.t1984 VDD VDD sg13_lv_pmos ad=0.19p pd=1.38u as=0 ps=0 w=1u l=1u
X1562 VSS.t914 VDD VSS.t916 VSS.t915 sg13_lv_nmos ad=79.8f pd=0.8u as=0 ps=0 w=0.42u l=1u
X1563 VDD VSS.t903 VDD VDD sg13_lv_pmos ad=0.34p pd=2.68u as=0 ps=0 w=1u l=1u
X1564 VSS.t1280 VDD VSS.t1279 VSS.t1154 sg13_lv_nmos ad=0.1428p pd=1.52u as=0 ps=0 w=0.42u l=1u
X1565 VSS.t503 VDD VSS.t503 VSS.t504 sg13_lv_nmos ad=0.1428p pd=1.52u as=0 ps=0 w=0.42u l=1u
X1566 VSS.t1241 VDD VSS.t1242 VSS.t1154 sg13_lv_nmos ad=79.8f pd=0.8u as=0 ps=0 w=0.42u l=1u
X1567 VDD VSS.t2761 VDD VDD sg13_lv_pmos ad=0.19p pd=1.38u as=0 ps=0 w=1u l=1u
X1568 VSS.t2489 VDD VSS.t2488 VSS.t2487 sg13_lv_nmos ad=0.1428p pd=1.52u as=0 ps=0 w=0.42u l=1u
X1569 VDD VSS.t355 VDD VDD sg13_lv_pmos ad=0.34p pd=2.68u as=0 ps=0 w=1u l=1u
X1570 sg13cmos5l_dfrbpq_1_2.CLK a_12010_15202# VSS.t27 VSS.t28 sg13_lv_nmos ad=0.1406p pd=1.12u as=0.1406p ps=1.12u w=0.74u l=0.13u
X1571 VSS.t1862 VDD VSS.t1864 VSS.t1863 sg13_lv_nmos ad=79.8f pd=0.8u as=0 ps=0 w=0.42u l=1u
X1572 VDD a_27407_13799# a_28074_14020# VDD sg13_lv_pmos ad=0.2128p pd=1.5u as=0.3864p ps=2.93u w=1.12u l=0.13u
X1573 VSS.t1655 VDD VSS.t1654 VSS.t1653 sg13_lv_nmos ad=0.1428p pd=1.52u as=0 ps=0 w=0.42u l=1u
X1574 VSS.t814 VDD VSS.t816 VSS.t815 sg13_lv_nmos ad=79.8f pd=0.8u as=0 ps=0 w=0.42u l=1u
X1575 VDD VSS.t2346 VDD VDD sg13_lv_pmos ad=0.19p pd=1.38u as=0 ps=0 w=1u l=1u
X1576 VSS.t719 VDD VSS.t721 VSS.t720 sg13_lv_nmos ad=79.8f pd=0.8u as=0 ps=0 w=0.42u l=1u
X1577 VDD VSS.t1281 VDD VDD sg13_lv_pmos ad=0.34p pd=2.68u as=0 ps=0 w=1u l=1u
X1578 VDD VSS.t1622 VDD VDD sg13_lv_pmos ad=0.19p pd=1.38u as=0 ps=0 w=1u l=1u
X1579 VSS.t929 VDD VSS.t931 VSS.t930 sg13_lv_nmos ad=79.8f pd=0.8u as=0 ps=0 w=0.42u l=1u
X1580 VSS.t1952 VDD VSS.t1954 VSS.t1953 sg13_lv_nmos ad=79.8f pd=0.8u as=0 ps=0 w=0.42u l=1u
X1581 sg13cmos5l_a21oi_1_0.A2 a_16969_16020# VDD VDD sg13_lv_pmos ad=0.3808p pd=2.92u as=0.3822p ps=1.84u w=1.12u l=0.13u
X1582 VDD VSS.t2724 VDD VDD sg13_lv_pmos ad=0.19p pd=1.38u as=0 ps=0 w=1u l=1u
X1583 VSS.t2022 VDD VSS.t2021 VSS.t2020 sg13_lv_nmos ad=0.1428p pd=1.52u as=0 ps=0 w=0.42u l=1u
X1584 VDD VSS.t418 VDD VDD sg13_lv_pmos ad=0.19p pd=1.38u as=0 ps=0 w=1u l=1u
X1585 VDD VSS.t1182 VDD VDD sg13_lv_pmos ad=0.19p pd=1.38u as=0 ps=0 w=1u l=1u
X1586 VSS.t2234 VDD VSS.t2233 VSS.t2232 sg13_lv_nmos ad=0.1428p pd=1.52u as=0 ps=0 w=0.42u l=1u
X1587 VDD VSS.t1649 VDD VDD sg13_lv_pmos ad=0.34p pd=2.68u as=0 ps=0 w=1u l=1u
X1588 VSS.t2779 VDD VSS.t2631 VSS.t198 sg13_lv_nmos ad=79.8f pd=0.8u as=0 ps=0 w=0.42u l=1u
X1589 VDD VSS.t981 VDD VDD sg13_lv_pmos ad=0.19p pd=1.38u as=0 ps=0 w=1u l=1u
X1590 VDD VSS.t2496 VDD VDD sg13_lv_pmos ad=0.19p pd=1.38u as=0 ps=0 w=1u l=1u
X1591 VSS.t162 a_19054_15423# sg13cmos5l_dlygate4sd3_1_4.X VSS.t18 sg13_lv_nmos ad=0.1426p pd=1.16u as=0.2516p ps=2.16u w=0.74u l=0.13u
X1592 a_16356_13735# a_16587_13844# a_16042_13945# VSS.t53 sg13_lv_nmos ad=0.2373p pd=1.97u as=79.8f ps=0.8u w=0.42u l=0.13u
X1593 VDD a_19323_13726# sg13cmos5l_buf_8_2.X VDD sg13_lv_pmos ad=0.2128p pd=1.5u as=0.2128p ps=1.5u w=1.12u l=0.13u
X1594 VDD VSS.t602 VDD VDD sg13_lv_pmos ad=0.19p pd=1.38u as=0 ps=0 w=1u l=1u
X1595 VSS.t1685 VDD VSS.t1687 VSS.t1686 sg13_lv_nmos ad=79.8f pd=0.8u as=0 ps=0 w=0.42u l=1u
X1596 VSS.t2102 VDD VSS.t2104 VSS.t2103 sg13_lv_nmos ad=79.8f pd=0.8u as=0 ps=0 w=0.42u l=1u
X1597 a_16294_13735# sg13cmos5l_dfrbpq_1_2.RESET_B VSS.t49 VSS.t249 sg13_lv_nmos ad=37.8f pd=0.6u as=0.1701p ps=1.65u w=0.42u l=0.13u
X1598 a_25956_13722# sg13cmos5l_dfrbpq_1_5.D a_25862_13722# VSS.t161 sg13_lv_nmos ad=60.89999f pd=0.71u as=0.1428p ps=1.52u w=0.42u l=0.13u
X1599 VSS.t849 VDD VSS.t851 VSS.t850 sg13_lv_nmos ad=79.8f pd=0.8u as=0 ps=0 w=0.42u l=1u
X1600 VSS.t969 VDD VSS.t971 VSS.t970 sg13_lv_nmos ad=79.8f pd=0.8u as=0 ps=0 w=0.42u l=1u
X1601 VDD VSS.t1996 VDD VDD sg13_lv_pmos ad=0.34p pd=2.68u as=0 ps=0 w=1u l=1u
X1602 VSS.t526 VDD VSS.t525 VSS.t524 sg13_lv_nmos ad=0.1428p pd=1.52u as=0 ps=0 w=0.42u l=1u
X1603 VSS.t1014 VDD VSS.t1016 VSS.t1015 sg13_lv_nmos ad=79.8f pd=0.8u as=0 ps=0 w=0.42u l=1u
X1604 VDD VSS.t3114 VDD VDD sg13_lv_pmos ad=0.19p pd=1.38u as=0 ps=0 w=1u l=1u
X1605 sg13cmos5l_nor2_1_0.B a_16140_15424# VDD VDD sg13_lv_pmos ad=0.2408p pd=1.55u as=0.3808p ps=2.92u w=1.12u l=0.13u
X1606 VSS.t2694 VDD VSS.t2694 VSS.t198 sg13_lv_nmos ad=0.1428p pd=1.52u as=0 ps=0 w=0.42u l=1u
X1607 VSS.t448 VDD VSS.t187 VSS.t447 sg13_lv_nmos ad=0.1428p pd=1.52u as=0 ps=0 w=0.42u l=1u
X1608 VDD VSS.t2687 VDD VDD sg13_lv_pmos ad=0.19p pd=1.38u as=0 ps=0 w=1u l=1u
X1609 VDD VSS.t1944 VDD VDD sg13_lv_pmos ad=0.19p pd=1.38u as=0 ps=0 w=1u l=1u
X1610 VSS.t2359 VDD VSS.t2358 VSS.t2357 sg13_lv_nmos ad=0.1428p pd=1.52u as=0 ps=0 w=0.42u l=1u
X1611 VSS.t2052 VDD VSS.t2054 VSS.t2053 sg13_lv_nmos ad=79.8f pd=0.8u as=0 ps=0 w=0.42u l=1u
X1612 VSS.t1615 VDD VSS.t1617 VSS.t1616 sg13_lv_nmos ad=79.8f pd=0.8u as=0 ps=0 w=0.42u l=1u
X1613 VSS.t3132 VDD VSS.t3134 VSS.t3133 sg13_lv_nmos ad=79.8f pd=0.8u as=0 ps=0 w=0.42u l=1u
X1614 VSS.t2661 VDD VSS.t2660 VSS.t198 sg13_lv_nmos ad=0.1428p pd=1.52u as=0 ps=0 w=0.42u l=1u
X1615 VDD VSS.t2291 VDD VDD sg13_lv_pmos ad=0.19p pd=1.38u as=0 ps=0 w=1u l=1u
X1616 VDD VSS.t1164 VDD VDD sg13_lv_pmos ad=0.34p pd=2.68u as=0 ps=0 w=1u l=1u
X1617 VDD VSS.t1627 VDD VDD sg13_lv_pmos ad=0.19p pd=1.38u as=0 ps=0 w=1u l=1u
X1618 VSS.t2007 VDD VSS.t2006 VSS.t2005 sg13_lv_nmos ad=0.1428p pd=1.52u as=0 ps=0 w=0.42u l=1u
X1619 VSS.t155 a_25786_15960# a_25505_16262# VSS.t3273 sg13_lv_nmos ad=79.8f pd=0.8u as=0.1428p ps=1.52u w=0.42u l=0.5u
X1620 VDD VSS.t818 VDD VDD sg13_lv_pmos ad=0.34p pd=2.68u as=0 ps=0 w=1u l=1u
X1621 VDD VSS.t1579 VDD VDD sg13_lv_pmos ad=0.34p pd=2.68u as=0 ps=0 w=1u l=1u
X1622 VSS.t2424 VDD VSS.t2426 VSS.t2425 sg13_lv_nmos ad=79.8f pd=0.8u as=0 ps=0 w=0.42u l=1u
X1623 VSS.t1897 VDD VSS.t1899 VSS.t1898 sg13_lv_nmos ad=79.8f pd=0.8u as=0 ps=0 w=0.42u l=1u
X1624 VSS.t1307 VDD VSS.t1306 VSS.t1154 sg13_lv_nmos ad=0.1428p pd=1.52u as=0 ps=0 w=0.42u l=1u
X1625 VDD VSS.t1634 VDD VDD sg13_lv_pmos ad=0.34p pd=2.68u as=0 ps=0 w=1u l=1u
X1626 VDD VSS.t2453 VDD VDD sg13_lv_pmos ad=0.34p pd=2.68u as=0 ps=0 w=1u l=1u
X1627 a_8218_13690# sg13cmos5l_dlygate4sd3_1_1.A VSS.t252 VSS.t3172 sg13_lv_nmos ad=0.1428p pd=1.52u as=79.8f ps=0.8u w=0.42u l=0.13u
X1628 VSS.t13 a_17126_15238# a_17238_15302# VSS.t3170 sg13_lv_nmos ad=0.1426p pd=1.16u as=0.1428p ps=1.52u w=0.42u l=0.5u
X1629 a_16042_13945# a_16485_13701# a_16425_14113# VDD sg13_lv_pmos ad=79.8f pd=0.8u as=63f ps=0.72u w=0.42u l=0.13u
X1630 VDD VSS.t871 VDD VDD sg13_lv_pmos ad=0.19p pd=1.38u as=0 ps=0 w=1u l=1u
X1631 VSS.t1312 VDD VSS.t1311 VSS.t1154 sg13_lv_nmos ad=0.1428p pd=1.52u as=0 ps=0 w=0.42u l=1u
X1632 VDD VSS.t555 VDD VDD sg13_lv_pmos ad=0.34p pd=2.68u as=0 ps=0 w=1u l=1u
X1633 VSS.t1847 VDD VSS.t1849 VSS.t1848 sg13_lv_nmos ad=79.8f pd=0.8u as=0 ps=0 w=0.42u l=1u
X1634 VDD VSS.t1313 VDD VDD sg13_lv_pmos ad=0.19p pd=1.38u as=0 ps=0 w=1u l=1u
X1635 VSS.t2707 VDD VSS.t2706 VSS.t198 sg13_lv_nmos ad=0.1428p pd=1.52u as=0 ps=0 w=0.42u l=1u
X1636 VSS.t322 sg13cmos5l_inv_1_0.Y a_18454_16374# VSS.t3269 sg13_lv_nmos ad=0.1406p pd=1.12u as=0.2516p ps=2.16u w=0.74u l=0.15u
X1637 VDD VSS.t3 VDD VDD sg13_lv_pmos ad=0.34p pd=2.68u as=0 ps=0 w=1u l=1u
X1638 VSS.t608 VDD VSS.t611 VSS.t743 sg13_lv_nmos ad=79.8f pd=0.8u as=0 ps=0 w=0.42u l=1u
X1639 VDD VSS.t2678 VDD VDD sg13_lv_pmos ad=0.19p pd=1.38u as=0 ps=0 w=1u l=1u
X1640 VDD VSS.t1964 VDD VDD sg13_lv_pmos ad=0.19p pd=1.38u as=0 ps=0 w=1u l=1u
X1641 VDD VSS.t3066 VDD VDD sg13_lv_pmos ad=0.34p pd=2.68u as=0 ps=0 w=1u l=1u
X1642 VDD VSS.t2283 VDD VDD sg13_lv_pmos ad=0.34p pd=2.68u as=0 ps=0 w=1u l=1u
X1643 VDD VSS.t1607 VDD VDD sg13_lv_pmos ad=0.19p pd=1.38u as=0 ps=0 w=1u l=1u
X1644 VSS.t1193 VDD VSS.t1194 VSS.t1154 sg13_lv_nmos ad=79.8f pd=0.8u as=0 ps=0 w=0.42u l=1u
X1645 VDD VSS.t973 VDD VDD sg13_lv_pmos ad=0.34p pd=2.68u as=0 ps=0 w=1u l=1u
X1646 VDD VSS.t1647 VDD VDD sg13_lv_pmos ad=0.19p pd=1.38u as=0 ps=0 w=1u l=1u
X1647 VDD VSS.t119 VDD VDD sg13_lv_pmos ad=0.34p pd=2.68u as=0 ps=0 w=1u l=1u
X1648 VSS.t11 a_26638_15423# sg13cmos5l_o21ai_1_2.B1 VSS.t3211 sg13_lv_nmos ad=0.1426p pd=1.16u as=0.2516p ps=2.16u w=0.74u l=0.13u
X1649 VDD VSS.t911 VDD VDD sg13_lv_pmos ad=0.19p pd=1.38u as=0 ps=0 w=1u l=1u
X1650 VSS.t1570 VDD VSS.t1569 VSS.t1568 sg13_lv_nmos ad=0.1428p pd=1.52u as=0 ps=0 w=0.42u l=1u
X1651 VSS.t3087 VDD VSS.t3086 VSS.t3085 sg13_lv_nmos ad=0.1428p pd=1.52u as=0 ps=0 w=0.42u l=1u
X1652 VDD VSS.t2296 VDD VDD sg13_lv_pmos ad=0.19p pd=1.38u as=0 ps=0 w=1u l=1u
X1653 VSS.t2621 VDD VSS.t2623 VSS.t198 sg13_lv_nmos ad=79.8f pd=0.8u as=0 ps=0 w=0.42u l=1u
X1654 VSS.t779 VDD VSS.t781 VSS.t780 sg13_lv_nmos ad=79.8f pd=0.8u as=0 ps=0 w=0.42u l=1u
X1655 VDD VSS.t2768 VDD VDD sg13_lv_pmos ad=0.19p pd=1.38u as=0 ps=0 w=1u l=1u
X1656 VDD VSS.t283 VDD VDD sg13_lv_pmos ad=0.34p pd=2.68u as=0 ps=0 w=1u l=1u
X1657 sg13cmos5l_dlygate4sd3_1_5.A sg13cmos5l_or3_1_2.B a_18552_15976# VDD sg13_lv_pmos ad=0.2128p pd=1.5u as=0.2128p ps=1.5u w=1.12u l=0.15u
X1658 VDD VSS.t1 VDD VDD sg13_lv_pmos ad=0.34p pd=2.68u as=0 ps=0 w=1u l=1u
X1659 VDD VSS.t632 VDD VDD sg13_lv_pmos ad=0.34p pd=2.68u as=0 ps=0 w=1u l=1u
X1660 VSS.t849 VDD VSS.t851 VSS.t850 sg13_lv_nmos ad=79.8f pd=0.8u as=0 ps=0 w=0.42u l=1u
X1661 VDD VSS.t838 VDD VDD sg13_lv_pmos ad=0.34p pd=2.68u as=0 ps=0 w=1u l=1u
X1662 VSS.t1867 VDD VSS.t1869 VSS.t1868 sg13_lv_nmos ad=79.8f pd=0.8u as=0 ps=0 w=0.42u l=1u
X1663 VSS.t1014 VDD VSS.t1016 VSS.t1015 sg13_lv_nmos ad=79.8f pd=0.8u as=0 ps=0 w=0.42u l=1u
X1664 VDD VSS.t1264 VDD VDD sg13_lv_pmos ad=0.34p pd=2.68u as=0 ps=0 w=1u l=1u
X1665 VSS.t593 VDD VSS.t180 VSS.t592 sg13_lv_nmos ad=0.1428p pd=1.52u as=0 ps=0 w=0.42u l=1u
X1666 VDD VSS.t87 VDD VDD sg13_lv_pmos ad=0.19p pd=1.38u as=0 ps=0 w=1u l=1u
X1667 VSS.t2409 VDD VSS.t2411 VSS.t2410 sg13_lv_nmos ad=79.8f pd=0.8u as=0 ps=0 w=0.42u l=1u
X1668 VDD VSS.t1981 VDD VDD sg13_lv_pmos ad=0.34p pd=2.68u as=0 ps=0 w=1u l=1u
X1669 VDD sg13cmos5l_nand3_1_0.Y a_7680_15549# VDD sg13_lv_pmos ad=0.2891p pd=1.695u as=0.1596p ps=1.22u w=0.84u l=0.13u
X1670 VDD VSS.t2351 VDD VDD sg13_lv_pmos ad=0.19p pd=1.38u as=0 ps=0 w=1u l=1u
X1671 VSS.t399 VDD VSS.t400 VSS.t11 sg13_lv_nmos ad=79.8f pd=0.8u as=0 ps=0 w=0.42u l=1u
X1672 VSS.t874 VDD VSS.t873 VSS.t872 sg13_lv_nmos ad=0.1428p pd=1.52u as=0 ps=0 w=0.42u l=1u
X1673 VDD VSS.t2106 VDD VDD sg13_lv_pmos ad=0.34p pd=2.68u as=0 ps=0 w=1u l=1u
X1674 VSS.t1207 VDD VSS.t1208 VSS.t1154 sg13_lv_nmos ad=79.8f pd=0.8u as=0 ps=0 w=0.42u l=1u
X1675 VSS.t1957 VDD VSS.t1959 VSS.t1958 sg13_lv_nmos ad=79.8f pd=0.8u as=0 ps=0 w=0.42u l=1u
X1676 VDD VSS.t1301 VDD VDD sg13_lv_pmos ad=0.19p pd=1.38u as=0 ps=0 w=1u l=1u
X1677 VSS.t1992 VDD VSS.t1991 VSS.t1990 sg13_lv_nmos ad=0.1428p pd=1.52u as=0 ps=0 w=0.42u l=1u
X1678 VSS.t629 VDD VSS.t629 VSS.t630 sg13_lv_nmos ad=79.8f pd=0.8u as=0 ps=0 w=0.42u l=1u
X1679 sg13cmos5l_nand3_1_0.Y sg13cmos5l_buf_1_0.X VDD VDD sg13_lv_pmos ad=0.3808p pd=2.92u as=0.2128p ps=1.5u w=1.12u l=0.13u
X1680 VSS.t1172 VDD VSS.t1172 VSS.t1154 sg13_lv_nmos ad=0.1428p pd=1.52u as=0 ps=0 w=0.42u l=1u
X1681 VSS.t934 VDD VSS.t936 VSS.t935 sg13_lv_nmos ad=79.8f pd=0.8u as=0 ps=0 w=0.42u l=1u
X1682 VDD VSS.t1564 VDD VDD sg13_lv_pmos ad=0.34p pd=2.68u as=0 ps=0 w=1u l=1u
X1683 VSS.t13 sg13cmos5l_a21oi_1_0.Y a_16856_15238# VSS.t3168 sg13_lv_nmos ad=79.8f pd=0.8u as=0.1428p ps=1.52u w=0.42u l=0.13u
X1684 VSS.t573 VDD VSS.t573 VSS.t693 sg13_lv_nmos ad=0.1428p pd=1.52u as=0 ps=0 w=0.42u l=1u
X1685 VDD VSS.t801 VDD VDD sg13_lv_pmos ad=0.19p pd=1.38u as=0 ps=0 w=1u l=1u
X1686 VDD VSS.t1619 VDD VDD sg13_lv_pmos ad=0.34p pd=2.68u as=0 ps=0 w=1u l=1u
X1687 VSS.t2987 VDD VSS.t2989 VSS.t2988 sg13_lv_nmos ad=79.8f pd=0.8u as=0 ps=0 w=0.42u l=1u
X1688 VSS.t2364 VDD VSS.t2363 VSS.t2362 sg13_lv_nmos ad=0.1428p pd=1.52u as=0 ps=0 w=0.42u l=1u
X1689 VSS.t1907 VDD VSS.t1909 VSS.t1908 sg13_lv_nmos ad=79.8f pd=0.8u as=0 ps=0 w=0.42u l=1u
X1690 VDD VSS.t2929 VDD VDD sg13_lv_pmos ad=0.19p pd=1.38u as=0 ps=0 w=1u l=1u
X1691 a_22030_15423# a_22145_15424# VDD VDD sg13_lv_pmos ad=0.34p pd=2.68u as=0.2254p ps=1.53u w=1u l=0.5u
X1692 VDD VSS.t555 VDD VDD sg13_lv_pmos ad=0.34p pd=2.68u as=0 ps=0 w=1u l=1u
X1693 VSS.t1690 VDD VSS.t1692 VSS.t1691 sg13_lv_nmos ad=79.8f pd=0.8u as=0 ps=0 w=0.42u l=1u
X1694 a_18106_15960# sg13cmos5l_dlygate4sd3_1_5.A VDD VDD sg13_lv_pmos ad=0.1428p pd=1.52u as=0.1523p ps=1.38u w=0.42u l=0.13u
X1695 VSS.t2770 VDD VSS.t2771 VSS.t198 sg13_lv_nmos ad=79.8f pd=0.8u as=0 ps=0 w=0.42u l=1u
X1696 VDD VSS.t2343 VDD VDD sg13_lv_pmos ad=0.34p pd=2.68u as=0 ps=0 w=1u l=1u
X1697 VDD VSS.t2001 VDD VDD sg13_lv_pmos ad=0.34p pd=2.68u as=0 ps=0 w=1u l=1u
X1698 sg13cmos5l_o21ai_1_1.Y sg13cmos5l_or3_1_2.A a_20278_14862# VSS.t9 sg13_lv_nmos ad=0.2516p pd=2.16u as=0.1406p ps=1.12u w=0.74u l=0.15u
X1699 VDD VSS.t1304 VDD VDD sg13_lv_pmos ad=0.19p pd=1.38u as=0 ps=0 w=1u l=1u
X1700 VSS.t503 VDD VSS.t503 VSS.t504 sg13_lv_nmos ad=0.1428p pd=1.52u as=0 ps=0 w=0.42u l=1u
X1701 VSS.t2697 VDD VSS.t2697 VSS.t198 sg13_lv_nmos ad=0.1428p pd=1.52u as=0 ps=0 w=0.42u l=1u
X1702 VSS.t1259 VDD VSS.t1258 VSS.t1154 sg13_lv_nmos ad=0.1428p pd=1.52u as=0 ps=0 w=0.42u l=1u
X1703 VDD VSS.t2671 VDD VDD sg13_lv_pmos ad=0.19p pd=1.38u as=0 ps=0 w=1u l=1u
X1704 VDD VSS.t1949 VDD VDD sg13_lv_pmos ad=0.19p pd=1.38u as=0 ps=0 w=1u l=1u
X1705 VDD VSS.t439 VDD VDD sg13_lv_pmos ad=0.19p pd=1.38u as=0 ps=0 w=1u l=1u
X1706 VDD VSS.t1282 VDD VDD sg13_lv_pmos ad=0.34p pd=2.68u as=0 ps=0 w=1u l=1u
X1707 VSS.t2329 VDD VSS.t2328 VSS.t2327 sg13_lv_nmos ad=0.1428p pd=1.52u as=0 ps=0 w=0.42u l=1u
X1708 VDD sg13cmos5l_a21oi_1_0.A1 a_16955_14484# VDD sg13_lv_pmos ad=0.2128p pd=1.5u as=0.2128p ps=1.5u w=1.12u l=0.13u
X1709 VDD VSS.t578 VDD VDD sg13_lv_pmos ad=0.19p pd=1.38u as=0 ps=0 w=1u l=1u
X1710 VSS.t611 VDD VSS.t608 VSS.t610 sg13_lv_nmos ad=0.1428p pd=1.52u as=0 ps=0 w=0.42u l=1u
X1711 VDD VSS.t1018 VDD VDD sg13_lv_pmos ad=0.34p pd=2.68u as=0 ps=0 w=1u l=1u
X1712 VSS.t1620 VDD VSS.t1622 VSS.t1621 sg13_lv_nmos ad=79.8f pd=0.8u as=0 ps=0 w=0.42u l=1u
X1713 VSS.t3137 VDD VSS.t3139 VSS.t3138 sg13_lv_nmos ad=79.8f pd=0.8u as=0 ps=0 w=0.42u l=1u
X1714 sg13cmos5l_buf_8_2.A a_15579_14854# VSS.t21 VSS.t3249 sg13_lv_nmos ad=0.1406p pd=1.12u as=0.1406p ps=1.12u w=0.74u l=0.13u
X1715 VSS.t227 VDD VSS.t227 VSS.t364 sg13_lv_nmos ad=0.1428p pd=1.52u as=0 ps=0 w=0.42u l=1u
X1716 VDD VSS.t403 VDD VDD sg13_lv_pmos ad=0.19p pd=1.38u as=0 ps=0 w=1u l=1u
X1717 VSS.t904 VDD VSS.t903 VSS.t902 sg13_lv_nmos ad=0.1428p pd=1.52u as=0 ps=0 w=0.42u l=1u
X1718 VSS.t2429 VDD VSS.t2431 VSS.t2430 sg13_lv_nmos ad=79.8f pd=0.8u as=0 ps=0 w=0.42u l=1u
X1719 a_17126_15238# a_16856_15238# VDD VDD sg13_lv_pmos ad=0.34p pd=2.68u as=0.1523p ps=1.38u w=1u l=0.5u
X1720 VSS.t779 VDD VSS.t781 VSS.t780 sg13_lv_nmos ad=79.8f pd=0.8u as=0 ps=0 w=0.42u l=1u
X1721 VDD VSS.t956 VDD VDD sg13_lv_pmos ad=0.19p pd=1.38u as=0 ps=0 w=1u l=1u
X1722 VDD VSS.t1236 VDD VDD sg13_lv_pmos ad=0.19p pd=1.38u as=0 ps=0 w=1u l=1u
X1723 VSS.t2696 VDD VSS.t2695 VSS.t198 sg13_lv_nmos ad=0.1428p pd=1.52u as=0 ps=0 w=0.42u l=1u
X1724 VDD VSS.t2458 VDD VDD sg13_lv_pmos ad=0.34p pd=2.68u as=0 ps=0 w=1u l=1u
X1725 VSS.t328 VDD VSS.t327 VSS.t326 sg13_lv_nmos ad=0.1428p pd=1.52u as=0 ps=0 w=0.42u l=1u
X1726 sg13cmos5l_xnor2_1_2.B sg13cmos5l_dlygate4sd3_1_3.A VDD VDD sg13_lv_pmos ad=0.2128p pd=1.5u as=0.3808p ps=2.92u w=1.12u l=0.13u
X1727 VDD a_10618_14448# a_10337_14750# VDD sg13_lv_pmos ad=0.1523p pd=1.38u as=0.34p ps=2.68u w=1u l=0.5u
X1728 VDD a_17327_13799# a_17584_13942# VDD sg13_lv_pmos ad=2.42015p pd=15.68u as=79.8f ps=0.8u w=0.42u l=0.13u
X1729 VSS.t1650 VDD VSS.t1649 VSS.t1648 sg13_lv_nmos ad=0.1428p pd=1.52u as=0 ps=0 w=0.42u l=1u
X1730 VDD VSS.t2914 VDD VDD sg13_lv_pmos ad=0.19p pd=1.38u as=0 ps=0 w=1u l=1u
X1731 VDD VSS.t2759 VDD VDD sg13_lv_pmos ad=0.19p pd=1.38u as=0 ps=0 w=1u l=1u
X1732 VDD VSS.t252 VDD VDD sg13_lv_pmos ad=0.19p pd=1.38u as=0 ps=0 w=1u l=1u
X1733 VDD a_21466_15202# a_21185_15424# VDD sg13_lv_pmos ad=0.1523p pd=1.38u as=0.34p ps=2.68u w=1u l=0.5u
X1734 a_16356_13735# a_16068_14040# a_16294_13735# VSS.t3215 sg13_lv_nmos ad=0.1428p pd=1.52u as=37.8f ps=0.6u w=0.42u l=0.13u
X1735 VSS.t209 VDD VSS.t98 VSS.t652 sg13_lv_nmos ad=0.1428p pd=1.52u as=0 ps=0 w=0.42u l=1u
X1736 VDD VSS.t2733 VDD VDD sg13_lv_pmos ad=0.34p pd=2.68u as=0 ps=0 w=1u l=1u
X1737 VSS.t503 VDD VSS.t503 VSS.t506 sg13_lv_nmos ad=0.1428p pd=1.52u as=0 ps=0 w=0.42u l=1u
X1738 VSS.t583 VDD VSS.t580 VSS.t708 sg13_lv_nmos ad=0.1428p pd=1.52u as=0 ps=0 w=0.42u l=1u
X1739 VDD VSS.t588 VDD VDD sg13_lv_pmos ad=0.19p pd=1.38u as=0 ps=0 w=1u l=1u
X1740 VSS.t2932 VDD VSS.t2934 VSS.t2933 sg13_lv_nmos ad=79.8f pd=0.8u as=0 ps=0 w=0.42u l=1u
X1741 VSS.t1852 VDD VSS.t1854 VSS.t1853 sg13_lv_nmos ad=79.8f pd=0.8u as=0 ps=0 w=0.42u l=1u
X1742 VDD VSS.t1162 VDD VDD sg13_lv_pmos ad=0.19p pd=1.38u as=0 ps=0 w=1u l=1u
X1743 VDD VSS.t1316 VDD VDD sg13_lv_pmos ad=0.19p pd=1.38u as=0 ps=0 w=1u l=1u
X1744 VSS.t1645 VDD VSS.t1644 VSS.t1643 sg13_lv_nmos ad=0.1428p pd=1.52u as=0 ps=0 w=0.42u l=1u
X1745 VSS.t426 VDD VSS.t427 VSS.t11 sg13_lv_nmos ad=79.8f pd=0.8u as=0 ps=0 w=0.42u l=1u
X1746 VDD VSS.t419 VDD VDD sg13_lv_pmos ad=0.34p pd=2.68u as=0 ps=0 w=1u l=1u
X1747 VDD VSS.t831 VDD VDD sg13_lv_pmos ad=0.19p pd=1.38u as=0 ps=0 w=1u l=1u
X1748 VSS.t874 VDD VSS.t873 VSS.t872 sg13_lv_nmos ad=0.1428p pd=1.52u as=0 ps=0 w=0.42u l=1u
X1749 VSS.t1406 VDD VSS.t1271 VSS.t1154 sg13_lv_nmos ad=0.1428p pd=1.52u as=0 ps=0 w=0.42u l=1u
X1750 VDD VSS.t2336 VDD VDD sg13_lv_pmos ad=0.19p pd=1.38u as=0 ps=0 w=1u l=1u
X1751 VSS.t2394 VDD VSS.t2396 VSS.t2395 sg13_lv_nmos ad=79.8f pd=0.8u as=0 ps=0 w=0.42u l=1u
X1752 VDD VSS.t2681 VDD VDD sg13_lv_pmos ad=0.19p pd=1.38u as=0 ps=0 w=1u l=1u
X1753 VDD VSS.t1934 VDD VDD sg13_lv_pmos ad=0.19p pd=1.38u as=0 ps=0 w=1u l=1u
X1754 VDD VSS.t3071 VDD VDD sg13_lv_pmos ad=0.34p pd=2.68u as=0 ps=0 w=1u l=1u
X1755 VSS.t2349 VDD VSS.t2348 VSS.t2347 sg13_lv_nmos ad=0.1428p pd=1.52u as=0 ps=0 w=0.42u l=1u
X1756 VDD VSS.t2288 VDD VDD sg13_lv_pmos ad=0.34p pd=2.68u as=0 ps=0 w=1u l=1u
X1757 VDD VSS.t723 VDD VDD sg13_lv_pmos ad=0.34p pd=2.68u as=0 ps=0 w=1u l=1u
X1758 VDD VSS.t1617 VDD VDD sg13_lv_pmos ad=0.19p pd=1.38u as=0 ps=0 w=1u l=1u
X1759 VSS.t526 VDD VSS.t525 VSS.t524 sg13_lv_nmos ad=0.1428p pd=1.52u as=0 ps=0 w=0.42u l=1u
X1760 VDD VSS.t1216 VDD VDD sg13_lv_pmos ad=0.34p pd=2.68u as=0 ps=0 w=1u l=1u
X1761 VDD a_7888_14726# a_7833_14607# VDD sg13_lv_pmos ad=2.42015p pd=15.68u as=93.45f ps=0.865u w=0.42u l=0.13u
X1762 sg13cmos5l_buf_8_2.A a_15579_14854# VSS.t21 VSS.t3245 sg13_lv_nmos ad=0.1406p pd=1.12u as=0.1406p ps=1.12u w=0.74u l=0.13u
X1763 VSS.t934 VDD VSS.t936 VSS.t935 sg13_lv_nmos ad=79.8f pd=0.8u as=0 ps=0 w=0.42u l=1u
X1764 VDD VSS.t1672 VDD VDD sg13_lv_pmos ad=0.19p pd=1.38u as=0 ps=0 w=1u l=1u
X1765 VSS.t3 VDD VSS.t3 VSS.t75 sg13_lv_nmos ad=0.1428p pd=1.52u as=0 ps=0 w=0.42u l=1u
X1766 VSS.t72 VDD VSS.t72 VSS.t513 sg13_lv_nmos ad=0.1428p pd=1.52u as=0 ps=0 w=0.42u l=1u
X1767 VDD VSS.t553 VDD VDD sg13_lv_pmos ad=0.19p pd=1.38u as=0 ps=0 w=1u l=1u
X1768 VSS.t979 VDD VSS.t981 VSS.t980 sg13_lv_nmos ad=79.8f pd=0.8u as=0 ps=0 w=0.42u l=1u
X1769 VDD VSS.t1193 VDD VDD sg13_lv_pmos ad=0.19p pd=1.38u as=0 ps=0 w=1u l=1u
X1770 VDD VSS.t2750 VDD VDD sg13_lv_pmos ad=0.19p pd=1.38u as=0 ps=0 w=1u l=1u
X1771 VSS.t2072 VDD VSS.t2071 VSS.t2070 sg13_lv_nmos ad=0.1428p pd=1.52u as=0 ps=0 w=0.42u l=1u
X1772 VDD VSS.t265 VDD VDD sg13_lv_pmos ad=0.19p pd=1.38u as=0 ps=0 w=1u l=1u
X1773 VSS.t1635 VDD VSS.t1634 VSS.t1633 sg13_lv_nmos ad=0.1428p pd=1.52u as=0 ps=0 w=0.42u l=1u
X1774 VSS.t3152 VDD VSS.t3151 VSS.t3150 sg13_lv_nmos ad=0.1428p pd=1.52u as=0 ps=0 w=0.42u l=1u
X1775 VSS.t2972 VDD VSS.t2974 VSS.t2973 sg13_lv_nmos ad=79.8f pd=0.8u as=0 ps=0 w=0.42u l=1u
X1776 a_6346_14452# a_6789_14495# a_6729_14531# VDD sg13_lv_pmos ad=79.8f pd=0.8u as=63f ps=0.72u w=0.42u l=0.13u
X1777 VSS.t2688 VDD VSS.t2690 VSS.t198 sg13_lv_nmos ad=79.8f pd=0.8u as=0 ps=0 w=0.42u l=1u
X1778 VDD VSS.t301 VDD VDD sg13_lv_pmos ad=0.19p pd=1.38u as=0 ps=0 w=1u l=1u
X1779 VDD VSS.t986 VDD VDD sg13_lv_pmos ad=0.19p pd=1.38u as=0 ps=0 w=1u l=1u
X1780 VSS.t2761 VDD VSS.t2762 VSS.t198 sg13_lv_nmos ad=79.8f pd=0.8u as=0 ps=0 w=0.42u l=1u
X1781 VSS.t408 VDD VSS.t407 VSS.t11 sg13_lv_nmos ad=0.1428p pd=1.52u as=0 ps=0 w=0.42u l=1u
X1782 VDD VSS.t783 VDD VDD sg13_lv_pmos ad=0.34p pd=2.68u as=0 ps=0 w=1u l=1u
X1783 VDD VSS.t1986 VDD VDD sg13_lv_pmos ad=0.34p pd=2.68u as=0 ps=0 w=1u l=1u
X1784 VSS.t593 VDD VSS.t596 VSS.t733 sg13_lv_nmos ad=79.8f pd=0.8u as=0 ps=0 w=0.42u l=1u
X1785 VDD VSS.t3104 VDD VDD sg13_lv_pmos ad=0.19p pd=1.38u as=0 ps=0 w=1u l=1u
X1786 VDD VSS.t2356 VDD VDD sg13_lv_pmos ad=0.19p pd=1.38u as=0 ps=0 w=1u l=1u
X1787 VSS.t2379 VDD VSS.t2381 VSS.t2380 sg13_lv_nmos ad=79.8f pd=0.8u as=0 ps=0 w=0.42u l=1u
X1788 VDD VSS.t2111 VDD VDD sg13_lv_pmos ad=0.34p pd=2.68u as=0 ps=0 w=1u l=1u
X1789 VSS.t1545 VDD VSS.t1547 VSS.t1546 sg13_lv_nmos ad=79.8f pd=0.8u as=0 ps=0 w=0.42u l=1u
X1790 VDD VSS.t2762 VDD VDD sg13_lv_pmos ad=0.34p pd=2.68u as=0 ps=0 w=1u l=1u
X1791 VSS.t1962 VDD VSS.t1964 VSS.t1963 sg13_lv_nmos ad=79.8f pd=0.8u as=0 ps=0 w=0.42u l=1u
X1792 VSS.t394 VDD VSS.t132 VSS.t464 sg13_lv_nmos ad=0.1428p pd=1.52u as=0 ps=0 w=0.42u l=1u
X1793 VSS.t2687 VDD VSS.t2688 VSS.t198 sg13_lv_nmos ad=79.8f pd=0.8u as=0 ps=0 w=0.42u l=1u
X1794 VSS.t1605 VDD VSS.t1607 VSS.t1606 sg13_lv_nmos ad=79.8f pd=0.8u as=0 ps=0 w=0.42u l=1u
X1795 VSS.t3122 VDD VSS.t3124 VSS.t3123 sg13_lv_nmos ad=79.8f pd=0.8u as=0 ps=0 w=0.42u l=1u
X1796 VDD VSS.t430 VDD VDD sg13_lv_pmos ad=0.19p pd=1.38u as=0 ps=0 w=1u l=1u
X1797 VSS.t904 VDD VSS.t903 VSS.t902 sg13_lv_nmos ad=0.1428p pd=1.52u as=0 ps=0 w=0.42u l=1u
X1798 VSS.t1420 VDD VSS.t1290 VSS.t1154 sg13_lv_nmos ad=0.1428p pd=1.52u as=0 ps=0 w=0.42u l=1u
X1799 a_26244_14909# a_25956_14488# a_26182_14909# VSS.t233 sg13_lv_nmos ad=0.1428p pd=1.52u as=37.8f ps=0.6u w=0.42u l=0.13u
X1800 VDD VSS.t1001 VDD VDD sg13_lv_pmos ad=0.19p pd=1.38u as=0 ps=0 w=1u l=1u
X1801 VDD VSS.t1262 VDD VDD sg13_lv_pmos ad=0.19p pd=1.38u as=0 ps=0 w=1u l=1u
X1802 VSS.t3 VDD VSS.t3 VSS.t379 sg13_lv_nmos ad=0.1428p pd=1.52u as=0 ps=0 w=0.42u l=1u
X1803 VDD VSS.t1569 VDD VDD sg13_lv_pmos ad=0.34p pd=2.68u as=0 ps=0 w=1u l=1u
X1804 a_19450_15202# sg13cmos5l_dfrbpq_1_3.Q VDD VDD sg13_lv_pmos ad=0.1428p pd=1.52u as=0.1523p ps=1.38u w=0.42u l=0.13u
X1805 VDD VSS.t1624 VDD VDD sg13_lv_pmos ad=0.34p pd=2.68u as=0 ps=0 w=1u l=1u
X1806 VSS.t2992 VDD VSS.t2994 VSS.t2993 sg13_lv_nmos ad=79.8f pd=0.8u as=0 ps=0 w=0.42u l=1u
X1807 VSS.t1912 VDD VSS.t1914 VSS.t1913 sg13_lv_nmos ad=79.8f pd=0.8u as=0 ps=0 w=0.42u l=1u
X1808 a_20603_15532# sg13cmos5l_or3_1_2.X VDD VDD sg13_lv_pmos ad=0.3808p pd=2.92u as=0.2128p ps=1.5u w=1.12u l=0.13u
X1809 VDD VSS.t2899 VDD VDD sg13_lv_pmos ad=0.19p pd=1.38u as=0 ps=0 w=1u l=1u
X1810 VSS.t1310 VDD VSS.t1309 VSS.t1154 sg13_lv_nmos ad=0.1428p pd=1.52u as=0 ps=0 w=0.42u l=1u
X1811 VSS.t1695 VDD VSS.t1697 VSS.t1696 sg13_lv_nmos ad=79.8f pd=0.8u as=0 ps=0 w=0.42u l=1u
X1812 VDD VSS.t2725 VDD VDD sg13_lv_pmos ad=0.34p pd=2.68u as=0 ps=0 w=1u l=1u
X1813 sg13cmos5l_dfrbpq_1_2.CLK a_12010_15202# VDD VDD sg13_lv_pmos ad=0.2128p pd=1.5u as=0.2128p ps=1.5u w=1.12u l=0.13u
X1814 VDD VSS.t132 VDD VDD sg13_lv_pmos ad=0.34p pd=2.68u as=0 ps=0 w=1u l=1u
X1815 VSS.t19 sg13cmos5l_or3_1_2.B a_20278_14862# VSS.t9 sg13_lv_nmos ad=0.1406p pd=1.12u as=0.2516p ps=2.16u w=0.74u l=0.15u
X1816 VDD VSS.t938 VDD VDD sg13_lv_pmos ad=0.34p pd=2.68u as=0 ps=0 w=1u l=1u
X1817 VDD VSS.t291 VDD VDD sg13_lv_pmos ad=0.19p pd=1.38u as=0 ps=0 w=1u l=1u
X1818 VDD VSS.t2313 VDD VDD sg13_lv_pmos ad=0.34p pd=2.68u as=0 ps=0 w=1u l=1u
X1819 VDD VSS.t1307 VDD VDD sg13_lv_pmos ad=0.19p pd=1.38u as=0 ps=0 w=1u l=1u
X1820 VDD VSS.t2498 VDD VDD sg13_lv_pmos ad=0.34p pd=2.68u as=0 ps=0 w=1u l=1u
X1821 VDD VSS.t1278 VDD VDD sg13_lv_pmos ad=0.34p pd=2.68u as=0 ps=0 w=1u l=1u
X1822 VDD VSS.t2673 VDD VDD sg13_lv_pmos ad=0.19p pd=1.38u as=0 ps=0 w=1u l=1u
X1823 VDD VSS.t2096 VDD VDD sg13_lv_pmos ad=0.34p pd=2.68u as=0 ps=0 w=1u l=1u
X1824 VDD VSS.t1919 VDD VDD sg13_lv_pmos ad=0.19p pd=1.38u as=0 ps=0 w=1u l=1u
X1825 sg13cmos5l_or3_1_2.C sg13cmos5l_dfrbpq_1_2.Q VDD VDD sg13_lv_pmos ad=0.2128p pd=1.5u as=0.3808p ps=2.92u w=1.12u l=0.13u
X1826 VSS.t2334 VDD VSS.t2333 VSS.t2332 sg13_lv_nmos ad=0.1428p pd=1.52u as=0 ps=0 w=0.42u l=1u
X1827 VDD VSS.t2273 VDD VDD sg13_lv_pmos ad=0.34p pd=2.68u as=0 ps=0 w=1u l=1u
X1828 VDD VSS.t410 VDD VDD sg13_lv_pmos ad=0.34p pd=2.68u as=0 ps=0 w=1u l=1u
X1829 VDD VSS.t3056 VDD VDD sg13_lv_pmos ad=0.34p pd=2.68u as=0 ps=0 w=1u l=1u
X1830 VDD VSS.t508 VDD VDD sg13_lv_pmos ad=0.19p pd=1.38u as=0 ps=0 w=1u l=1u
X1831 VSS.t3107 VDD VSS.t3109 VSS.t3108 sg13_lv_nmos ad=79.8f pd=0.8u as=0 ps=0 w=0.42u l=1u
X1832 VDD VSS.t400 VDD VDD sg13_lv_pmos ad=0.19p pd=1.38u as=0 ps=0 w=1u l=1u
X1833 VDD VSS.t1243 VDD VDD sg13_lv_pmos ad=0.34p pd=2.68u as=0 ps=0 w=1u l=1u
X1834 VDD VSS.t553 VDD VDD sg13_lv_pmos ad=0.19p pd=1.38u as=0 ps=0 w=1u l=1u
X1835 VSS.t979 VDD VSS.t981 VSS.t980 sg13_lv_nmos ad=79.8f pd=0.8u as=0 ps=0 w=0.42u l=1u
X1836 VSS.t1319 VDD VSS.t1318 VSS.t1154 sg13_lv_nmos ad=0.1428p pd=1.52u as=0 ps=0 w=0.42u l=1u
X1837 VDD VSS.t1602 VDD VDD sg13_lv_pmos ad=0.19p pd=1.38u as=0 ps=0 w=1u l=1u
X1838 VSS.t1490 VDD VSS.t1492 VSS.t1491 sg13_lv_nmos ad=79.8f pd=0.8u as=0 ps=0 w=0.42u l=1u
X1839 VSS.t2399 VDD VSS.t2401 VSS.t2400 sg13_lv_nmos ad=79.8f pd=0.8u as=0 ps=0 w=0.42u l=1u
X1840 VSS.t839 VDD VSS.t838 VSS.t837 sg13_lv_nmos ad=0.1428p pd=1.52u as=0 ps=0 w=0.42u l=1u
X1841 VDD VSS.t1184 VDD VDD sg13_lv_pmos ad=0.19p pd=1.38u as=0 ps=0 w=1u l=1u
X1842 VDD VSS.t1974 VDD VDD sg13_lv_pmos ad=0.19p pd=1.38u as=0 ps=0 w=1u l=1u
X1843 VSS.t1620 VDD VSS.t1619 VSS.t1618 sg13_lv_nmos ad=0.1428p pd=1.52u as=0 ps=0 w=0.42u l=1u
X1844 VSS.t3137 VDD VSS.t3136 VSS.t3135 sg13_lv_nmos ad=0.1428p pd=1.52u as=0 ps=0 w=0.42u l=1u
X1845 a_17327_13799# a_16485_13701# a_16068_14040# VDD sg13_lv_pmos ad=0.2048p pd=1.63u as=0.34p ps=2.68u w=1u l=0.13u
X1846 sg13cmos5l_dfrbpq_1_2.CLK a_12010_15202# VDD VDD sg13_lv_pmos ad=0.2128p pd=1.5u as=0.2128p ps=1.5u w=1.12u l=0.13u
X1847 VDD VSS.t573 VDD VDD sg13_lv_pmos ad=0.19p pd=1.38u as=0 ps=0 w=1u l=1u
X1848 VSS.t2937 VDD VSS.t2939 VSS.t2938 sg13_lv_nmos ad=79.8f pd=0.8u as=0 ps=0 w=0.42u l=1u
X1849 VSS.t1857 VDD VSS.t1859 VSS.t1858 sg13_lv_nmos ad=79.8f pd=0.8u as=0 ps=0 w=0.42u l=1u
X1850 VDD VSS.t1298 VDD VDD sg13_lv_pmos ad=0.19p pd=1.38u as=0 ps=0 w=1u l=1u
X1851 VDD sg13cmos5l_dfrbpq_1_5.RESET_B a_25862_13722# VDD sg13_lv_pmos ad=0.36237p pd=2.605u as=79.8f ps=0.8u w=0.42u l=0.13u
X1852 VDD VSS.t2341 VDD VDD sg13_lv_pmos ad=0.19p pd=1.38u as=0 ps=0 w=1u l=1u
X1853 VDD VSS.t1487 VDD VDD sg13_lv_pmos ad=0.19p pd=1.38u as=0 ps=0 w=1u l=1u
X1854 VDD a_15579_14854# sg13cmos5l_buf_8_2.A VDD sg13_lv_pmos ad=0.2128p pd=1.5u as=0.2128p ps=1.5u w=1.12u l=0.13u
X1855 VSS.t1530 VDD VSS.t1532 VSS.t1531 sg13_lv_nmos ad=79.8f pd=0.8u as=0 ps=0 w=0.42u l=1u
X1856 VSS.t1710 VDD VSS.t1709 VSS.t1708 sg13_lv_nmos ad=0.1428p pd=1.52u as=0 ps=0 w=0.42u l=1u
X1857 VDD VSS.t3041 VDD VDD sg13_lv_pmos ad=0.34p pd=2.68u as=0 ps=0 w=1u l=1u
X1858 VDD VSS.t2258 VDD VDD sg13_lv_pmos ad=0.34p pd=2.68u as=0 ps=0 w=1u l=1u
X1859 VSS.t1947 VDD VSS.t1949 VSS.t1948 sg13_lv_nmos ad=79.8f pd=0.8u as=0 ps=0 w=0.42u l=1u
X1860 VDD a_22319_14845# a_22576_14726# VDD sg13_lv_pmos ad=2.42015p pd=15.68u as=79.8f ps=0.8u w=0.42u l=0.13u
X1861 a_25094_14484# a_24824_14525# VSS.t103 VSS.t4 sg13_lv_nmos ad=0.1428p pd=1.52u as=79.8f ps=0.8u w=0.42u l=0.5u
X1862 VSS.t596 VDD VSS.t593 VSS.t595 sg13_lv_nmos ad=0.1428p pd=1.52u as=0 ps=0 w=0.42u l=1u
X1863 VSS.t2678 VDD VSS.t2679 VSS.t198 sg13_lv_nmos ad=79.8f pd=0.8u as=0 ps=0 w=0.42u l=1u
X1864 VDD VSS.t2649 VDD VDD sg13_lv_pmos ad=0.19p pd=1.38u as=0 ps=0 w=1u l=1u
X1865 VDD VSS.t1622 VDD VDD sg13_lv_pmos ad=0.19p pd=1.38u as=0 ps=0 w=1u l=1u
X1866 VDD VSS.t2959 VDD VDD sg13_lv_pmos ad=0.19p pd=1.38u as=0 ps=0 w=1u l=1u
X1867 VDD VSS.t1966 VDD VDD sg13_lv_pmos ad=0.34p pd=2.68u as=0 ps=0 w=1u l=1u
X1868 VSS.t799 VDD VSS.t801 VSS.t800 sg13_lv_nmos ad=79.8f pd=0.8u as=0 ps=0 w=0.42u l=1u
X1869 VDD VSS.t418 VDD VDD sg13_lv_pmos ad=0.19p pd=1.38u as=0 ps=0 w=1u l=1u
X1870 VDD VSS.t858 VDD VDD sg13_lv_pmos ad=0.34p pd=2.68u as=0 ps=0 w=1u l=1u
X1871 VDD VSS.t2753 VDD VDD sg13_lv_pmos ad=0.19p pd=1.38u as=0 ps=0 w=1u l=1u
X1872 VSS.t2354 VDD VSS.t2353 VSS.t2352 sg13_lv_nmos ad=0.1428p pd=1.52u as=0 ps=0 w=0.42u l=1u
X1873 VSS.t2077 VDD VSS.t2076 VSS.t2075 sg13_lv_nmos ad=0.1428p pd=1.52u as=0 ps=0 w=0.42u l=1u
X1874 VSS.t1640 VDD VSS.t1639 VSS.t1638 sg13_lv_nmos ad=0.1428p pd=1.52u as=0 ps=0 w=0.42u l=1u
X1875 VSS.t3157 VDD VSS.t3156 VSS.t3155 sg13_lv_nmos ad=0.1428p pd=1.52u as=0 ps=0 w=0.42u l=1u
X1876 VSS.t2977 VDD VSS.t2979 VSS.t2978 sg13_lv_nmos ad=79.8f pd=0.8u as=0 ps=0 w=0.42u l=1u
X1877 VDD a_16485_13701# a_16587_13844# VDD sg13_lv_pmos ad=2.42015p pd=15.68u as=0.3864p ps=2.93u w=1.12u l=0.13u
X1878 VDD VSS.t1649 VDD VDD sg13_lv_pmos ad=0.34p pd=2.68u as=0 ps=0 w=1u l=1u
X1879 a_10618_14448# sg13cmos5l_dlygate4sd3_1_8.A VDD VDD sg13_lv_pmos ad=0.1428p pd=1.52u as=0.1523p ps=1.38u w=0.42u l=0.13u
X1880 VDD VSS.t983 VDD VDD sg13_lv_pmos ad=0.34p pd=2.68u as=0 ps=0 w=1u l=1u
X1881 VSS.t1680 VDD VSS.t1682 VSS.t1681 sg13_lv_nmos ad=79.8f pd=0.8u as=0 ps=0 w=0.42u l=1u
X1882 VSS.t138 VDD VSS.t135 VSS.t695 sg13_lv_nmos ad=0.1428p pd=1.52u as=0 ps=0 w=0.42u l=1u
X1883 VSS.t602 VDD VSS.t602 VSS.t738 sg13_lv_nmos ad=0.1428p pd=1.52u as=0 ps=0 w=0.42u l=1u
X1884 VSS.t2764 VDD VSS.t2765 VSS.t198 sg13_lv_nmos ad=79.8f pd=0.8u as=0 ps=0 w=0.42u l=1u
X1885 VSS.t1842 VDD VSS.t1844 VSS.t1843 sg13_lv_nmos ad=79.8f pd=0.8u as=0 ps=0 w=0.42u l=1u
X1886 a_25025_16344# sg13cmos5l_a21oi_1_2.A1 sg13cmos5l_dlygate4sd3_1_17.A VSS.t203 sg13_lv_nmos ad=0.1406p pd=1.12u as=0.1406p ps=1.12u w=0.74u l=0.13u
X1887 VDD VSS.t2298 VDD VDD sg13_lv_pmos ad=0.34p pd=2.68u as=0 ps=0 w=1u l=1u
X1888 VSS.t566 VDD VSS.t565 VSS.t564 sg13_lv_nmos ad=0.1428p pd=1.52u as=0 ps=0 w=0.42u l=1u
X1889 VDD VSS.t2326 VDD VDD sg13_lv_pmos ad=0.19p pd=1.38u as=0 ps=0 w=1u l=1u
X1890 VSS.t2384 VDD VSS.t2386 VSS.t2385 sg13_lv_nmos ad=79.8f pd=0.8u as=0 ps=0 w=0.42u l=1u
X1891 VDD VSS.t921 VDD VDD sg13_lv_pmos ad=0.19p pd=1.38u as=0 ps=0 w=1u l=1u
X1892 VSS.t1219 VDD VSS.t1220 VSS.t1154 sg13_lv_nmos ad=79.8f pd=0.8u as=0 ps=0 w=0.42u l=1u
X1893 VDD VSS.t1472 VDD VDD sg13_lv_pmos ad=0.19p pd=1.38u as=0 ps=0 w=1u l=1u
X1894 a_22025_16334# a_22149_16033# VDD VDD sg13_lv_pmos ad=0.2442p pd=2.06u as=2.8961p ps=18.25u w=0.66u l=0.13u
X1895 VDD VSS.t2081 VDD VDD sg13_lv_pmos ad=0.34p pd=2.68u as=0 ps=0 w=1u l=1u
X1896 VDD VSS.t1314 VDD VDD sg13_lv_pmos ad=0.19p pd=1.38u as=0 ps=0 w=1u l=1u
X1897 VDD VSS.t1269 VDD VDD sg13_lv_pmos ad=0.34p pd=2.68u as=0 ps=0 w=1u l=1u
X1898 VSS.t1550 VDD VSS.t1552 VSS.t1551 sg13_lv_nmos ad=79.8f pd=0.8u as=0 ps=0 w=0.42u l=1u
X1899 VDD VSS.t2765 VDD VDD sg13_lv_pmos ad=0.34p pd=2.68u as=0 ps=0 w=1u l=1u
X1900 VSS.t1932 VDD VSS.t1934 VSS.t1933 sg13_lv_nmos ad=79.8f pd=0.8u as=0 ps=0 w=0.42u l=1u
X1901 VDD VSS.t508 VDD VDD sg13_lv_pmos ad=0.19p pd=1.38u as=0 ps=0 w=1u l=1u
X1902 VDD a_15579_14854# sg13cmos5l_buf_8_2.A VDD sg13_lv_pmos ad=0.2128p pd=1.5u as=0.2128p ps=1.5u w=1.12u l=0.13u
X1903 VSS.t503 VDD VSS.t503 VSS.t506 sg13_lv_nmos ad=0.1428p pd=1.52u as=0 ps=0 w=0.42u l=1u
X1904 VSS.t1262 VDD VSS.t1262 VSS.t1154 sg13_lv_nmos ad=79.8f pd=0.8u as=0 ps=0 w=0.42u l=1u
X1905 VSS.t2952 VDD VSS.t2951 VSS.t2950 sg13_lv_nmos ad=0.1428p pd=1.52u as=0 ps=0 w=0.42u l=1u
X1906 VSS.t1872 VDD VSS.t1871 VSS.t1870 sg13_lv_nmos ad=0.1428p pd=1.52u as=0 ps=0 w=0.42u l=1u
X1907 VSS.t1342 VDD VSS.t1182 VSS.t1154 sg13_lv_nmos ad=0.1428p pd=1.52u as=0 ps=0 w=0.42u l=1u
X1908 VSS.t59 VDD VSS.t59 VSS.t349 sg13_lv_nmos ad=0.1428p pd=1.52u as=0 ps=0 w=0.42u l=1u
X1909 a_16314_15532# sg13cmos5l_or3_1_2.B sg13cmos5l_nor2_1_0.B VDD sg13_lv_pmos ad=0.1428p pd=1.375u as=0.2408p ps=1.55u w=1.12u l=0.13u
X1910 VSS.t954 VDD VSS.t956 VSS.t955 sg13_lv_nmos ad=79.8f pd=0.8u as=0 ps=0 w=0.42u l=1u
X1911 VDD VSS.t1023 VDD VDD sg13_lv_pmos ad=0.34p pd=2.68u as=0 ps=0 w=1u l=1u
X1912 VSS.t839 VDD VSS.t838 VSS.t837 sg13_lv_nmos ad=0.1428p pd=1.52u as=0 ps=0 w=0.42u l=1u
X1913 VSS.t1670 VDD VSS.t1672 VSS.t1671 sg13_lv_nmos ad=79.8f pd=0.8u as=0 ps=0 w=0.42u l=1u
X1914 VSS.t2651 VDD VSS.t2652 VSS.t198 sg13_lv_nmos ad=79.8f pd=0.8u as=0 ps=0 w=0.42u l=1u
X1915 a_25930_14452# a_26373_14495# a_25670_14922# VSS.t229 sg13_lv_nmos ad=79.8f pd=0.8u as=0.1296p ps=1.52u w=0.42u l=0.13u
X1916 VDD VSS.t1629 VDD VDD sg13_lv_pmos ad=0.34p pd=2.68u as=0 ps=0 w=1u l=1u
X1917 VDD VSS.t2904 VDD VDD sg13_lv_pmos ad=0.19p pd=1.38u as=0 ps=0 w=1u l=1u
X1918 VDD VSS.t49 VDD VDD sg13_lv_pmos ad=0.34p pd=2.68u as=0 ps=0 w=1u l=1u
X1919 VDD VSS.t1634 VDD VDD sg13_lv_pmos ad=0.34p pd=2.68u as=0 ps=0 w=1u l=1u
X1920 VDD VSS.t2728 VDD VDD sg13_lv_pmos ad=0.34p pd=2.68u as=0 ps=0 w=1u l=1u
X1921 VDD a_27502_15423# sg13cmos5l_or3_1_1.A VDD sg13_lv_pmos ad=0.2254p pd=1.53u as=0.4256p ps=3u w=1.12u l=0.13u
X1922 VSS.t1665 VDD VSS.t1667 VSS.t1666 sg13_lv_nmos ad=79.8f pd=0.8u as=0 ps=0 w=0.42u l=1u
X1923 VSS.t526 VDD VSS.t528 VSS.t527 sg13_lv_nmos ad=79.8f pd=0.8u as=0 ps=0 w=0.42u l=1u
X1924 VSS.t72 VDD VSS.t72 VSS.t513 sg13_lv_nmos ad=0.1428p pd=1.52u as=0 ps=0 w=0.42u l=1u
X1925 VDD VSS.t1195 VDD VDD sg13_lv_pmos ad=0.34p pd=2.68u as=0 ps=0 w=1u l=1u
X1926 VDD VSS.t2318 VDD VDD sg13_lv_pmos ad=0.34p pd=2.68u as=0 ps=0 w=1u l=1u
X1927 VDD VSS.t1976 VDD VDD sg13_lv_pmos ad=0.34p pd=2.68u as=0 ps=0 w=1u l=1u
X1928 VSS.t65 sg13cmos5l_o21ai_1_2.A2 a_24169_14508# VSS.t4 sg13_lv_nmos ad=0.1045p pd=0.93u as=0.187p ps=1.78u w=0.55u l=0.13u
X1929 VSS.t2922 VDD VSS.t2924 VSS.t2923 sg13_lv_nmos ad=79.8f pd=0.8u as=0 ps=0 w=0.42u l=1u
X1930 VDD VSS.t1289 VDD VDD sg13_lv_pmos ad=0.19p pd=1.38u as=0 ps=0 w=1u l=1u
X1931 VDD VSS.t2503 VDD VDD sg13_lv_pmos ad=0.34p pd=2.68u as=0 ps=0 w=1u l=1u
X1932 a_3333_15213# sg13cmos5l_dfrbpq_1_2.CLK VSS.t11 VSS.t3182 sg13_lv_nmos ad=0.2516p pd=2.16u as=3.8707p ps=25.555u w=0.74u l=0.13u
X1933 a_21070_15423# a_21185_15424# VDD VDD sg13_lv_pmos ad=0.34p pd=2.68u as=0.2254p ps=1.53u w=1u l=0.5u
X1934 VDD VSS.t2676 VDD VDD sg13_lv_pmos ad=0.19p pd=1.38u as=0 ps=0 w=1u l=1u
X1935 sg13cmos5l_dfrbpq_1_3.Q a_19530_14484# VDD VDD sg13_lv_pmos ad=0.3808p pd=2.92u as=0.2128p ps=1.5u w=1.12u l=0.13u
X1936 VDD VSS.t590 VDD VDD sg13_lv_pmos ad=0.19p pd=1.38u as=0 ps=0 w=1u l=1u
X1937 VDD VSS.t1038 VDD VDD sg13_lv_pmos ad=0.34p pd=2.68u as=0 ps=0 w=1u l=1u
X1938 VSS.t1500 VDD VSS.t1502 VSS.t1501 sg13_lv_nmos ad=79.8f pd=0.8u as=0 ps=0 w=0.42u l=1u
X1939 VSS.t2339 VDD VSS.t2338 VSS.t2337 sg13_lv_nmos ad=0.1428p pd=1.52u as=0 ps=0 w=0.42u l=1u
X1940 a_26373_14495# sg13cmos5l_buf_8_2.X VDD VDD sg13_lv_pmos ad=0.4088p pd=2.97u as=2.3367p ps=15.135u w=1.12u l=0.13u
X1941 VSS.t623 VDD VSS.t620 VSS.t622 sg13_lv_nmos ad=0.1428p pd=1.52u as=0 ps=0 w=0.42u l=1u
X1942 VSS.t1695 VDD VSS.t1694 VSS.t1693 sg13_lv_nmos ad=0.1428p pd=1.52u as=0 ps=0 w=0.42u l=1u
X1943 VSS.t2112 VDD VSS.t2111 VSS.t2110 sg13_lv_nmos ad=0.1428p pd=1.52u as=0 ps=0 w=0.42u l=1u
X1944 VSS.t3 VDD VSS.t373 VSS.t375 sg13_lv_nmos ad=0.1428p pd=1.52u as=0 ps=0 w=0.42u l=1u
X1945 sg13cmos5l_dlygate4sd3_1_3.A a_4842_15532# VSS.t11 VSS.t125 sg13_lv_nmos ad=0.2516p pd=2.16u as=0.1406p ps=1.12u w=0.74u l=0.13u
X1946 VSS.t799 VDD VSS.t801 VSS.t800 sg13_lv_nmos ad=79.8f pd=0.8u as=0 ps=0 w=0.42u l=1u
X1947 VSS.t1237 VDD VSS.t1238 VSS.t1154 sg13_lv_nmos ad=79.8f pd=0.8u as=0 ps=0 w=0.42u l=1u
X1948 VDD VSS.t1607 VDD VDD sg13_lv_pmos ad=0.19p pd=1.38u as=0 ps=0 w=1u l=1u
X1949 VDD VSS.t1662 VDD VDD sg13_lv_pmos ad=0.19p pd=1.38u as=0 ps=0 w=1u l=1u
X1950 VSS.t1495 VDD VSS.t1497 VSS.t1496 sg13_lv_nmos ad=79.8f pd=0.8u as=0 ps=0 w=0.42u l=1u
X1951 VDD VSS.t3121 VDD VDD sg13_lv_pmos ad=0.34p pd=2.68u as=0 ps=0 w=1u l=1u
X1952 VSS.t2404 VDD VSS.t2406 VSS.t2405 sg13_lv_nmos ad=79.8f pd=0.8u as=0 ps=0 w=0.42u l=1u
X1953 VDD VSS.t180 VDD VDD sg13_lv_pmos ad=0.19p pd=1.38u as=0 ps=0 w=1u l=1u
X1954 VSS.t209 a_7822_13911# sg13cmos5l_xnor2_1_2.A VSS.t208 sg13_lv_nmos ad=0.1426p pd=1.16u as=0.2516p ps=2.16u w=0.74u l=0.13u
X1955 VSS.t724 VDD VSS.t723 VSS.t722 sg13_lv_nmos ad=0.1428p pd=1.52u as=0 ps=0 w=0.42u l=1u
X1956 VDD VSS.t1187 VDD VDD sg13_lv_pmos ad=0.19p pd=1.38u as=0 ps=0 w=1u l=1u
X1957 VDD VSS.t2744 VDD VDD sg13_lv_pmos ad=0.19p pd=1.38u as=0 ps=0 w=1u l=1u
X1958 VSS.t1625 VDD VSS.t1624 VSS.t1623 sg13_lv_nmos ad=0.1428p pd=1.52u as=0 ps=0 w=0.42u l=1u
X1959 sg13cmos5l_buf_1_0.X a_1192_3900# VDD VDD sg13_lv_pmos ad=0.42p pd=2.99u as=0.2114p ps=1.54u w=1.12u l=0.13u
X1960 VSS.t3142 VDD VSS.t3141 VSS.t3140 sg13_lv_nmos ad=0.1428p pd=1.52u as=0 ps=0 w=0.42u l=1u
X1961 VSS.t72 VDD VSS.t72 VSS.t515 sg13_lv_nmos ad=0.1428p pd=1.52u as=0 ps=0 w=0.42u l=1u
X1962 VSS.t984 VDD VSS.t986 VSS.t985 sg13_lv_nmos ad=79.8f pd=0.8u as=0 ps=0 w=0.42u l=1u
X1963 VDD VSS.t1174 VDD VDD sg13_lv_pmos ad=0.19p pd=1.38u as=0 ps=0 w=1u l=1u
X1964 VSS.t274 VDD VSS.t274 VSS.t276 sg13_lv_nmos ad=0.1428p pd=1.52u as=0 ps=0 w=0.42u l=1u
X1965 VSS.t438 VDD VSS.t439 VSS.t11 sg13_lv_nmos ad=79.8f pd=0.8u as=0 ps=0 w=0.42u l=1u
X1966 a_16955_14484# sg13cmos5l_a21oi_1_3.B1 sg13cmos5l_a21oi_1_0.Y VDD sg13_lv_pmos ad=0.2128p pd=1.5u as=0.3808p ps=2.92u w=1.12u l=0.13u
X1967 VSS.t2434 VDD VSS.t2433 VSS.t2432 sg13_lv_nmos ad=0.1428p pd=1.52u as=0 ps=0 w=0.42u l=1u
X1968 VDD VSS.t1301 VDD VDD sg13_lv_pmos ad=0.19p pd=1.38u as=0 ps=0 w=1u l=1u
X1969 VSS.t2628 VDD VSS.t2627 VSS.t198 sg13_lv_nmos ad=0.1428p pd=1.52u as=0 ps=0 w=0.42u l=1u
X1970 VDD VSS.t698 VDD VDD sg13_lv_pmos ad=0.34p pd=2.68u as=0 ps=0 w=1u l=1u
X1971 VDD VSS.t2672 VDD VDD sg13_lv_pmos ad=0.19p pd=1.38u as=0 ps=0 w=1u l=1u
X1972 VSS.t2369 VDD VSS.t2371 VSS.t2370 sg13_lv_nmos ad=79.8f pd=0.8u as=0 ps=0 w=0.42u l=1u
X1973 a_9418_15457# a_9861_15213# a_9801_15625# VDD sg13_lv_pmos ad=79.8f pd=0.8u as=63f ps=0.72u w=0.42u l=0.13u
X1974 VDD VSS.t2488 VDD VDD sg13_lv_pmos ad=0.34p pd=2.68u as=0 ps=0 w=1u l=1u
X1975 VDD VSS.t2311 VDD VDD sg13_lv_pmos ad=0.19p pd=1.38u as=0 ps=0 w=1u l=1u
X1976 VDD VSS.t1457 VDD VDD sg13_lv_pmos ad=0.19p pd=1.38u as=0 ps=0 w=1u l=1u
X1977 VSS.t42 sg13cmos5l_dfrbpq_1_7.RESET_B a_25764_14922# VSS.t243 sg13_lv_nmos ad=0.1626p pd=1.415u as=60.89999f ps=0.71u w=0.42u l=0.13u
X1978 VSS.t1535 VDD VSS.t1537 VSS.t1536 sg13_lv_nmos ad=79.8f pd=0.8u as=0 ps=0 w=0.42u l=1u
X1979 VSS.t1715 VDD VSS.t1714 VSS.t1713 sg13_lv_nmos ad=0.1428p pd=1.52u as=0 ps=0 w=0.42u l=1u
X1980 VSS.t2681 VDD VSS.t2682 VSS.t198 sg13_lv_nmos ad=79.8f pd=0.8u as=0 ps=0 w=0.42u l=1u
X1981 VDD VSS.t2436 VDD VDD sg13_lv_pmos ad=0.19p pd=1.38u as=0 ps=0 w=1u l=1u
X1982 VSS.t2097 VDD VSS.t2096 VSS.t2095 sg13_lv_nmos ad=0.1428p pd=1.52u as=0 ps=0 w=0.42u l=1u
X1983 VSS.t954 VDD VSS.t956 VSS.t955 sg13_lv_nmos ad=79.8f pd=0.8u as=0 ps=0 w=0.42u l=1u
X1984 VDD VSS.t1228 VDD VDD sg13_lv_pmos ad=0.34p pd=2.68u as=0 ps=0 w=1u l=1u
X1985 VSS.t1289 VDD VSS.t1288 VSS.t1154 sg13_lv_nmos ad=0.1428p pd=1.52u as=0 ps=0 w=0.42u l=1u
X1986 VSS.t336 VDD VSS.t338 VSS.t337 sg13_lv_nmos ad=79.8f pd=0.8u as=0 ps=0 w=0.42u l=1u
X1987 VDD VSS.t1317 VDD VDD sg13_lv_pmos ad=0.34p pd=2.68u as=0 ps=0 w=1u l=1u
X1988 VDD VSS.t2964 VDD VDD sg13_lv_pmos ad=0.19p pd=1.38u as=0 ps=0 w=1u l=1u
X1989 VSS.t2937 VDD VSS.t2936 VSS.t2935 sg13_lv_nmos ad=0.1428p pd=1.52u as=0 ps=0 w=0.42u l=1u
X1990 VDD VSS.t3 VDD VDD sg13_lv_pmos ad=0.34p pd=2.68u as=0 ps=0 w=1u l=1u
X1991 VSS.t999 VDD VSS.t1001 VSS.t1000 sg13_lv_nmos ad=79.8f pd=0.8u as=0 ps=0 w=0.42u l=1u
X1992 VDD VSS.t1839 VDD VDD sg13_lv_pmos ad=0.19p pd=1.38u as=0 ps=0 w=1u l=1u
X1993 VSS.t304 VDD VSS.t306 VSS.t305 sg13_lv_nmos ad=79.8f pd=0.8u as=0 ps=0 w=0.42u l=1u
X1994 VSS.t385 VDD VSS.t384 VSS.t383 sg13_lv_nmos ad=0.1428p pd=1.52u as=0 ps=0 w=0.42u l=1u
X1995 VDD VSS.t2682 VDD VDD sg13_lv_pmos ad=0.34p pd=2.68u as=0 ps=0 w=1u l=1u
X1996 VDD VSS.t1936 VDD VDD sg13_lv_pmos ad=0.34p pd=2.68u as=0 ps=0 w=1u l=1u
X1997 VSS.t145 sg13cmos5l_dfrbpq_1_5.RESET_B a_25956_13722# VSS.t144 sg13_lv_nmos ad=0.1626p pd=1.415u as=60.89999f ps=0.71u w=0.42u l=0.13u
X1998 VDD VSS.t1614 VDD VDD sg13_lv_pmos ad=0.34p pd=2.68u as=0 ps=0 w=1u l=1u
X1999 VDD VSS.t2756 VDD VDD sg13_lv_pmos ad=0.19p pd=1.38u as=0 ps=0 w=1u l=1u
X2000 VDD VSS.t1155 VDD VDD sg13_lv_pmos ad=0.34p pd=2.68u as=0 ps=0 w=1u l=1u
X2001 VDD VSS.t1266 VDD VDD sg13_lv_pmos ad=0.19p pd=1.38u as=0 ps=0 w=1u l=1u
X2002 VSS.t420 VDD VSS.t419 VSS.t11 sg13_lv_nmos ad=0.1428p pd=1.52u as=0 ps=0 w=0.42u l=1u
X2003 VSS.t444 VDD VSS.t443 VSS.t11 sg13_lv_nmos ad=0.1428p pd=1.52u as=0 ps=0 w=0.42u l=1u
X2004 VDD VSS.t1619 VDD VDD sg13_lv_pmos ad=0.34p pd=2.68u as=0 ps=0 w=1u l=1u
X2005 VSS.t593 VDD VSS.t593 VSS.t594 sg13_lv_nmos ad=79.8f pd=0.8u as=0 ps=0 w=0.42u l=1u
X2006 VSS.t1214 VDD VSS.t1214 VSS.t1154 sg13_lv_nmos ad=79.8f pd=0.8u as=0 ps=0 w=0.42u l=1u
X2007 VSS.t1510 VDD VSS.t1509 VSS.t1508 sg13_lv_nmos ad=0.1428p pd=1.52u as=0 ps=0 w=0.42u l=1u
X2008 VSS.t2419 VDD VSS.t2418 VSS.t2417 sg13_lv_nmos ad=0.1428p pd=1.52u as=0 ps=0 w=0.42u l=1u
X2009 VDD VSS.t2303 VDD VDD sg13_lv_pmos ad=0.34p pd=2.68u as=0 ps=0 w=1u l=1u
X2010 VSS.t405 VDD VSS.t406 VSS.t11 sg13_lv_nmos ad=79.8f pd=0.8u as=0 ps=0 w=0.42u l=1u
X2011 VDD VSS.t617 VDD VDD sg13_lv_pmos ad=0.19p pd=1.38u as=0 ps=0 w=1u l=1u
X2012 VDD sg13cmos5l_xnor2_1_2.A a_6540_13238# VDD sg13_lv_pmos ad=0.4536p pd=2.76u as=0.1596p ps=1.22u w=0.84u l=0.13u
X2013 a_22426_15202# sg13cmos5l_dfrbpq_1_6.Q VDD VDD sg13_lv_pmos ad=0.1428p pd=1.52u as=0.1523p ps=1.38u w=0.42u l=0.13u
X2014 VDD VSS.t394 VDD VDD sg13_lv_pmos ad=0.19p pd=1.38u as=0 ps=0 w=1u l=1u
X2015 VSS.t1485 VDD VSS.t1487 VSS.t1486 sg13_lv_nmos ad=79.8f pd=0.8u as=0 ps=0 w=0.42u l=1u
X2016 sg13cmos5l_dfrbpq_1_3.Q a_19530_14484# VSS.t52 VSS.t9 sg13_lv_nmos ad=0.2516p pd=2.16u as=0.1406p ps=1.12u w=0.74u l=0.13u
X2017 VSS.t1431 VDD VSS.t1301 VSS.t1154 sg13_lv_nmos ad=0.1428p pd=1.52u as=0 ps=0 w=0.42u l=1u
X2018 VDD VSS.t540 VDD VDD sg13_lv_pmos ad=0.34p pd=2.68u as=0 ps=0 w=1u l=1u
X2019 VDD VSS.t2644 VDD VDD sg13_lv_pmos ad=0.19p pd=1.38u as=0 ps=0 w=1u l=1u
X2020 VSS.t1877 VDD VSS.t1876 VSS.t1875 sg13_lv_nmos ad=0.1428p pd=1.52u as=0 ps=0 w=0.42u l=1u
X2021 a_3333_15213# sg13cmos5l_dfrbpq_1_2.CLK VDD VDD sg13_lv_pmos ad=0.4088p pd=2.97u as=2.77542p ps=17.49u w=1.12u l=0.13u
X2022 VSS.t2047 VDD VSS.t2049 VSS.t2048 sg13_lv_nmos ad=79.8f pd=0.8u as=0 ps=0 w=0.42u l=1u
X2023 VDD VSS.t2004 VDD VDD sg13_lv_pmos ad=0.19p pd=1.38u as=0 ps=0 w=1u l=1u
X2024 VDD VSS.t1202 VDD VDD sg13_lv_pmos ad=0.19p pd=1.38u as=0 ps=0 w=1u l=1u
X2025 VDD VSS.t2358 VDD VDD sg13_lv_pmos ad=0.34p pd=2.68u as=0 ps=0 w=1u l=1u
X2026 VDD VSS.t3 VDD VDD sg13_lv_pmos ad=0.34p pd=2.68u as=0 ps=0 w=1u l=1u
X2027 VSS.t1480 VDD VSS.t1482 VSS.t1481 sg13_lv_nmos ad=79.8f pd=0.8u as=0 ps=0 w=0.42u l=1u
X2028 VDD VSS.t3106 VDD VDD sg13_lv_pmos ad=0.34p pd=2.68u as=0 ps=0 w=1u l=1u
X2029 VSS.t2389 VDD VSS.t2391 VSS.t2390 sg13_lv_nmos ad=79.8f pd=0.8u as=0 ps=0 w=0.42u l=1u
X2030 VSS.t1675 VDD VSS.t1677 VSS.t1676 sg13_lv_nmos ad=79.8f pd=0.8u as=0 ps=0 w=0.42u l=1u
X2031 VDD VSS.t403 VDD VDD sg13_lv_pmos ad=0.19p pd=1.38u as=0 ps=0 w=1u l=1u
X2032 VDD VSS.t1599 VDD VDD sg13_lv_pmos ad=0.34p pd=2.68u as=0 ps=0 w=1u l=1u
X2033 VSS.t1967 VDD VSS.t1966 VSS.t1965 sg13_lv_nmos ad=0.1428p pd=1.52u as=0 ps=0 w=0.42u l=1u
X2034 VSS.t984 VDD VSS.t986 VSS.t985 sg13_lv_nmos ad=79.8f pd=0.8u as=0 ps=0 w=0.42u l=1u
X2035 VDD VSS.t1246 VDD VDD sg13_lv_pmos ad=0.34p pd=2.68u as=0 ps=0 w=1u l=1u
X2036 VDD VSS.t2909 VDD VDD sg13_lv_pmos ad=0.19p pd=1.38u as=0 ps=0 w=1u l=1u
X2037 VSS.t2967 VDD VSS.t2969 VSS.t2968 sg13_lv_nmos ad=79.8f pd=0.8u as=0 ps=0 w=0.42u l=1u
X2038 VDD a_7532_15960# counter_value_o[1] VDD sg13_lv_pmos ad=0.2114p pd=1.54u as=0.42p ps=2.99u w=1.12u l=0.13u
X2039 VDD VSS.t958 VDD VDD sg13_lv_pmos ad=0.34p pd=2.68u as=0 ps=0 w=1u l=1u
X2040 VSS.t1196 VDD VSS.t1195 VSS.t1154 sg13_lv_nmos ad=0.1428p pd=1.52u as=0 ps=0 w=0.42u l=1u
X2041 VDD VSS.t1517 VDD VDD sg13_lv_pmos ad=0.19p pd=1.38u as=0 ps=0 w=1u l=1u
X2042 VSS.t21 a_15579_14854# sg13cmos5l_buf_8_2.A VSS.t3246 sg13_lv_nmos ad=0.1406p pd=1.12u as=0.1406p ps=1.12u w=0.74u l=0.13u
X2043 a_27502_15423# a_27617_15424# VSS.t11 VSS.t11 sg13_lv_nmos ad=0.1428p pd=1.52u as=0.1426p ps=1.16u w=0.42u l=0.5u
X2044 VDD VSS.t1292 VDD VDD sg13_lv_pmos ad=0.19p pd=1.38u as=0 ps=0 w=1u l=1u
X2045 VDD VSS.t2763 VDD VDD sg13_lv_pmos ad=0.34p pd=2.68u as=0 ps=0 w=1u l=1u
X2046 VDD VSS.t2664 VDD VDD sg13_lv_pmos ad=0.19p pd=1.38u as=0 ps=0 w=1u l=1u
X2047 VSS.t129 a_10960_15454# a_10609_15311# VSS.t128 sg13_lv_nmos ad=79.8f pd=0.8u as=0.1428p ps=1.52u w=0.42u l=0.13u
X2048 VDD VSS.t2473 VDD VDD sg13_lv_pmos ad=0.34p pd=2.68u as=0 ps=0 w=1u l=1u
X2049 VSS.t784 VDD VSS.t783 VSS.t782 sg13_lv_nmos ad=0.1428p pd=1.52u as=0 ps=0 w=0.42u l=1u
X2050 VSS.t162 a_19120_14726# a_18769_14845# VSS.t9 sg13_lv_nmos ad=79.8f pd=0.8u as=0.1428p ps=1.52u w=0.42u l=0.13u
X2051 VSS.t1470 VDD VSS.t1472 VSS.t1471 sg13_lv_nmos ad=79.8f pd=0.8u as=0 ps=0 w=0.42u l=1u
X2052 VSS.t1700 VDD VSS.t1699 VSS.t1698 sg13_lv_nmos ad=0.1428p pd=1.52u as=0 ps=0 w=0.42u l=1u
X2053 VDD a_10703_15311# a_10960_15454# VDD sg13_lv_pmos ad=2.8961p pd=18.25u as=79.8f ps=0.8u w=0.42u l=0.13u
X2054 a_6086_14922# a_6891_14495# a_6346_14452# VDD sg13_lv_pmos ad=0.1428p pd=1.52u as=79.8f ps=0.8u w=0.42u l=0.13u
X2055 VSS.t423 VDD VSS.t424 VSS.t11 sg13_lv_nmos ad=79.8f pd=0.8u as=0 ps=0 w=0.42u l=1u
X2056 VSS.t999 VDD VSS.t1001 VSS.t1000 sg13_lv_nmos ad=79.8f pd=0.8u as=0 ps=0 w=0.42u l=1u
X2057 VDD VSS.t1255 VDD VDD sg13_lv_pmos ad=0.34p pd=2.68u as=0 ps=0 w=1u l=1u
X2058 VDD VSS.t678 VDD VDD sg13_lv_pmos ad=0.19p pd=1.38u as=0 ps=0 w=1u l=1u
X2059 VDD VSS.t1989 VDD VDD sg13_lv_pmos ad=0.19p pd=1.38u as=0 ps=0 w=1u l=1u
X2060 VDD VSS.t44 VDD VDD sg13_lv_pmos ad=0.34p pd=2.68u as=0 ps=0 w=1u l=1u
X2061 VSS.t566 VDD VSS.t565 VSS.t564 sg13_lv_nmos ad=0.1428p pd=1.52u as=0 ps=0 w=0.42u l=1u
X2062 VDD VSS.t98 VDD VDD sg13_lv_pmos ad=0.34p pd=2.68u as=0 ps=0 w=1u l=1u
X2063 VDD VSS.t3126 VDD VDD sg13_lv_pmos ad=0.34p pd=2.68u as=0 ps=0 w=1u l=1u
X2064 VDD VSS.t1190 VDD VDD sg13_lv_pmos ad=0.19p pd=1.38u as=0 ps=0 w=1u l=1u
X2065 VDD VSS.t1672 VDD VDD sg13_lv_pmos ad=0.19p pd=1.38u as=0 ps=0 w=1u l=1u
X2066 VDD VSS.t2747 VDD VDD sg13_lv_pmos ad=0.19p pd=1.38u as=0 ps=0 w=1u l=1u
X2067 VDD VSS.t1292 VDD VDD sg13_lv_pmos ad=0.19p pd=1.38u as=0 ps=0 w=1u l=1u
X2068 VSS.t1173 VDD VSS.t1174 VSS.t1154 sg13_lv_nmos ad=79.8f pd=0.8u as=0 ps=0 w=0.42u l=1u
X2069 VSS.t1630 VDD VSS.t1629 VSS.t1628 sg13_lv_nmos ad=0.1428p pd=1.52u as=0 ps=0 w=0.42u l=1u
X2070 VSS.t3112 VDD VSS.t3111 VSS.t3110 sg13_lv_nmos ad=0.1428p pd=1.52u as=0 ps=0 w=0.42u l=1u
X2071 a_26170_15202# sg13cmos5l_a21oi_1_3.Y VDD VDD sg13_lv_pmos ad=0.1428p pd=1.52u as=0.1523p ps=1.38u w=0.42u l=0.13u
X2072 VSS.t1495 VDD VSS.t1494 VSS.t1493 sg13_lv_nmos ad=0.1428p pd=1.52u as=0 ps=0 w=0.42u l=1u
X2073 VSS.t2404 VDD VSS.t2403 VSS.t2402 sg13_lv_nmos ad=0.1428p pd=1.52u as=0 ps=0 w=0.42u l=1u
X2074 VSS.t187 sg13cmos5l_dfrbpq_1_0.RESET_B a_2724_15234# VSS.t3230 sg13_lv_nmos ad=0.1626p pd=1.415u as=60.89999f ps=0.71u w=0.42u l=0.13u
X2075 VSS.t2721 VDD VSS.t2723 VSS.t198 sg13_lv_nmos ad=79.8f pd=0.8u as=0 ps=0 w=0.42u l=1u
X2076 VSS.t2374 VDD VSS.t2376 VSS.t2375 sg13_lv_nmos ad=79.8f pd=0.8u as=0 ps=0 w=0.42u l=1u
X2077 VDD VSS.t988 VDD VDD sg13_lv_pmos ad=0.34p pd=2.68u as=0 ps=0 w=1u l=1u
X2078 VDD VSS.t2921 VDD VDD sg13_lv_pmos ad=0.34p pd=2.68u as=0 ps=0 w=1u l=1u
X2079 VDD VSS.t132 VDD VDD sg13_lv_pmos ad=0.19p pd=1.38u as=0 ps=0 w=1u l=1u
X2080 VDD VSS.t803 VDD VDD sg13_lv_pmos ad=0.34p pd=2.68u as=0 ps=0 w=1u l=1u
X2081 VDD VSS.t1462 VDD VDD sg13_lv_pmos ad=0.19p pd=1.38u as=0 ps=0 w=1u l=1u
X2082 VSS.t11 VDD VSS.t11 VSS.t451 sg13_lv_nmos ad=0.1428p pd=1.52u as=0 ps=0 w=0.42u l=1u
X2083 VDD VSS.t540 VDD VDD sg13_lv_pmos ad=0.34p pd=2.68u as=0 ps=0 w=1u l=1u
X2084 VSS.t526 VDD VSS.t528 VSS.t527 sg13_lv_nmos ad=79.8f pd=0.8u as=0 ps=0 w=0.42u l=1u
X2085 VSS.t2684 VDD VSS.t2685 VSS.t198 sg13_lv_nmos ad=79.8f pd=0.8u as=0 ps=0 w=0.42u l=1u
X2086 VSS.t267 VDD VSS.t267 VSS.t266 sg13_lv_nmos ad=0.1428p pd=1.52u as=0 ps=0 w=0.42u l=1u
X2087 VDD VSS.t2637 VDD VDD sg13_lv_pmos ad=0.19p pd=1.38u as=0 ps=0 w=1u l=1u
X2088 VSS.t1862 VDD VSS.t1861 VSS.t1860 sg13_lv_nmos ad=0.1428p pd=1.52u as=0 ps=0 w=0.42u l=1u
X2089 VSS.t2942 VDD VSS.t2941 VSS.t2940 sg13_lv_nmos ad=0.1428p pd=1.52u as=0 ps=0 w=0.42u l=1u
X2090 sg13cmos5l_or3_1_1.B a_14261_15238# VSS.t111 VSS.t206 sg13_lv_nmos ad=0.1406p pd=1.12u as=0.1406p ps=1.12u w=0.74u l=0.13u
X2091 VDD VSS.t1428 VDD VDD sg13_lv_pmos ad=0.34p pd=2.68u as=0 ps=0 w=1u l=1u
X2092 VSS.t2017 VDD VSS.t2019 VSS.t2018 sg13_lv_nmos ad=79.8f pd=0.8u as=0 ps=0 w=0.42u l=1u
X2093 VDD VSS.t2685 VDD VDD sg13_lv_pmos ad=0.34p pd=2.68u as=0 ps=0 w=1u l=1u
X2094 VDD VSS.t1941 VDD VDD sg13_lv_pmos ad=0.34p pd=2.68u as=0 ps=0 w=1u l=1u
X2095 VDD VSS.t430 VDD VDD sg13_lv_pmos ad=0.19p pd=1.38u as=0 ps=0 w=1u l=1u
X2096 VSS.t1660 VDD VSS.t1662 VSS.t1661 sg13_lv_nmos ad=79.8f pd=0.8u as=0 ps=0 w=0.42u l=1u
X2097 VDD VSS.t866 VDD VDD sg13_lv_pmos ad=0.19p pd=1.38u as=0 ps=0 w=1u l=1u
X2098 VDD VSS.t1181 VDD VDD sg13_lv_pmos ad=0.19p pd=1.38u as=0 ps=0 w=1u l=1u
X2099 VDD VSS.t2739 VDD VDD sg13_lv_pmos ad=0.19p pd=1.38u as=0 ps=0 w=1u l=1u
X2100 VSS.t2052 VDD VSS.t2051 VSS.t2050 sg13_lv_nmos ad=0.1428p pd=1.52u as=0 ps=0 w=0.42u l=1u
X2101 a_24923_15996# sg13cmos5l_a21oi_1_3.B1 sg13cmos5l_dlygate4sd3_1_17.A VDD sg13_lv_pmos ad=0.2128p pd=1.5u as=0.3808p ps=2.92u w=1.12u l=0.13u
X2102 VSS.t602 VDD VSS.t599 VSS.t601 sg13_lv_nmos ad=0.1428p pd=1.52u as=0 ps=0 w=0.42u l=1u
X2103 VSS.t1615 VDD VSS.t1614 VSS.t1613 sg13_lv_nmos ad=0.1428p pd=1.52u as=0 ps=0 w=0.42u l=1u
X2104 VDD VSS.t2894 VDD VDD sg13_lv_pmos ad=0.19p pd=1.38u as=0 ps=0 w=1u l=1u
X2105 VSS.t3132 VDD VSS.t3131 VSS.t3130 sg13_lv_nmos ad=0.1428p pd=1.52u as=0 ps=0 w=0.42u l=1u
X2106 VSS.t2952 VDD VSS.t2954 VSS.t2953 sg13_lv_nmos ad=79.8f pd=0.8u as=0 ps=0 w=0.42u l=1u
X2107 a_18202_15202# sg13cmos5l_dfrbpq_1_2.Q VSS.t13 VSS.t3222 sg13_lv_nmos ad=0.1428p pd=1.52u as=79.8f ps=0.8u w=0.42u l=0.13u
X2108 VDD VSS.t1624 VDD VDD sg13_lv_pmos ad=0.34p pd=2.68u as=0 ps=0 w=1u l=1u
X2109 a_2630_15234# a_3435_15356# a_2890_15457# VDD sg13_lv_pmos ad=0.1428p pd=1.52u as=79.8f ps=0.8u w=0.42u l=0.13u
X2110 VDD VSS.t1679 VDD VDD sg13_lv_pmos ad=0.34p pd=2.68u as=0 ps=0 w=1u l=1u
X2111 VSS.t2424 VDD VSS.t2423 VSS.t2422 sg13_lv_nmos ad=0.1428p pd=1.52u as=0 ps=0 w=0.42u l=1u
X2112 VDD VSS.t404 VDD VDD sg13_lv_pmos ad=0.34p pd=2.68u as=0 ps=0 w=1u l=1u
X2113 VDD VSS.t2308 VDD VDD sg13_lv_pmos ad=0.34p pd=2.68u as=0 ps=0 w=1u l=1u
X2114 VSS.t784 VDD VSS.t783 VSS.t782 sg13_lv_nmos ad=0.1428p pd=1.52u as=0 ps=0 w=0.42u l=1u
X2115 VDD VSS.t2754 VDD VDD sg13_lv_pmos ad=0.34p pd=2.68u as=0 ps=0 w=1u l=1u
X2116 a_25956_14488# a_25930_14452# VDD VDD sg13_lv_pmos ad=0.34p pd=2.68u as=0.36237p ps=2.605u w=1u l=0.13u
X2117 VDD a_4432_15454# a_4377_15549# VDD sg13_lv_pmos ad=2.8961p pd=18.25u as=93.45f ps=0.865u w=0.42u l=0.13u
X2118 VSS.t72 VDD VSS.t72 VSS.t515 sg13_lv_nmos ad=0.1428p pd=1.52u as=0 ps=0 w=0.42u l=1u
X2119 VDD VSS.t1200 VDD VDD sg13_lv_pmos ad=0.19p pd=1.38u as=0 ps=0 w=1u l=1u
X2120 VSS.t1525 VDD VSS.t1527 VSS.t1526 sg13_lv_nmos ad=79.8f pd=0.8u as=0 ps=0 w=0.42u l=1u
X2121 VSS.t1274 VDD VSS.t1274 VSS.t1154 sg13_lv_nmos ad=79.8f pd=0.8u as=0 ps=0 w=0.42u l=1u
X2122 VSS.t1455 VDD VSS.t1457 VSS.t1456 sg13_lv_nmos ad=79.8f pd=0.8u as=0 ps=0 w=0.42u l=1u
X2123 VDD VSS.t2647 VDD VDD sg13_lv_pmos ad=0.19p pd=1.38u as=0 ps=0 w=1u l=1u
X2124 VSS.t1847 VDD VSS.t1846 VSS.t1845 sg13_lv_nmos ad=0.1428p pd=1.52u as=0 ps=0 w=0.42u l=1u
X2125 VSS.t3 a_37484_15960# counter_value_o[7] VSS.t2 sg13_lv_nmos ad=0.14875p pd=1.16u as=0.2886p ps=2.26u w=0.74u l=0.13u
X2126 VSS.t417 VDD VSS.t418 VSS.t11 sg13_lv_nmos ad=79.8f pd=0.8u as=0 ps=0 w=0.42u l=1u
X2127 VDD VSS.t410 VDD VDD sg13_lv_pmos ad=0.34p pd=2.68u as=0 ps=0 w=1u l=1u
X2128 VDD VSS.t1205 VDD VDD sg13_lv_pmos ad=0.19p pd=1.38u as=0 ps=0 w=1u l=1u
X2129 VDD VSS.t2705 VDD VDD sg13_lv_pmos ad=0.19p pd=1.38u as=0 ps=0 w=1u l=1u
X2130 VSS.t2389 VDD VSS.t2388 VSS.t2387 sg13_lv_nmos ad=0.1428p pd=1.52u as=0 ps=0 w=0.42u l=1u
X2131 VSS.t111 sg13cmos5l_nand4_1_0.Y a_14261_15238# VSS.t3186 sg13_lv_nmos ad=0.3293p pd=1.63u as=0.2516p ps=2.16u w=0.74u l=0.13u
X2132 VSS.t87 a_17584_13942# a_17233_13799# VSS.t153 sg13_lv_nmos ad=79.8f pd=0.8u as=0.1428p ps=1.52u w=0.42u l=0.13u
X2133 VDD VSS.t2328 VDD VDD sg13_lv_pmos ad=0.34p pd=2.68u as=0 ps=0 w=1u l=1u
X2134 a_16596_15280# sg13cmos5l_or3_1_2.B a_16140_15424# VSS.t3293 sg13_lv_nmos ad=78.39999f pd=0.885u as=0.2176p ps=1.96u w=0.64u l=0.13u
X2135 a_7833_14607# a_6891_14495# a_7631_14845# VDD sg13_lv_pmos ad=93.45f pd=0.865u as=0.2048p ps=1.63u w=0.42u l=0.13u
X2136 a_16485_13701# sg13cmos5l_dfrbpq_1_2.CLK VSS.t72 VSS.t3183 sg13_lv_nmos ad=0.2516p pd=2.16u as=15.38618p ps=0.10091m w=0.74u l=0.13u
X2137 VSS.t291 VDD VSS.t291 VSS.t297 sg13_lv_nmos ad=0.1428p pd=1.52u as=0 ps=0 w=0.42u l=1u
X2138 VSS.t3 VDD VSS.t3 VSS.t377 sg13_lv_nmos ad=0.1428p pd=1.52u as=0 ps=0 w=0.42u l=1u
X2139 VSS.t438 VDD VSS.t437 VSS.t11 sg13_lv_nmos ad=0.1428p pd=1.52u as=0 ps=0 w=0.42u l=1u
X2140 VDD VSS.t1969 VDD VDD sg13_lv_pmos ad=0.19p pd=1.38u as=0 ps=0 w=1u l=1u
X2141 VSS.t1937 VDD VSS.t1936 VSS.t1935 sg13_lv_nmos ad=0.1428p pd=1.52u as=0 ps=0 w=0.42u l=1u
X2142 VSS.t2454 VDD VSS.t2456 VSS.t2455 sg13_lv_nmos ad=79.8f pd=0.8u as=0 ps=0 w=0.42u l=1u
X2143 VDD VSS.t1522 VDD VDD sg13_lv_pmos ad=0.19p pd=1.38u as=0 ps=0 w=1u l=1u
X2144 a_17584_13942# a_17327_13799# a_17746_13722# VSS.t85 sg13_lv_nmos ad=0.1428p pd=1.52u as=37.8f ps=0.6u w=0.42u l=0.13u
X2145 VSS.t2621 VDD VSS.t2621 VSS.t198 sg13_lv_nmos ad=0.1428p pd=1.52u as=0 ps=0 w=0.42u l=1u
X2146 VSS.t984 VDD VSS.t983 VSS.t982 sg13_lv_nmos ad=0.1428p pd=1.52u as=0 ps=0 w=0.42u l=1u
X2147 VDD VSS.t2667 VDD VDD sg13_lv_pmos ad=0.19p pd=1.38u as=0 ps=0 w=1u l=1u
X2148 VSS.t3002 VDD VSS.t3001 VSS.t3000 sg13_lv_nmos ad=0.1428p pd=1.52u as=0 ps=0 w=0.42u l=1u
X2149 VSS.t279 VDD VSS.t279 VSS.t280 sg13_lv_nmos ad=79.8f pd=0.8u as=0 ps=0 w=0.42u l=1u
X2150 VDD VSS.t1036 VDD VDD sg13_lv_pmos ad=0.19p pd=1.38u as=0 ps=0 w=1u l=1u
X2151 VDD VSS.t2906 VDD VDD sg13_lv_pmos ad=0.34p pd=2.68u as=0 ps=0 w=1u l=1u
X2152 VSS.t1475 VDD VSS.t1477 VSS.t1476 sg13_lv_nmos ad=79.8f pd=0.8u as=0 ps=0 w=0.42u l=1u
X2153 VSS.t1670 VDD VSS.t1669 VSS.t1668 sg13_lv_nmos ad=0.1428p pd=1.52u as=0 ps=0 w=0.42u l=1u
X2154 VDD VSS.t1487 VDD VDD sg13_lv_pmos ad=0.19p pd=1.38u as=0 ps=0 w=1u l=1u
X2155 VSS.t2676 VDD VSS.t2677 VSS.t198 sg13_lv_nmos ad=79.8f pd=0.8u as=0 ps=0 w=0.42u l=1u
X2156 VDD VSS.t2396 VDD VDD sg13_lv_pmos ad=0.19p pd=1.38u as=0 ps=0 w=1u l=1u
X2157 a_18454_16374# sg13cmos5l_or3_1_2.B VSS.t322 VSS.t3288 sg13_lv_nmos ad=0.1406p pd=1.12u as=0.1406p ps=1.12u w=0.74u l=0.15u
X2158 a_9732_15247# a_9963_15356# a_9418_15457# VSS.t92 sg13_lv_nmos ad=0.2373p pd=1.97u as=79.8f ps=0.8u w=0.42u l=0.13u
X2159 a_9670_15247# sg13cmos5l_tiehi_1.L_HI VSS.t1 VSS.t92 sg13_lv_nmos ad=37.8f pd=0.6u as=0.1701p ps=1.65u w=0.42u l=0.13u
X2160 a_25094_14484# a_24824_14525# VDD VDD sg13_lv_pmos ad=0.34p pd=2.68u as=0.1523p ps=1.38u w=1u l=0.5u
X2161 sg13cmos5l_dfrbpq_1_7.Q a_27882_14484# VDD VDD sg13_lv_pmos ad=0.3808p pd=2.92u as=0.2128p ps=1.5u w=1.12u l=0.13u
X2162 VSS.t2284 VDD VSS.t2286 VSS.t2285 sg13_lv_nmos ad=79.8f pd=0.8u as=0 ps=0 w=0.42u l=1u
X2163 VSS.t2002 VDD VSS.t2004 VSS.t2003 sg13_lv_nmos ad=79.8f pd=0.8u as=0 ps=0 w=0.42u l=1u
X2164 VSS.t596 VDD VSS.t596 VSS.t734 sg13_lv_nmos ad=0.1428p pd=1.52u as=0 ps=0 w=0.42u l=1u
X2165 a_7532_15960# sg13cmos5l_dlygate4sd3_1_1.A VSS.t283 VSS.t3173 sg13_lv_nmos ad=0.187p pd=1.78u as=0.14875p ps=1.16u w=0.55u l=0.13u
X2166 VSS.t1292 VDD VSS.t1292 VSS.t1154 sg13_lv_nmos ad=79.8f pd=0.8u as=0 ps=0 w=0.42u l=1u
X2167 VDD VSS.t2677 VDD VDD sg13_lv_pmos ad=0.34p pd=2.68u as=0 ps=0 w=1u l=1u
X2168 VSS.t1957 VDD VSS.t1956 VSS.t1955 sg13_lv_nmos ad=0.1428p pd=1.52u as=0 ps=0 w=0.42u l=1u
X2169 VDD VSS.t1173 VDD VDD sg13_lv_pmos ad=0.19p pd=1.38u as=0 ps=0 w=1u l=1u
X2170 VSS.t1600 VDD VSS.t1599 VSS.t1598 sg13_lv_nmos ad=0.1428p pd=1.52u as=0 ps=0 w=0.42u l=1u
X2171 VSS.t3117 VDD VSS.t3116 VSS.t3115 sg13_lv_nmos ad=0.1428p pd=1.52u as=0 ps=0 w=0.42u l=1u
X2172 VDD VSS.t2653 VDD VDD sg13_lv_pmos ad=0.34p pd=2.68u as=0 ps=0 w=1u l=1u
X2173 VSS.t309 VDD VSS.t311 VSS.t310 sg13_lv_nmos ad=79.8f pd=0.8u as=0 ps=0 w=0.42u l=1u
X2174 a_10618_14448# sg13cmos5l_dlygate4sd3_1_8.A VSS.t129 VSS.t151 sg13_lv_nmos ad=0.1428p pd=1.52u as=79.8f ps=0.8u w=0.42u l=0.13u
X2175 VDD VSS.t431 VDD VDD sg13_lv_pmos ad=0.34p pd=2.68u as=0 ps=0 w=1u l=1u
X2176 VDD VSS.t1664 VDD VDD sg13_lv_pmos ad=0.34p pd=2.68u as=0 ps=0 w=1u l=1u
X2177 VSS.t1500 VDD VSS.t1499 VSS.t1498 sg13_lv_nmos ad=0.1428p pd=1.52u as=0 ps=0 w=0.42u l=1u
X2178 VSS.t2409 VDD VSS.t2408 VSS.t2407 sg13_lv_nmos ad=0.1428p pd=1.52u as=0 ps=0 w=0.42u l=1u
X2179 VSS.t1515 VDD VSS.t1517 VSS.t1516 sg13_lv_nmos ad=79.8f pd=0.8u as=0 ps=0 w=0.42u l=1u
X2180 VDD VSS.t1003 VDD VDD sg13_lv_pmos ad=0.34p pd=2.68u as=0 ps=0 w=1u l=1u
X2181 VSS.t2725 VDD VSS.t2726 VSS.t198 sg13_lv_nmos ad=79.8f pd=0.8u as=0 ps=0 w=0.42u l=1u
X2182 VSS.t1907 VDD VSS.t1906 VSS.t1905 sg13_lv_nmos ad=0.1428p pd=1.52u as=0 ps=0 w=0.42u l=1u
X2183 VDD VSS.t1467 VDD VDD sg13_lv_pmos ad=0.19p pd=1.38u as=0 ps=0 w=1u l=1u
X2184 VDD VSS.t2926 VDD VDD sg13_lv_pmos ad=0.34p pd=2.68u as=0 ps=0 w=1u l=1u
X2185 VDD VSS.t3099 VDD VDD sg13_lv_pmos ad=0.19p pd=1.38u as=0 ps=0 w=1u l=1u
X2186 VSS.t1510 VDD VSS.t1512 VSS.t1511 sg13_lv_nmos ad=79.8f pd=0.8u as=0 ps=0 w=0.42u l=1u
X2187 VSS.t1690 VDD VSS.t1689 VSS.t1688 sg13_lv_nmos ad=0.1428p pd=1.52u as=0 ps=0 w=0.42u l=1u
X2188 VDD VSS.t1472 VDD VDD sg13_lv_pmos ad=0.19p pd=1.38u as=0 ps=0 w=1u l=1u
X2189 sg13cmos5l_buf_8_2.X a_19323_13726# VSS.t698 VSS.t3255 sg13_lv_nmos ad=0.1406p pd=1.12u as=0.1406p ps=1.12u w=0.74u l=0.13u
X2190 VSS.t2668 VDD VSS.t2669 VSS.t198 sg13_lv_nmos ad=79.8f pd=0.8u as=0 ps=0 w=0.42u l=1u
X2191 VDD VSS.t2639 VDD VDD sg13_lv_pmos ad=0.19p pd=1.38u as=0 ps=0 w=1u l=1u
X2192 VDD VSS.t2381 VDD VDD sg13_lv_pmos ad=0.19p pd=1.38u as=0 ps=0 w=1u l=1u
X2193 VSS.t119 VDD VSS.t119 VSS.t388 sg13_lv_nmos ad=0.1428p pd=1.52u as=0 ps=0 w=0.42u l=1u
X2194 VDD VSS.t145 VDD VDD sg13_lv_pmos ad=0.34p pd=2.68u as=0 ps=0 w=1u l=1u
X2195 VSS.t2947 VDD VSS.t2946 VSS.t2945 sg13_lv_nmos ad=0.1428p pd=1.52u as=0 ps=0 w=0.42u l=1u
X2196 VDD VSS.t1301 VDD VDD sg13_lv_pmos ad=0.34p pd=2.68u as=0 ps=0 w=1u l=1u
X2197 VSS.t1987 VDD VSS.t1989 VSS.t1988 sg13_lv_nmos ad=79.8f pd=0.8u as=0 ps=0 w=0.42u l=1u
X2198 VDD a_9658_14725# sg13cmos5l_tiehi_1.L_HI VDD sg13_lv_pmos ad=2.42015p pd=15.68u as=0.3927p ps=2.99u w=1.155u l=0.13u
X2199 VDD VSS.t2688 VDD VDD sg13_lv_pmos ad=0.34p pd=2.68u as=0 ps=0 w=1u l=1u
X2200 VDD VSS.t2506 VDD VDD sg13_lv_pmos ad=0.19p pd=1.38u as=0 ps=0 w=1u l=1u
X2201 VDD VSS.t1946 VDD VDD sg13_lv_pmos ad=0.34p pd=2.68u as=0 ps=0 w=1u l=1u
X2202 a_6789_14495# sg13cmos5l_dfrbpq_1_2.CLK VDD VDD sg13_lv_pmos ad=0.4088p pd=2.97u as=2.3367p ps=15.135u w=1.12u l=0.13u
X2203 VDD VSS.t1278 VDD VDD sg13_lv_pmos ad=0.19p pd=1.38u as=0 ps=0 w=1u l=1u
X2204 VDD sg13cmos5l_dfrbpq_1_3.Q sg13cmos5l_o21ai_1_2.A2 VDD sg13_lv_pmos ad=0.2128p pd=1.5u as=0.2128p ps=1.5u w=1.12u l=0.13u
X2205 a_25764_14922# sg13cmos5l_dfrbpq_1_7.D a_25670_14922# VSS.t4 sg13_lv_nmos ad=60.89999f pd=0.71u as=0.1428p ps=1.52u w=0.42u l=0.13u
X2206 a_24365_14508# sg13cmos5l_or3_1_2.B a_24263_14508# VDD sg13_lv_pmos ad=0.1575p pd=1.315u as=0.19p ps=1.38u w=1u l=0.13u
X2207 VDD VSS.t620 VDD VDD sg13_lv_pmos ad=0.19p pd=1.38u as=0 ps=0 w=1u l=1u
X2208 VSS.t1226 VDD VSS.t1226 VSS.t1154 sg13_lv_nmos ad=79.8f pd=0.8u as=0 ps=0 w=0.42u l=1u
X2209 VDD VSS.t1629 VDD VDD sg13_lv_pmos ad=0.34p pd=2.68u as=0 ps=0 w=1u l=1u
X2210 VSS.t614 VDD VSS.t614 VSS.t746 sg13_lv_nmos ad=0.1428p pd=1.52u as=0 ps=0 w=0.42u l=1u
X2211 VDD VSS.t1684 VDD VDD sg13_lv_pmos ad=0.34p pd=2.68u as=0 ps=0 w=1u l=1u
X2212 VDD VSS.t1841 VDD VDD sg13_lv_pmos ad=0.34p pd=2.68u as=0 ps=0 w=1u l=1u
X2213 VSS.t984 VDD VSS.t983 VSS.t982 sg13_lv_nmos ad=0.1428p pd=1.52u as=0 ps=0 w=0.42u l=1u
X2214 VDD VSS.t966 VDD VDD sg13_lv_pmos ad=0.19p pd=1.38u as=0 ps=0 w=1u l=1u
X2215 VDD VSS.t2757 VDD VDD sg13_lv_pmos ad=0.34p pd=2.68u as=0 ps=0 w=1u l=1u
X2216 VDD a_26373_14495# a_26475_14495# VDD sg13_lv_pmos ad=2.42015p pd=15.68u as=0.3864p ps=2.93u w=1.12u l=0.13u
X2217 sg13cmos5l_or3_1_1.X a_24841_13726# VDD VDD sg13_lv_pmos ad=0.3808p pd=2.92u as=0.3822p ps=1.84u w=1.12u l=0.13u
X2218 VSS.t1315 VDD VSS.t1314 VSS.t1154 sg13_lv_nmos ad=0.1428p pd=1.52u as=0 ps=0 w=0.42u l=1u
X2219 VDD VSS.t560 VDD VDD sg13_lv_pmos ad=0.34p pd=2.68u as=0 ps=0 w=1u l=1u
X2220 VDD VSS.t893 VDD VDD sg13_lv_pmos ad=0.34p pd=2.68u as=0 ps=0 w=1u l=1u
X2221 VSS.t1460 VDD VSS.t1462 VSS.t1461 sg13_lv_nmos ad=79.8f pd=0.8u as=0 ps=0 w=0.42u l=1u
X2222 VSS.t1852 VDD VSS.t1851 VSS.t1850 sg13_lv_nmos ad=0.1428p pd=1.52u as=0 ps=0 w=0.42u l=1u
X2223 a_21466_15202# sg13cmos5l_o21ai_1_1.Y VDD VDD sg13_lv_pmos ad=0.1428p pd=1.52u as=0.1523p ps=1.38u w=0.42u l=0.13u
X2224 VSS.t2932 VDD VSS.t2931 VSS.t2930 sg13_lv_nmos ad=0.1428p pd=1.52u as=0 ps=0 w=0.42u l=1u
X2225 VSS.t2770 VDD VSS.t2769 VSS.t198 sg13_lv_nmos ad=0.1428p pd=1.52u as=0 ps=0 w=0.42u l=1u
X2226 VSS.t2022 VDD VSS.t2024 VSS.t2023 sg13_lv_nmos ad=79.8f pd=0.8u as=0 ps=0 w=0.42u l=1u
X2227 VDD VSS.t1979 VDD VDD sg13_lv_pmos ad=0.19p pd=1.38u as=0 ps=0 w=1u l=1u
X2228 sg13cmos5l_dfrbpq_1_7.Q a_27882_14484# VSS.t241 VSS.t11 sg13_lv_nmos ad=0.2516p pd=2.16u as=0.1406p ps=1.12u w=0.74u l=0.13u
X2229 VDD VSS.t1208 VDD VDD sg13_lv_pmos ad=0.19p pd=1.38u as=0 ps=0 w=1u l=1u
X2230 VDD VSS.t2708 VDD VDD sg13_lv_pmos ad=0.19p pd=1.38u as=0 ps=0 w=1u l=1u
X2231 VSS.t2269 VDD VSS.t2271 VSS.t2270 sg13_lv_nmos ad=79.8f pd=0.8u as=0 ps=0 w=0.42u l=1u
X2232 VSS.t2394 VDD VSS.t2393 VSS.t2392 sg13_lv_nmos ad=0.1428p pd=1.52u as=0 ps=0 w=0.42u l=1u
X2233 VSS.t623 VDD VSS.t623 VSS.t752 sg13_lv_nmos ad=0.1428p pd=1.52u as=0 ps=0 w=0.42u l=1u
X2234 VDD VSS.t2333 VDD VDD sg13_lv_pmos ad=0.34p pd=2.68u as=0 ps=0 w=1u l=1u
X2235 VDD sg13cmos5l_tiehi_1.L_HI a_9418_15457# VDD sg13_lv_pmos ad=0.1563p pd=1.22u as=0.147p ps=1.54u w=0.42u l=0.13u
X2236 VDD VSS.t1479 VDD VDD sg13_lv_pmos ad=0.34p pd=2.68u as=0 ps=0 w=1u l=1u
X2237 VSS.t570 VDD VSS.t678 VSS.t677 sg13_lv_nmos ad=79.8f pd=0.8u as=0 ps=0 w=0.42u l=1u
X2238 VSS.t1560 VDD VSS.t1559 VSS.t1558 sg13_lv_nmos ad=0.1428p pd=1.52u as=0 ps=0 w=0.42u l=1u
X2239 VDD VSS.t768 VDD VDD sg13_lv_pmos ad=0.34p pd=2.68u as=0 ps=0 w=1u l=1u
X2240 VSS.t1208 VDD VSS.t1207 VSS.t1154 sg13_lv_nmos ad=0.1428p pd=1.52u as=0 ps=0 w=0.42u l=1u
X2241 VDD VSS.t1662 VDD VDD sg13_lv_pmos ad=0.19p pd=1.38u as=0 ps=0 w=1u l=1u
X2242 VSS.t1942 VDD VSS.t1941 VSS.t1940 sg13_lv_nmos ad=0.1428p pd=1.52u as=0 ps=0 w=0.42u l=1u
X2243 VDD VSS.t2645 VDD VDD sg13_lv_pmos ad=0.34p pd=2.68u as=0 ps=0 w=1u l=1u
X2244 VSS.t2459 VDD VSS.t2461 VSS.t2460 sg13_lv_nmos ad=79.8f pd=0.8u as=0 ps=0 w=0.42u l=1u
X2245 VDD VSS.t370 VDD VDD sg13_lv_pmos ad=0.34p pd=2.68u as=0 ps=0 w=1u l=1u
X2246 VSS.t399 VDD VSS.t241 VSS.t11 sg13_lv_nmos ad=0.1428p pd=1.52u as=0 ps=0 w=0.42u l=1u
X2247 VSS.t536 VDD VSS.t538 VSS.t537 sg13_lv_nmos ad=79.8f pd=0.8u as=0 ps=0 w=0.42u l=1u
X2248 a_25786_15960# sg13cmos5l_o21ai_1_3.Y VDD VDD sg13_lv_pmos ad=0.1428p pd=1.52u as=0.1523p ps=1.38u w=0.42u l=0.13u
X2249 VDD VSS.t583 VDD VDD sg13_lv_pmos ad=0.34p pd=2.68u as=0 ps=0 w=1u l=1u
X2250 VDD VSS.t2034 VDD VDD sg13_lv_pmos ad=0.19p pd=1.38u as=0 ps=0 w=1u l=1u
X2251 VSS.t1680 VDD VSS.t1679 VSS.t1678 sg13_lv_nmos ad=0.1428p pd=1.52u as=0 ps=0 w=0.42u l=1u
X2252 VSS.t2624 VDD VSS.t2624 VSS.t198 sg13_lv_nmos ad=0.1428p pd=1.52u as=0 ps=0 w=0.42u l=1u
X2253 VSS.t2715 VDD VSS.t2717 VSS.t198 sg13_lv_nmos ad=79.8f pd=0.8u as=0 ps=0 w=0.42u l=1u
X2254 VSS.t804 VDD VSS.t803 VSS.t802 sg13_lv_nmos ad=0.1428p pd=1.52u as=0 ps=0 w=0.42u l=1u
X2255 VSS.t1244 VDD VSS.t1245 VSS.t1154 sg13_lv_nmos ad=79.8f pd=0.8u as=0 ps=0 w=0.42u l=1u
X2256 VSS.t2972 VDD VSS.t2971 VSS.t2970 sg13_lv_nmos ad=0.1428p pd=1.52u as=0 ps=0 w=0.42u l=1u
X2257 VSS.t1328 VDD VSS.t1168 VSS.t1154 sg13_lv_nmos ad=79.8f pd=0.8u as=0 ps=0 w=0.42u l=1u
X2258 VDD VSS.t1452 VDD VDD sg13_lv_pmos ad=0.19p pd=1.38u as=0 ps=0 w=1u l=1u
X2259 VDD VSS.t2911 VDD VDD sg13_lv_pmos ad=0.34p pd=2.68u as=0 ps=0 w=1u l=1u
X2260 VSS.t435 VDD VSS.t436 VSS.t11 sg13_lv_nmos ad=79.8f pd=0.8u as=0 ps=0 w=0.42u l=1u
X2261 VSS.t1675 VDD VSS.t1674 VSS.t1673 sg13_lv_nmos ad=0.1428p pd=1.52u as=0 ps=0 w=0.42u l=1u
X2262 VSS.t402 VDD VSS.t403 VSS.t11 sg13_lv_nmos ad=79.8f pd=0.8u as=0 ps=0 w=0.42u l=1u
X2263 a_21477_14495# sg13cmos5l_buf_8_2.X VSS.t11 VSS.t79 sg13_lv_nmos ad=0.2516p pd=2.16u as=3.8707p ps=25.555u w=0.74u l=0.13u
X2264 VDD VSS.t1457 VDD VDD sg13_lv_pmos ad=0.19p pd=1.38u as=0 ps=0 w=1u l=1u
X2265 VSS.t2761 VDD VSS.t2760 VSS.t198 sg13_lv_nmos ad=0.1428p pd=1.52u as=0 ps=0 w=0.42u l=1u
X2266 VSS.t2042 VDD VSS.t2044 VSS.t2043 sg13_lv_nmos ad=79.8f pd=0.8u as=0 ps=0 w=0.42u l=1u
X2267 VSS.t2254 VDD VSS.t2256 VSS.t2255 sg13_lv_nmos ad=79.8f pd=0.8u as=0 ps=0 w=0.42u l=1u
X2268 VDD VSS.t3101 VDD VDD sg13_lv_pmos ad=0.34p pd=2.68u as=0 ps=0 w=1u l=1u
X2269 VDD VSS.t2491 VDD VDD sg13_lv_pmos ad=0.19p pd=1.38u as=0 ps=0 w=1u l=1u
X2270 VDD VSS.t923 VDD VDD sg13_lv_pmos ad=0.34p pd=2.68u as=0 ps=0 w=1u l=1u
X2271 VSS.t1184 VDD VSS.t1185 VSS.t1154 sg13_lv_nmos ad=79.8f pd=0.8u as=0 ps=0 w=0.42u l=1u
X2272 VSS.t1222 VDD VSS.t1220 VSS.t1154 sg13_lv_nmos ad=0.1428p pd=1.52u as=0 ps=0 w=0.42u l=1u
X2273 VDD VSS.t1931 VDD VDD sg13_lv_pmos ad=0.34p pd=2.68u as=0 ps=0 w=1u l=1u
X2274 a_22149_16033# a_22149_16033# VSS.t75 VSS.t189 sg13_lv_nmos ad=0.111p pd=1.34u as=7.70437p ps=50.66u w=0.3u l=0.13u
X2275 VSS.t1253 VDD VSS.t1254 VSS.t1154 sg13_lv_nmos ad=79.8f pd=0.8u as=0 ps=0 w=0.42u l=1u
X2276 VDD VSS.t1614 VDD VDD sg13_lv_pmos ad=0.34p pd=2.68u as=0 ps=0 w=1u l=1u
X2277 VSS.t1505 VDD VSS.t1504 VSS.t1503 sg13_lv_nmos ad=0.1428p pd=1.52u as=0 ps=0 w=0.42u l=1u
X2278 VSS.t2414 VDD VSS.t2413 VSS.t2412 sg13_lv_nmos ad=0.1428p pd=1.52u as=0 ps=0 w=0.42u l=1u
X2279 VDD VSS.t1008 VDD VDD sg13_lv_pmos ad=0.34p pd=2.68u as=0 ps=0 w=1u l=1u
X2280 VSS.t959 VDD VSS.t958 VSS.t957 sg13_lv_nmos ad=0.1428p pd=1.52u as=0 ps=0 w=0.42u l=1u
X2281 VSS.t1520 VDD VSS.t1522 VSS.t1521 sg13_lv_nmos ad=79.8f pd=0.8u as=0 ps=0 w=0.42u l=1u
X2282 VSS.t2727 VDD VSS.t2728 VSS.t198 sg13_lv_nmos ad=79.8f pd=0.8u as=0 ps=0 w=0.42u l=1u
X2283 VSS.t417 VDD VSS.t416 VSS.t11 sg13_lv_nmos ad=0.1428p pd=1.52u as=0 ps=0 w=0.42u l=1u
X2284 VDD VSS.t823 VDD VDD sg13_lv_pmos ad=0.34p pd=2.68u as=0 ps=0 w=1u l=1u
X2285 VSS.t1258 VDD VSS.t1259 VSS.t1154 sg13_lv_nmos ad=79.8f pd=0.8u as=0 ps=0 w=0.42u l=1u
X2286 VDD VSS.t1191 VDD VDD sg13_lv_pmos ad=0.34p pd=2.68u as=0 ps=0 w=1u l=1u
X2287 VSS.t578 VDD VSS.t578 VSS.t577 sg13_lv_nmos ad=0.1428p pd=1.52u as=0 ps=0 w=0.42u l=1u
X2288 VDD VSS.t560 VDD VDD sg13_lv_pmos ad=0.34p pd=2.68u as=0 ps=0 w=1u l=1u
X2289 VDD VSS.t2896 VDD VDD sg13_lv_pmos ad=0.34p pd=2.68u as=0 ps=0 w=1u l=1u
X2290 VDD VSS.t267 VDD VDD sg13_lv_pmos ad=0.34p pd=2.68u as=0 ps=0 w=1u l=1u
X2291 VSS.t1837 VDD VSS.t1836 VSS.t1835 sg13_lv_nmos ad=0.1428p pd=1.52u as=0 ps=0 w=0.42u l=1u
X2292 VSS.t531 VDD VSS.t530 VSS.t529 sg13_lv_nmos ad=0.1428p pd=1.52u as=0 ps=0 w=0.42u l=1u
X2293 VSS.t2917 VDD VSS.t2916 VSS.t2915 sg13_lv_nmos ad=0.1428p pd=1.52u as=0 ps=0 w=0.42u l=1u
X2294 VSS.t23 VDD VSS.t23 VSS.t591 sg13_lv_nmos ad=0.1428p pd=1.52u as=0 ps=0 w=0.42u l=1u
X2295 VSS.t1019 VDD VSS.t1021 VSS.t1020 sg13_lv_nmos ad=79.8f pd=0.8u as=0 ps=0 w=0.42u l=1u
X2296 VDD VSS.t1199 VDD VDD sg13_lv_pmos ad=0.19p pd=1.38u as=0 ps=0 w=1u l=1u
X2297 VDD VSS.t1304 VDD VDD sg13_lv_pmos ad=0.34p pd=2.68u as=0 ps=0 w=1u l=1u
X2298 VDD VSS.t2699 VDD VDD sg13_lv_pmos ad=0.19p pd=1.38u as=0 ps=0 w=1u l=1u
X2299 VSS.t2379 VDD VSS.t2378 VSS.t2377 sg13_lv_nmos ad=0.1428p pd=1.52u as=0 ps=0 w=0.42u l=1u
X2300 VSS.t1992 VDD VSS.t1994 VSS.t1993 sg13_lv_nmos ad=79.8f pd=0.8u as=0 ps=0 w=0.42u l=1u
X2301 VSS.t703 sg13cmos5l_or3_1_2.B a_21251_13690# VSS.t3294 sg13_lv_nmos ad=0.1045p pd=0.93u as=0.198p ps=1.27u w=0.55u l=0.13u
X2302 VSS.t1277 VDD VSS.t1278 VSS.t1154 sg13_lv_nmos ad=79.8f pd=0.8u as=0 ps=0 w=0.42u l=1u
X2303 a_2724_15234# sg13cmos5l_and2_1_0.X a_2630_15234# VSS.t221 sg13_lv_nmos ad=60.89999f pd=0.71u as=0.1428p ps=1.52u w=0.42u l=0.13u
X2304 VSS.t501 VDD VSS.t503 VSS.t502 sg13_lv_nmos ad=79.8f pd=0.8u as=0 ps=0 w=0.42u l=1u
X2305 VDD VSS.t580 VDD VDD sg13_lv_pmos ad=0.19p pd=1.38u as=0 ps=0 w=1u l=1u
X2306 VDD VSS.t886 VDD VDD sg13_lv_pmos ad=0.19p pd=1.38u as=0 ps=0 w=1u l=1u
X2307 VDD VSS.t1464 VDD VDD sg13_lv_pmos ad=0.34p pd=2.68u as=0 ps=0 w=1u l=1u
X2308 VDD VSS.t2672 VDD VDD sg13_lv_pmos ad=0.34p pd=2.68u as=0 ps=0 w=1u l=1u
X2309 VSS.t2687 VDD VSS.t2685 VSS.t198 sg13_lv_nmos ad=0.1428p pd=1.52u as=0 ps=0 w=0.42u l=1u
X2310 VDD VSS.t355 VDD VDD sg13_lv_pmos ad=0.19p pd=1.38u as=0 ps=0 w=1u l=1u
X2311 VDD VSS.t1599 VDD VDD sg13_lv_pmos ad=0.34p pd=2.68u as=0 ps=0 w=1u l=1u
X2312 VSS.t2444 VDD VSS.t2446 VSS.t2445 sg13_lv_nmos ad=79.8f pd=0.8u as=0 ps=0 w=0.42u l=1u
X2313 VSS.t1490 VDD VSS.t1489 VSS.t1488 sg13_lv_nmos ad=0.1428p pd=1.52u as=0 ps=0 w=0.42u l=1u
X2314 VSS.t804 VDD VSS.t803 VSS.t802 sg13_lv_nmos ad=0.1428p pd=1.52u as=0 ps=0 w=0.42u l=1u
X2315 VSS.t2399 VDD VSS.t2398 VSS.t2397 sg13_lv_nmos ad=0.1428p pd=1.52u as=0 ps=0 w=0.42u l=1u
X2316 VDD VSS.t2019 VDD VDD sg13_lv_pmos ad=0.19p pd=1.38u as=0 ps=0 w=1u l=1u
X2317 VDD VSS.t145 VDD VDD sg13_lv_pmos ad=0.19p pd=1.38u as=0 ps=0 w=1u l=1u
X2318 VSS.t11 a_9861_15213# a_9963_15356# VSS.t93 sg13_lv_nmos ad=4.11262p pd=27.15u as=0.2516p ps=2.16u w=0.74u l=0.13u
X2319 VSS.t561 VDD VSS.t560 VSS.t559 sg13_lv_nmos ad=0.1428p pd=1.52u as=0 ps=0 w=0.42u l=1u
X2320 VSS.t1034 VDD VSS.t1036 VSS.t1035 sg13_lv_nmos ad=79.8f pd=0.8u as=0 ps=0 w=0.42u l=1u
X2321 VDD VSS.t1517 VDD VDD sg13_lv_pmos ad=0.19p pd=1.38u as=0 ps=0 w=1u l=1u
X2322 VDD VSS.t1971 VDD VDD sg13_lv_pmos ad=0.34p pd=2.68u as=0 ps=0 w=1u l=1u
X2323 VDD VSS.t1182 VDD VDD sg13_lv_pmos ad=0.34p pd=2.68u as=0 ps=0 w=1u l=1u
X2324 VDD VSS.t2740 VDD VDD sg13_lv_pmos ad=0.34p pd=2.68u as=0 ps=0 w=1u l=1u
X2325 a_2059_14832# sg13cmos5l_buf_1_10.X a_1965_14832# VSS.t107 sg13_lv_nmos ad=0.1216p pd=1.02u as=0.2176p ps=1.96u w=0.64u l=0.13u
X2326 VSS.t1465 VDD VSS.t1467 VSS.t1466 sg13_lv_nmos ad=79.8f pd=0.8u as=0 ps=0 w=0.42u l=1u
X2327 VSS.t2680 VDD VSS.t2679 VSS.t198 sg13_lv_nmos ad=0.1428p pd=1.52u as=0 ps=0 w=0.42u l=1u
X2328 VSS.t1155 reset_n_i a_1192_9948# VSS.t1154 sg13_lv_nmos ad=0.14875p pd=1.16u as=0.187p ps=1.78u w=0.55u l=0.13u
X2329 VDD VSS.t1175 VDD VDD sg13_lv_pmos ad=0.34p pd=2.68u as=0 ps=0 w=1u l=1u
X2330 VSS.t2027 VDD VSS.t2029 VSS.t2028 sg13_lv_nmos ad=79.8f pd=0.8u as=0 ps=0 w=0.42u l=1u
X2331 VDD VSS.t1984 VDD VDD sg13_lv_pmos ad=0.19p pd=1.38u as=0 ps=0 w=1u l=1u
X2332 VDD VSS.t853 VDD VDD sg13_lv_pmos ad=0.34p pd=2.68u as=0 ps=0 w=1u l=1u
X2333 VDD VSS.t1041 VDD VDD sg13_lv_pmos ad=0.19p pd=1.38u as=0 ps=0 w=1u l=1u
X2334 VDD VSS.t1211 VDD VDD sg13_lv_pmos ad=0.19p pd=1.38u as=0 ps=0 w=1u l=1u
X2335 VSS.t2735 VDD VSS.t2734 VSS.t198 sg13_lv_nmos ad=0.1428p pd=1.52u as=0 ps=0 w=0.42u l=1u
X2336 VSS.t2239 VDD VSS.t2241 VSS.t2240 sg13_lv_nmos ad=79.8f pd=0.8u as=0 ps=0 w=0.42u l=1u
X2337 VDD VSS.t291 VDD VDD sg13_lv_pmos ad=0.34p pd=2.68u as=0 ps=0 w=1u l=1u
X2338 VDD VSS.t2338 VDD VDD sg13_lv_pmos ad=0.34p pd=2.68u as=0 ps=0 w=1u l=1u
X2339 VDD sg13cmos5l_or3_1_1.B a_16168_15996# VDD sg13_lv_pmos ad=0.2114p pd=1.54u as=0.2856p ps=2.36u w=0.84u l=0.13u
X2340 VDD VSS.t1484 VDD VDD sg13_lv_pmos ad=0.34p pd=2.68u as=0 ps=0 w=1u l=1u
X2341 VDD VSS.t1657 VDD VDD sg13_lv_pmos ad=0.19p pd=1.38u as=0 ps=0 w=1u l=1u
X2342 VDD sg13cmos5l_dfrbpq_1_3.Q sg13cmos5l_or3_1_1.C VDD sg13_lv_pmos ad=0.2128p pd=1.5u as=0.2128p ps=1.5u w=1.12u l=0.13u
X2343 VSS.t1530 VDD VSS.t1529 VSS.t1528 sg13_lv_nmos ad=0.1428p pd=1.52u as=0 ps=0 w=0.42u l=1u
X2344 VSS.t1947 VDD VSS.t1946 VSS.t1945 sg13_lv_nmos ad=0.1428p pd=1.52u as=0 ps=0 w=0.42u l=1u
X2345 VDD VSS.t2648 VDD VDD sg13_lv_pmos ad=0.34p pd=2.68u as=0 ps=0 w=1u l=1u
X2346 VSS.t959 VDD VSS.t958 VSS.t957 sg13_lv_nmos ad=0.1428p pd=1.52u as=0 ps=0 w=0.42u l=1u
X2347 VDD VSS.t916 VDD VDD sg13_lv_pmos ad=0.19p pd=1.38u as=0 ps=0 w=1u l=1u
X2348 VSS.t1004 VDD VSS.t1003 VSS.t1002 sg13_lv_nmos ad=0.1428p pd=1.52u as=0 ps=0 w=0.42u l=1u
X2349 VDD VSS.t2346 VDD VDD sg13_lv_pmos ad=0.19p pd=1.38u as=0 ps=0 w=1u l=1u
X2350 VDD VSS.t2039 VDD VDD sg13_lv_pmos ad=0.19p pd=1.38u as=0 ps=0 w=1u l=1u
X2351 a_7160_15242# sg13cmos5l_xnor2_1_2.A a_7058_15242# VSS.t96 sg13_lv_nmos ad=0.1406p pd=1.12u as=0.1406p ps=1.12u w=0.74u l=0.13u
X2352 VSS.t1285 VDD VSS.t1286 VSS.t1154 sg13_lv_nmos ad=79.8f pd=0.8u as=0 ps=0 w=0.42u l=1u
X2353 VSS.t1685 VDD VSS.t1684 VSS.t1683 sg13_lv_nmos ad=0.1428p pd=1.52u as=0 ps=0 w=0.42u l=1u
X2354 VSS.t42 a_25774_15423# sg13cmos5l_dfrbpq_1_7.D VSS.t64 sg13_lv_nmos ad=0.1426p pd=1.16u as=0.2516p ps=2.16u w=0.74u l=0.13u
X2355 VSS.t2719 VDD VSS.t2720 VSS.t198 sg13_lv_nmos ad=79.8f pd=0.8u as=0 ps=0 w=0.42u l=1u
X2356 VDD VSS.t2654 VDD VDD sg13_lv_pmos ad=0.19p pd=1.38u as=0 ps=0 w=1u l=1u
X2357 VSS.t2977 VDD VSS.t2976 VSS.t2975 sg13_lv_nmos ad=0.1428p pd=1.52u as=0 ps=0 w=0.42u l=1u
X2358 VDD VSS.t434 VDD VDD sg13_lv_pmos ad=0.34p pd=2.68u as=0 ps=0 w=1u l=1u
X2359 VSS.t2364 VDD VSS.t2366 VSS.t2365 sg13_lv_nmos ad=79.8f pd=0.8u as=0 ps=0 w=0.42u l=1u
X2360 VSS.t411 VDD VSS.t410 VSS.t11 sg13_lv_nmos ad=0.1428p pd=1.52u as=0 ps=0 w=0.42u l=1u
X2361 VSS.t1450 VDD VSS.t1452 VSS.t1451 sg13_lv_nmos ad=79.8f pd=0.8u as=0 ps=0 w=0.42u l=1u
X2362 a_21166_16263# a_21281_16262# VSS.t236 VSS.t3279 sg13_lv_nmos ad=0.1428p pd=1.52u as=0.1426p ps=1.16u w=0.42u l=0.5u
X2363 VSS.t1019 VDD VSS.t1021 VSS.t1020 sg13_lv_nmos ad=79.8f pd=0.8u as=0 ps=0 w=0.42u l=1u
X2364 VDD VSS.t1267 VDD VDD sg13_lv_pmos ad=0.34p pd=2.68u as=0 ps=0 w=1u l=1u
X2365 VSS.t1205 VDD VSS.t1206 VSS.t1154 sg13_lv_nmos ad=79.8f pd=0.8u as=0 ps=0 w=0.42u l=1u
X2366 VDD VSS.t209 VDD VDD sg13_lv_pmos ad=0.19p pd=1.38u as=0 ps=0 w=1u l=1u
X2367 VDD VSS.t816 VDD VDD sg13_lv_pmos ad=0.19p pd=1.38u as=0 ps=0 w=1u l=1u
X2368 VDD VSS.t1462 VDD VDD sg13_lv_pmos ad=0.19p pd=1.38u as=0 ps=0 w=1u l=1u
X2369 VDD VSS.t2371 VDD VDD sg13_lv_pmos ad=0.19p pd=1.38u as=0 ps=0 w=1u l=1u
X2370 VSS.t89 a_22426_15202# a_22145_15424# VSS.t64 sg13_lv_nmos ad=79.8f pd=0.8u as=0.1428p ps=1.52u w=0.42u l=0.5u
X2371 VDD VSS.t608 VDD VDD sg13_lv_pmos ad=0.19p pd=1.38u as=0 ps=0 w=1u l=1u
X2372 VSS.t2259 VDD VSS.t2261 VSS.t2260 sg13_lv_nmos ad=79.8f pd=0.8u as=0 ps=0 w=0.42u l=1u
X2373 VSS.t1304 VDD VSS.t1304 VSS.t1154 sg13_lv_nmos ad=79.8f pd=0.8u as=0 ps=0 w=0.42u l=1u
X2374 VDD VSS.t1295 VDD VDD sg13_lv_pmos ad=0.34p pd=2.68u as=0 ps=0 w=1u l=1u
X2375 sg13cmos5l_or3_1_1.B a_14261_15238# VDD VDD sg13_lv_pmos ad=0.2128p pd=1.5u as=0.2128p ps=1.5u w=1.12u l=0.13u
X2376 a_17806_15423# a_17921_15424# VSS.t13 VSS.t259 sg13_lv_nmos ad=0.1428p pd=1.52u as=0.1426p ps=1.16u w=0.42u l=0.5u
X2377 VDD VSS.t583 VDD VDD sg13_lv_pmos ad=0.19p pd=1.38u as=0 ps=0 w=1u l=1u
X2378 VDD VSS.t931 VDD VDD sg13_lv_pmos ad=0.19p pd=1.38u as=0 ps=0 w=1u l=1u
X2379 VSS.t2717 VDD VSS.t2718 VSS.t198 sg13_lv_nmos ad=79.8f pd=0.8u as=0 ps=0 w=0.42u l=1u
X2380 VDD VSS.t2496 VDD VDD sg13_lv_pmos ad=0.19p pd=1.38u as=0 ps=0 w=1u l=1u
X2381 VSS.t1977 VDD VSS.t1979 VSS.t1978 sg13_lv_nmos ad=79.8f pd=0.8u as=0 ps=0 w=0.42u l=1u
X2382 VSS.t89 a_22576_14726# a_22225_14845# VSS.t4 sg13_lv_nmos ad=79.8f pd=0.8u as=0.1428p ps=1.52u w=0.42u l=0.13u
X2383 VDD VSS.t2664 VDD VDD sg13_lv_pmos ad=0.34p pd=2.68u as=0 ps=0 w=1u l=1u
X2384 VSS.t1480 VDD VSS.t1479 VSS.t1478 sg13_lv_nmos ad=0.1428p pd=1.52u as=0 ps=0 w=0.42u l=1u
X2385 a_27472_14726# sg13cmos5l_dfrbpq_1_7.RESET_B VDD VDD sg13_lv_pmos ad=79.8f pd=0.8u as=2.42015p ps=15.68u w=0.42u l=0.13u
X2386 a_8218_13690# sg13cmos5l_dlygate4sd3_1_1.A VDD VDD sg13_lv_pmos ad=0.1428p pd=1.52u as=0.1523p ps=1.38u w=0.42u l=0.13u
X2387 VSS.t138 sg13cmos5l_buf_8_2.A a_19323_13726# VSS.t137 sg13_lv_nmos ad=0.1406p pd=1.12u as=0.1406p ps=1.12u w=0.74u l=0.13u
X2388 a_26148_14040# a_26122_13945# VSS.t145 VSS.t238 sg13_lv_nmos ad=0.2516p pd=2.16u as=0.1626p ps=1.415u w=0.74u l=0.13u
X2389 VDD VSS.t1218 VDD VDD sg13_lv_pmos ad=0.34p pd=2.68u as=0 ps=0 w=1u l=1u
X2390 VDD VSS.t2718 VDD VDD sg13_lv_pmos ad=0.34p pd=2.68u as=0 ps=0 w=1u l=1u
X2391 VDD VSS.t1996 VDD VDD sg13_lv_pmos ad=0.34p pd=2.68u as=0 ps=0 w=1u l=1u
X2392 VSS.t1034 VDD VSS.t1036 VSS.t1035 sg13_lv_nmos ad=79.8f pd=0.8u as=0 ps=0 w=0.42u l=1u
X2393 VDD VSS.t1276 VDD VDD sg13_lv_pmos ad=0.34p pd=2.68u as=0 ps=0 w=1u l=1u
X2394 a_17746_13722# sg13cmos5l_dfrbpq_1_2.RESET_B VSS.t87 VSS.t250 sg13_lv_nmos ad=37.8f pd=0.6u as=79.8f ps=0.8u w=0.42u l=0.13u
X2395 VSS.t1475 VDD VSS.t1474 VSS.t1473 sg13_lv_nmos ad=0.1428p pd=1.52u as=0 ps=0 w=0.42u l=1u
X2396 VSS.t2384 VDD VSS.t2383 VSS.t2382 sg13_lv_nmos ad=0.1428p pd=1.52u as=0 ps=0 w=0.42u l=1u
X2397 VDD VSS.t1679 VDD VDD sg13_lv_pmos ad=0.34p pd=2.68u as=0 ps=0 w=1u l=1u
X2398 VSS.t2709 VDD VSS.t2711 VSS.t198 sg13_lv_nmos ad=79.8f pd=0.8u as=0 ps=0 w=0.42u l=1u
X2399 VDD VSS.t1956 VDD VDD sg13_lv_pmos ad=0.34p pd=2.68u as=0 ps=0 w=1u l=1u
X2400 VDD VSS.t404 VDD VDD sg13_lv_pmos ad=0.34p pd=2.68u as=0 ps=0 w=1u l=1u
X2401 VSS.t536 VDD VSS.t538 VSS.t537 sg13_lv_nmos ad=79.8f pd=0.8u as=0 ps=0 w=0.42u l=1u
X2402 VSS.t894 VDD VSS.t893 VSS.t892 sg13_lv_nmos ad=0.1428p pd=1.52u as=0 ps=0 w=0.42u l=1u
X2403 VDD VSS.t2901 VDD VDD sg13_lv_pmos ad=0.34p pd=2.68u as=0 ps=0 w=1u l=1u
X2404 VSS.t2299 VDD VSS.t2301 VSS.t2300 sg13_lv_nmos ad=79.8f pd=0.8u as=0 ps=0 w=0.42u l=1u
X2405 a_2916_15552# a_2890_15457# VDD VDD sg13_lv_pmos ad=0.34p pd=2.68u as=0.36237p ps=2.605u w=1u l=0.13u
X2406 VDD VSS.t3074 VDD VDD sg13_lv_pmos ad=0.19p pd=1.38u as=0 ps=0 w=1u l=1u
X2407 VDD VSS.t2291 VDD VDD sg13_lv_pmos ad=0.19p pd=1.38u as=0 ps=0 w=1u l=1u
X2408 VDD a_9861_15213# a_9963_15356# VDD sg13_lv_pmos ad=2.8961p pd=18.25u as=0.3864p ps=2.93u w=1.12u l=0.13u
X2409 VDD VSS.t387 VDD VDD sg13_lv_pmos ad=0.19p pd=1.38u as=0 ps=0 w=1u l=1u
X2410 a_4078_14751# a_4193_14750# VDD VDD sg13_lv_pmos ad=0.34p pd=2.68u as=0.2254p ps=1.53u w=1u l=0.5u
X2411 a_22521_14607# a_21579_14495# a_22319_14845# VDD sg13_lv_pmos ad=93.45f pd=0.865u as=0.2048p ps=1.63u w=0.42u l=0.13u
X2412 VSS.t2727 VDD VSS.t2727 VSS.t198 sg13_lv_nmos ad=0.1428p pd=1.52u as=0 ps=0 w=0.42u l=1u
X2413 VDD VSS.t2678 VDD VDD sg13_lv_pmos ad=0.34p pd=2.68u as=0 ps=0 w=1u l=1u
X2414 VDD VSS.t898 VDD VDD sg13_lv_pmos ad=0.34p pd=2.68u as=0 ps=0 w=1u l=1u
X2415 VDD VSS.t2323 VDD VDD sg13_lv_pmos ad=0.34p pd=2.68u as=0 ps=0 w=1u l=1u
X2416 VSS.t769 VDD VSS.t768 VSS.t767 sg13_lv_nmos ad=0.1428p pd=1.52u as=0 ps=0 w=0.42u l=1u
X2417 VDD VSS.t1469 VDD VDD sg13_lv_pmos ad=0.34p pd=2.68u as=0 ps=0 w=1u l=1u
X2418 a_14261_15238# sg13cmos5l_nand4_1_0.Y VDD VDD sg13_lv_pmos ad=0.1596p pd=1.22u as=0.2856p ps=2.36u w=0.84u l=0.13u
X2419 VSS.t2107 VDD VSS.t2109 VSS.t2108 sg13_lv_nmos ad=79.8f pd=0.8u as=0 ps=0 w=0.42u l=1u
X2420 VDD VSS.t632 VDD VDD sg13_lv_pmos ad=0.19p pd=1.38u as=0 ps=0 w=1u l=1u
X2421 VDD VSS.t821 VDD VDD sg13_lv_pmos ad=0.19p pd=1.38u as=0 ps=0 w=1u l=1u
X2422 VSS.t626 VDD VSS.t626 VSS.t754 sg13_lv_nmos ad=0.1428p pd=1.52u as=0 ps=0 w=0.42u l=1u
X2423 VSS.t2671 VDD VSS.t2670 VSS.t198 sg13_lv_nmos ad=0.1428p pd=1.52u as=0 ps=0 w=0.42u l=1u
X2424 VDD VSS.t355 VDD VDD sg13_lv_pmos ad=0.34p pd=2.68u as=0 ps=0 w=1u l=1u
X2425 VSS.t1004 VDD VSS.t1003 VSS.t1002 sg13_lv_nmos ad=0.1428p pd=1.52u as=0 ps=0 w=0.42u l=1u
X2426 VDD VSS.t1659 VDD VDD sg13_lv_pmos ad=0.34p pd=2.68u as=0 ps=0 w=1u l=1u
X2427 VDD VSS.t773 VDD VDD sg13_lv_pmos ad=0.34p pd=2.68u as=0 ps=0 w=1u l=1u
X2428 VDD VSS.t443 VDD VDD sg13_lv_pmos ad=0.34p pd=2.68u as=0 ps=0 w=1u l=1u
X2429 VDD VSS.t1522 VDD VDD sg13_lv_pmos ad=0.19p pd=1.38u as=0 ps=0 w=1u l=1u
X2430 a_18021_14495# sg13cmos5l_buf_8_2.X VSS.t11 VSS.t76 sg13_lv_nmos ad=0.2516p pd=2.16u as=3.8707p ps=25.555u w=0.74u l=0.13u
X2431 VSS.t1165 VDD VSS.t1166 VSS.t1154 sg13_lv_nmos ad=79.8f pd=0.8u as=0 ps=0 w=0.42u l=1u
X2432 VSS.t1200 VDD VSS.t1200 VSS.t1154 sg13_lv_nmos ad=0.1428p pd=1.52u as=0 ps=0 w=0.42u l=1u
X2433 VDD VSS.t1185 VDD VDD sg13_lv_pmos ad=0.34p pd=2.68u as=0 ps=0 w=1u l=1u
X2434 VSS.t2962 VDD VSS.t2961 VSS.t2960 sg13_lv_nmos ad=0.1428p pd=1.52u as=0 ps=0 w=0.42u l=1u
X2435 VDD VSS.t2743 VDD VDD sg13_lv_pmos ad=0.34p pd=2.68u as=0 ps=0 w=1u l=1u
X2436 VDD VSS.t1294 VDD VDD sg13_lv_pmos ad=0.34p pd=2.68u as=0 ps=0 w=1u l=1u
X2437 VSS.t809 VDD VSS.t808 VSS.t807 sg13_lv_nmos ad=0.1428p pd=1.52u as=0 ps=0 w=0.42u l=1u
X2438 VSS.t150 a_12524_15960# counter_value_o[2] VSS.t152 sg13_lv_nmos ad=0.14875p pd=1.16u as=0.2886p ps=2.26u w=0.74u l=0.13u
X2439 a_17165_16020# sg13cmos5l_inv_1_0.Y a_17063_16020# VDD sg13_lv_pmos ad=0.1575p pd=1.315u as=0.19p ps=1.38u w=1u l=0.13u
X2440 VSS.t1169 VDD VSS.t1171 VSS.t1154 sg13_lv_nmos ad=79.8f pd=0.8u as=0 ps=0 w=0.42u l=1u
X2441 VDD VSS.t2693 VDD VDD sg13_lv_pmos ad=0.19p pd=1.38u as=0 ps=0 w=1u l=1u
X2442 VSS.t2244 VDD VSS.t2246 VSS.t2245 sg13_lv_nmos ad=79.8f pd=0.8u as=0 ps=0 w=0.42u l=1u
X2443 VDD clock_i a_15579_14854# VDD sg13_lv_pmos ad=0.2128p pd=1.5u as=0.3808p ps=2.92u w=1.12u l=0.13u
X2444 VSS.t924 VDD VSS.t923 VSS.t922 sg13_lv_nmos ad=0.1428p pd=1.52u as=0 ps=0 w=0.42u l=1u
X2445 VSS.t2369 VDD VSS.t2368 VSS.t2367 sg13_lv_nmos ad=0.1428p pd=1.52u as=0 ps=0 w=0.42u l=1u
X2446 VSS.t573 VDD VSS.t573 VSS.t692 sg13_lv_nmos ad=79.8f pd=0.8u as=0 ps=0 w=0.42u l=1u
X2447 VDD VSS.t788 VDD VDD sg13_lv_pmos ad=0.34p pd=2.68u as=0 ps=0 w=1u l=1u
X2448 VDD VSS.t1454 VDD VDD sg13_lv_pmos ad=0.34p pd=2.68u as=0 ps=0 w=1u l=1u
X2449 VSS.t2708 VDD VSS.t2709 VSS.t198 sg13_lv_nmos ad=79.8f pd=0.8u as=0 ps=0 w=0.42u l=1u
X2450 VDD VSS.t611 VDD VDD sg13_lv_pmos ad=0.34p pd=2.68u as=0 ps=0 w=1u l=1u
X2451 VDD VSS.t976 VDD VDD sg13_lv_pmos ad=0.19p pd=1.38u as=0 ps=0 w=1u l=1u
X2452 VSS.t1220 VDD VSS.t1219 VSS.t1154 sg13_lv_nmos ad=0.1428p pd=1.52u as=0 ps=0 w=0.42u l=1u
X2453 VSS.t2092 VDD VSS.t2094 VSS.t2093 sg13_lv_nmos ad=79.8f pd=0.8u as=0 ps=0 w=0.42u l=1u
X2454 VDD VSS.t274 VDD VDD sg13_lv_pmos ad=0.19p pd=1.38u as=0 ps=0 w=1u l=1u
X2455 VSS.t291 VDD VSS.t291 VSS.t295 sg13_lv_nmos ad=0.1428p pd=1.52u as=0 ps=0 w=0.42u l=1u
X2456 sg13cmos5l_and2_1_0.X a_1965_14832# VDD VDD sg13_lv_pmos ad=0.3808p pd=2.92u as=0.1918p ps=1.5u w=1.12u l=0.13u
X2457 VSS.t556 VDD VSS.t558 VSS.t557 sg13_lv_nmos ad=79.8f pd=0.8u as=0 ps=0 w=0.42u l=1u
X2458 VSS.t1535 VDD VSS.t1534 VSS.t1533 sg13_lv_nmos ad=0.1428p pd=1.52u as=0 ps=0 w=0.42u l=1u
X2459 VDD VSS.t67 VDD VDD sg13_lv_pmos ad=0.34p pd=2.68u as=0 ps=0 w=1u l=1u
X2460 VSS.t2681 VDD VSS.t2680 VSS.t198 sg13_lv_nmos ad=0.1428p pd=1.52u as=0 ps=0 w=0.42u l=1u
X2461 VDD VSS.t2650 VDD VDD sg13_lv_pmos ad=0.34p pd=2.68u as=0 ps=0 w=1u l=1u
X2462 VSS.t531 VDD VSS.t530 VSS.t529 sg13_lv_nmos ad=0.1428p pd=1.52u as=0 ps=0 w=0.42u l=1u
X2463 VDD sg13cmos5l_dfrbpq_1_3.RESET_B a_17318_14922# VDD sg13_lv_pmos ad=0.36237p pd=2.605u as=79.8f ps=0.8u w=0.42u l=0.13u
X2464 VDD VSS.t1361 VDD VDD sg13_lv_pmos ad=0.34p pd=2.68u as=0 ps=0 w=1u l=1u
X2465 VDD VSS.t2841 VDD VDD sg13_lv_pmos ad=0.34p pd=2.68u as=0 ps=0 w=1u l=1u
X2466 VDD VSS.t1981 VDD VDD sg13_lv_pmos ad=0.34p pd=2.68u as=0 ps=0 w=1u l=1u
X2467 VDD VSS.t2351 VDD VDD sg13_lv_pmos ad=0.19p pd=1.38u as=0 ps=0 w=1u l=1u
X2468 VDD VSS.t2009 VDD VDD sg13_lv_pmos ad=0.19p pd=1.38u as=0 ps=0 w=1u l=1u
X2469 VSS.t501 VDD VSS.t503 VSS.t502 sg13_lv_nmos ad=79.8f pd=0.8u as=0 ps=0 w=0.42u l=1u
X2470 VSS.t824 VDD VSS.t823 VSS.t822 sg13_lv_nmos ad=0.1428p pd=1.52u as=0 ps=0 w=0.42u l=1u
X2471 VSS.t894 VDD VSS.t893 VSS.t892 sg13_lv_nmos ad=0.1428p pd=1.52u as=0 ps=0 w=0.42u l=1u
X2472 VSS.t1256 VDD VSS.t1257 VSS.t1154 sg13_lv_nmos ad=79.8f pd=0.8u as=0 ps=0 w=0.42u l=1u
X2473 VSS.t1177 VDD VSS.t1179 VSS.t1154 sg13_lv_nmos ad=79.8f pd=0.8u as=0 ps=0 w=0.42u l=1u
X2474 VDD VSS.t431 VDD VDD sg13_lv_pmos ad=0.34p pd=2.68u as=0 ps=0 w=1u l=1u
X2475 VDD VSS.t851 VDD VDD sg13_lv_pmos ad=0.19p pd=1.38u as=0 ps=0 w=1u l=1u
X2476 VDD VSS.t1664 VDD VDD sg13_lv_pmos ad=0.34p pd=2.68u as=0 ps=0 w=1u l=1u
X2477 VSS.t2982 VDD VSS.t2981 VSS.t2980 sg13_lv_nmos ad=0.1428p pd=1.52u as=0 ps=0 w=0.42u l=1u
X2478 VSS.t2701 VDD VSS.t2702 VSS.t198 sg13_lv_nmos ad=79.8f pd=0.8u as=0 ps=0 w=0.42u l=1u
X2479 VDD VSS.t2886 VDD VDD sg13_lv_pmos ad=0.34p pd=2.68u as=0 ps=0 w=1u l=1u
X2480 a_6180_14922# sg13cmos5l_and2_1_1.X a_6086_14922# VSS.t127 sg13_lv_nmos ad=60.89999f pd=0.71u as=0.1428p ps=1.52u w=0.42u l=0.13u
X2481 VDD VSS.t1016 VDD VDD sg13_lv_pmos ad=0.19p pd=1.38u as=0 ps=0 w=1u l=1u
X2482 VSS.t2464 VDD VSS.t2463 VSS.t2462 sg13_lv_nmos ad=0.1428p pd=1.52u as=0 ps=0 w=0.42u l=1u
X2483 VSS.t2754 VDD VSS.t2755 VSS.t198 sg13_lv_nmos ad=79.8f pd=0.8u as=0 ps=0 w=0.42u l=1u
X2484 sg13cmos5l_buf_8_2.X a_19323_13726# VSS.t138 VSS.t3253 sg13_lv_nmos ad=0.1406p pd=1.12u as=0.1406p ps=1.12u w=0.74u l=0.13u
X2485 VDD VSS.t1467 VDD VDD sg13_lv_pmos ad=0.19p pd=1.38u as=0 ps=0 w=1u l=1u
X2486 VDD VSS.t2376 VDD VDD sg13_lv_pmos ad=0.19p pd=1.38u as=0 ps=0 w=1u l=1u
X2487 sg13cmos5l_or3_1_2.B a_16168_15996# VSS.t7 VSS.t6 sg13_lv_nmos ad=0.2886p pd=2.26u as=0.14875p ps=1.16u w=0.74u l=0.13u
X2488 VSS.t580 VDD VSS.t583 VSS.t582 sg13_lv_nmos ad=79.8f pd=0.8u as=0 ps=0 w=0.42u l=1u
X2489 VSS.t561 VDD VSS.t560 VSS.t559 sg13_lv_nmos ad=0.1428p pd=1.52u as=0 ps=0 w=0.42u l=1u
X2490 VSS.t769 VDD VSS.t768 VSS.t767 sg13_lv_nmos ad=0.1428p pd=1.52u as=0 ps=0 w=0.42u l=1u
X2491 VDD VSS.t943 VDD VDD sg13_lv_pmos ad=0.34p pd=2.68u as=0 ps=0 w=1u l=1u
X2492 VSS.t323 VDD VSS.t325 VSS.t324 sg13_lv_nmos ad=79.8f pd=0.8u as=0 ps=0 w=0.42u l=1u
X2493 VDD a_6789_14495# a_6891_14495# VDD sg13_lv_pmos ad=2.42015p pd=15.68u as=0.3864p ps=2.93u w=1.12u l=0.13u
X2494 VSS.t1234 VDD VSS.t1233 VSS.t1154 sg13_lv_nmos ad=0.1428p pd=1.52u as=0 ps=0 w=0.42u l=1u
X2495 VSS.t1982 VDD VSS.t1984 VSS.t1983 sg13_lv_nmos ad=79.8f pd=0.8u as=0 ps=0 w=0.42u l=1u
X2496 VSS.t2699 VDD VSS.t2700 VSS.t198 sg13_lv_nmos ad=79.8f pd=0.8u as=0 ps=0 w=0.42u l=1u
X2497 VSS.t1485 VDD VSS.t1484 VSS.t1483 sg13_lv_nmos ad=0.1428p pd=1.52u as=0 ps=0 w=0.42u l=1u
X2498 VDD a_21166_16263# sg13cmos5l_dfrbpq_1_6.D VDD sg13_lv_pmos ad=0.2254p pd=1.53u as=0.4256p ps=3u w=1.12u l=0.13u
X2499 VSS.t1655 VDD VSS.t1657 VSS.t1656 sg13_lv_nmos ad=79.8f pd=0.8u as=0 ps=0 w=0.42u l=1u
X2500 VDD VSS.t433 VDD VDD sg13_lv_pmos ad=0.19p pd=1.38u as=0 ps=0 w=1u l=1u
X2501 VSS.t2047 VDD VSS.t2046 VSS.t2045 sg13_lv_nmos ad=0.1428p pd=1.52u as=0 ps=0 w=0.42u l=1u
X2502 VSS.t503 VDD VSS.t503 VSS.t505 sg13_lv_nmos ad=79.8f pd=0.8u as=0 ps=0 w=0.42u l=1u
X2503 VDD VSS.t2700 VDD VDD sg13_lv_pmos ad=0.34p pd=2.68u as=0 ps=0 w=1u l=1u
X2504 VDD VSS.t2001 VDD VDD sg13_lv_pmos ad=0.34p pd=2.68u as=0 ps=0 w=1u l=1u
X2505 VDD VSS.t7 VDD VDD sg13_lv_pmos ad=0.19p pd=1.38u as=0 ps=0 w=1u l=1u
X2506 VSS.t580 VDD VSS.t580 VSS.t707 sg13_lv_nmos ad=79.8f pd=0.8u as=0 ps=0 w=0.42u l=1u
X2507 VSS.t1238 VDD VSS.t1237 VSS.t1154 sg13_lv_nmos ad=0.1428p pd=1.52u as=0 ps=0 w=0.42u l=1u
X2508 VDD VSS.t1006 VDD VDD sg13_lv_pmos ad=0.19p pd=1.38u as=0 ps=0 w=1u l=1u
X2509 VSS.t1161 VDD VSS.t1160 VSS.t1154 sg13_lv_nmos ad=0.1428p pd=1.52u as=0 ps=0 w=0.42u l=1u
X2510 VSS.t1269 VDD VSS.t1271 VSS.t1154 sg13_lv_nmos ad=79.8f pd=0.8u as=0 ps=0 w=0.42u l=1u
X2511 VSS.t2229 VDD VSS.t2231 VSS.t2230 sg13_lv_nmos ad=79.8f pd=0.8u as=0 ps=0 w=0.42u l=1u
X2512 VSS.t429 VDD VSS.t428 VSS.t11 sg13_lv_nmos ad=0.1428p pd=1.52u as=0 ps=0 w=0.42u l=1u
X2513 a_27898_15202# sg13cmos5l_dfrbpq_1_5.Q VDD VDD sg13_lv_pmos ad=0.1428p pd=1.52u as=0.1523p ps=1.38u w=0.42u l=0.13u
X2514 VDD VSS.t1684 VDD VDD sg13_lv_pmos ad=0.34p pd=2.68u as=0 ps=0 w=1u l=1u
X2515 VDD VSS.t1961 VDD VDD sg13_lv_pmos ad=0.34p pd=2.68u as=0 ps=0 w=1u l=1u
X2516 VDD VSS.t1177 VDD VDD sg13_lv_pmos ad=0.34p pd=2.68u as=0 ps=0 w=1u l=1u
X2517 VSS.t2304 VDD VSS.t2306 VSS.t2305 sg13_lv_nmos ad=79.8f pd=0.8u as=0 ps=0 w=0.42u l=1u
X2518 VSS.t809 VDD VSS.t808 VSS.t807 sg13_lv_nmos ad=0.1428p pd=1.52u as=0 ps=0 w=0.42u l=1u
X2519 VDD VSS.t3079 VDD VDD sg13_lv_pmos ad=0.19p pd=1.38u as=0 ps=0 w=1u l=1u
X2520 VDD VSS.t721 VDD VDD sg13_lv_pmos ad=0.19p pd=1.38u as=0 ps=0 w=1u l=1u
X2521 VSS.t1039 VDD VSS.t1041 VSS.t1040 sg13_lv_nmos ad=79.8f pd=0.8u as=0 ps=0 w=0.42u l=1u
X2522 VSS.t924 VDD VSS.t923 VSS.t922 sg13_lv_nmos ad=0.1428p pd=1.52u as=0 ps=0 w=0.42u l=1u
X2523 VSS.t83 sg13cmos5l_dfrbpq_1_2.Q a_16552_15996# VSS.t3223 sg13_lv_nmos ad=0.14875p pd=1.16u as=0.187p ps=1.78u w=0.55u l=0.13u
X2524 VSS.t227 VDD VSS.t227 VSS.t360 sg13_lv_nmos ad=79.8f pd=0.8u as=0 ps=0 w=0.42u l=1u
X2525 VSS.t508 VDD VSS.t72 VSS.t512 sg13_lv_nmos ad=79.8f pd=0.8u as=0 ps=0 w=0.42u l=1u
X2526 VSS.t2730 VDD VSS.t2729 VSS.t198 sg13_lv_nmos ad=0.1428p pd=1.52u as=0 ps=0 w=0.42u l=1u
X2527 a_21348_14909# a_21579_14495# a_21034_14452# VSS.t174 sg13_lv_nmos ad=0.2373p pd=1.97u as=79.8f ps=0.8u w=0.42u l=0.13u
X2528 VDD VSS.t2663 VDD VDD sg13_lv_pmos ad=0.34p pd=2.68u as=0 ps=0 w=1u l=1u
X2529 VSS.t269 VDD VSS.t269 VSS.t272 sg13_lv_nmos ad=79.8f pd=0.8u as=0 ps=0 w=0.42u l=1u
X2530 VDD VSS.t1021 VDD VDD sg13_lv_pmos ad=0.19p pd=1.38u as=0 ps=0 w=1u l=1u
X2531 VDD a_27898_15202# a_27617_15424# VDD sg13_lv_pmos ad=0.1523p pd=1.38u as=0.34p ps=2.68u w=1u l=0.5u
X2532 VDD VSS.t413 VDD VDD sg13_lv_pmos ad=0.34p pd=2.68u as=0 ps=0 w=1u l=1u
X2533 VSS.t2077 VDD VSS.t2079 VSS.t2078 sg13_lv_nmos ad=79.8f pd=0.8u as=0 ps=0 w=0.42u l=1u
X2534 VDD VSS.t1241 VDD VDD sg13_lv_pmos ad=0.19p pd=1.38u as=0 ps=0 w=1u l=1u
X2535 VSS.t1520 VDD VSS.t1519 VSS.t1518 sg13_lv_nmos ad=0.1428p pd=1.52u as=0 ps=0 w=0.42u l=1u
X2536 VDD VSS.t2738 VDD VDD sg13_lv_pmos ad=0.19p pd=1.38u as=0 ps=0 w=1u l=1u
X2537 VSS.t2449 VDD VSS.t2448 VSS.t2447 sg13_lv_nmos ad=0.1428p pd=1.52u as=0 ps=0 w=0.42u l=1u
X2538 VDD VSS.t1479 VDD VDD sg13_lv_pmos ad=0.34p pd=2.68u as=0 ps=0 w=1u l=1u
X2539 VSS.t2673 VDD VSS.t2673 VSS.t198 sg13_lv_nmos ad=0.1428p pd=1.52u as=0 ps=0 w=0.42u l=1u
X2540 VDD VSS.t2643 VDD VDD sg13_lv_pmos ad=0.34p pd=2.68u as=0 ps=0 w=1u l=1u
X2541 VDD VSS.t2388 VDD VDD sg13_lv_pmos ad=0.34p pd=2.68u as=0 ps=0 w=1u l=1u
X2542 VSS.t824 VDD VSS.t823 VSS.t822 sg13_lv_nmos ad=0.1428p pd=1.52u as=0 ps=0 w=0.42u l=1u
X2543 VSS.t1252 VDD VSS.t1251 VSS.t1154 sg13_lv_nmos ad=0.1428p pd=1.52u as=0 ps=0 w=0.42u l=1u
X2544 VDD VSS.t593 VDD VDD sg13_lv_pmos ad=0.19p pd=1.38u as=0 ps=0 w=1u l=1u
X2545 VDD VSS.t781 VDD VDD sg13_lv_pmos ad=0.19p pd=1.38u as=0 ps=0 w=1u l=1u
X2546 VSS.t728 VDD VSS.t147 VSS.t727 sg13_lv_nmos ad=0.1428p pd=1.52u as=0 ps=0 w=0.42u l=1u
X2547 VDD VSS.t2336 VDD VDD sg13_lv_pmos ad=0.19p pd=1.38u as=0 ps=0 w=1u l=1u
X2548 VDD VSS.t1994 VDD VDD sg13_lv_pmos ad=0.19p pd=1.38u as=0 ps=0 w=1u l=1u
X2549 VSS.t1997 VDD VSS.t1996 VSS.t1995 sg13_lv_nmos ad=0.1428p pd=1.52u as=0 ps=0 w=0.42u l=1u
X2550 VSS.t1283 VDD VSS.t1284 VSS.t1154 sg13_lv_nmos ad=79.8f pd=0.8u as=0 ps=0 w=0.42u l=1u
X2551 a_26148_14040# a_26122_13945# VDD VDD sg13_lv_pmos ad=0.34p pd=2.68u as=0.36237p ps=2.605u w=1u l=0.13u
X2552 VDD VSS.t1188 VDD VDD sg13_lv_pmos ad=0.34p pd=2.68u as=0 ps=0 w=1u l=1u
X2553 VSS.t2967 VDD VSS.t2966 VSS.t2965 sg13_lv_nmos ad=0.1428p pd=1.52u as=0 ps=0 w=0.42u l=1u
X2554 VSS.t132 VDD VSS.t132 VSS.t463 sg13_lv_nmos ad=79.8f pd=0.8u as=0 ps=0 w=0.42u l=1u
X2555 VSS.t1009 VDD VSS.t1008 VSS.t1007 sg13_lv_nmos ad=0.1428p pd=1.52u as=0 ps=0 w=0.42u l=1u
X2556 VDD VSS.t1186 VDD VDD sg13_lv_pmos ad=0.34p pd=2.68u as=0 ps=0 w=1u l=1u
X2557 VDD VSS.t422 VDD VDD sg13_lv_pmos ad=0.34p pd=2.68u as=0 ps=0 w=1u l=1u
X2558 VSS.t1288 VDD VSS.t1289 VSS.t1154 sg13_lv_nmos ad=79.8f pd=0.8u as=0 ps=0 w=0.42u l=1u
X2559 VSS.t623 VDD VSS.t626 VSS.t753 sg13_lv_nmos ad=79.8f pd=0.8u as=0 ps=0 w=0.42u l=1u
X2560 VDD VSS.t873 VDD VDD sg13_lv_pmos ad=0.34p pd=2.68u as=0 ps=0 w=1u l=1u
X2561 VDD VSS.t1452 VDD VDD sg13_lv_pmos ad=0.19p pd=1.38u as=0 ps=0 w=1u l=1u
X2562 VSS.t2745 VDD VSS.t2746 VSS.t198 sg13_lv_nmos ad=79.8f pd=0.8u as=0 ps=0 w=0.42u l=1u
X2563 VSS.t2249 VDD VSS.t2251 VSS.t2250 sg13_lv_nmos ad=79.8f pd=0.8u as=0 ps=0 w=0.42u l=1u
X2564 VSS.t2721 VDD VSS.t2721 VSS.t198 sg13_lv_nmos ad=0.1428p pd=1.52u as=0 ps=0 w=0.42u l=1u
X2565 VDD VSS.t1459 VDD VDD sg13_lv_pmos ad=0.34p pd=2.68u as=0 ps=0 w=1u l=1u
X2566 VDD VSS.t1632 VDD VDD sg13_lv_pmos ad=0.19p pd=1.38u as=0 ps=0 w=1u l=1u
X2567 VSS.t1470 VDD VSS.t1469 VSS.t1468 sg13_lv_nmos ad=0.1428p pd=1.52u as=0 ps=0 w=0.42u l=1u
X2568 VSS.t1540 VDD VSS.t1539 VSS.t1538 sg13_lv_nmos ad=0.1428p pd=1.52u as=0 ps=0 w=0.42u l=1u
X2569 sg13cmos5l_or3_1_1.C sg13cmos5l_o21ai_1_2.B1 a_24062_15242# VSS.t64 sg13_lv_nmos ad=0.2516p pd=2.16u as=0.1406p ps=1.12u w=0.74u l=0.13u
X2570 VDD VSS.t2636 VDD VDD sg13_lv_pmos ad=0.34p pd=2.68u as=0 ps=0 w=1u l=1u
X2571 VDD VSS.t936 VDD VDD sg13_lv_pmos ad=0.19p pd=1.38u as=0 ps=0 w=1u l=1u
X2572 VSS.t1 sg13cmos5l_and2_1_2.B a_8779_14832# VSS.t0 sg13_lv_nmos ad=0.1331p pd=1.12u as=0.1216p ps=1.02u w=0.64u l=0.13u
X2573 a_27407_13799# a_26565_13701# a_27313_13799# VSS.t73 sg13_lv_nmos ad=0.12665p pd=1.145u as=0.1428p ps=1.52u w=0.42u l=0.13u
X2574 VDD VSS.t1212 VDD VDD sg13_lv_pmos ad=0.34p pd=2.68u as=0 ps=0 w=1u l=1u
X2575 VDD VSS.t1986 VDD VDD sg13_lv_pmos ad=0.34p pd=2.68u as=0 ps=0 w=1u l=1u
X2576 VDD VSS.t2356 VDD VDD sg13_lv_pmos ad=0.19p pd=1.38u as=0 ps=0 w=1u l=1u
X2577 VDD VSS.t2014 VDD VDD sg13_lv_pmos ad=0.19p pd=1.38u as=0 ps=0 w=1u l=1u
X2578 a_6660_14909# a_6372_14488# a_6598_14909# VSS.t160 sg13_lv_nmos ad=0.1428p pd=1.52u as=37.8f ps=0.6u w=0.42u l=0.13u
X2579 a_25203_13320# sg13cmos5l_a21oi_1_3.A2 VSS.t67 VSS.t231 sg13_lv_nmos ad=0.1406p pd=1.12u as=0.2516p ps=2.16u w=0.74u l=0.13u
X2580 VSS.t1660 VDD VSS.t1659 VSS.t1658 sg13_lv_nmos ad=0.1428p pd=1.52u as=0 ps=0 w=0.42u l=1u
X2581 VDD VSS.t863 VDD VDD sg13_lv_pmos ad=0.34p pd=2.68u as=0 ps=0 w=1u l=1u
X2582 VSS.t21 clock_i a_15579_14854# VSS.t3239 sg13_lv_nmos ad=0.1406p pd=1.12u as=0.1406p ps=1.12u w=0.74u l=0.13u
X2583 VDD VSS.t1279 VDD VDD sg13_lv_pmos ad=0.34p pd=2.68u as=0 ps=0 w=1u l=1u
X2584 a_17892_14909# a_18123_14495# a_17578_14452# VSS.t8 sg13_lv_nmos ad=0.2373p pd=1.97u as=79.8f ps=0.8u w=0.42u l=0.13u
X2585 a_17961_14531# a_17604_14488# VDD VDD sg13_lv_pmos ad=63f pd=0.72u as=0.1563p ps=1.22u w=0.42u l=0.13u
X2586 VDD VSS.t503 VDD VDD sg13_lv_pmos ad=0.34p pd=2.68u as=0 ps=0 w=1u l=1u
X2587 VDD VSS.t611 VDD VDD sg13_lv_pmos ad=0.19p pd=1.38u as=0 ps=0 w=1u l=1u
X2588 VSS.t1039 VDD VSS.t1041 VSS.t1040 sg13_lv_nmos ad=79.8f pd=0.8u as=0 ps=0 w=0.42u l=1u
X2589 VSS.t2469 VDD VSS.t2468 VSS.t2467 sg13_lv_nmos ad=0.1428p pd=1.52u as=0 ps=0 w=0.42u l=1u
X2590 VDD a_32492_15960# counter_value_o[6] VDD sg13_lv_pmos ad=0.2114p pd=1.54u as=0.42p ps=2.99u w=1.12u l=0.13u
X2591 VSS.t605 VDD VSS.t605 VSS.t740 sg13_lv_nmos ad=0.1428p pd=1.52u as=0 ps=0 w=0.42u l=1u
X2592 VDD VSS.t1242 VDD VDD sg13_lv_pmos ad=0.19p pd=1.38u as=0 ps=0 w=1u l=1u
X2593 VDD VSS.t2041 VDD VDD sg13_lv_pmos ad=0.34p pd=2.68u as=0 ps=0 w=1u l=1u
X2594 a_17126_15238# a_16856_15238# VSS.t13 VSS.t176 sg13_lv_nmos ad=0.1428p pd=1.52u as=79.8f ps=0.8u w=0.42u l=0.5u
X2595 VSS.t899 VDD VSS.t898 VSS.t897 sg13_lv_nmos ad=0.1428p pd=1.52u as=0 ps=0 w=0.42u l=1u
X2596 VDD VSS.t3159 VDD VDD sg13_lv_pmos ad=0.19p pd=1.38u as=0 ps=0 w=1u l=1u
X2597 VSS.t2234 VDD VSS.t2236 VSS.t2235 sg13_lv_nmos ad=79.8f pd=0.8u as=0 ps=0 w=0.42u l=1u
X2598 VSS.t1222 VDD VSS.t1223 VSS.t1154 sg13_lv_nmos ad=79.8f pd=0.8u as=0 ps=0 w=0.42u l=1u
X2599 VDD VSS.t2655 VDD VDD sg13_lv_pmos ad=0.34p pd=2.68u as=0 ps=0 w=1u l=1u
X2600 VSS.t2702 VDD VSS.t2703 VSS.t198 sg13_lv_nmos ad=79.8f pd=0.8u as=0 ps=0 w=0.42u l=1u
X2601 VSS.t1455 VDD VSS.t1454 VSS.t1453 sg13_lv_nmos ad=0.1428p pd=1.52u as=0 ps=0 w=0.42u l=1u
X2602 VSS.t172 a_21466_15202# a_21185_15424# VSS.t171 sg13_lv_nmos ad=79.8f pd=0.8u as=0.1428p ps=1.52u w=0.42u l=0.5u
X2603 VDD VSS.t903 VDD VDD sg13_lv_pmos ad=0.34p pd=2.68u as=0 ps=0 w=1u l=1u
X2604 VDD VSS.t1464 VDD VDD sg13_lv_pmos ad=0.34p pd=2.68u as=0 ps=0 w=1u l=1u
X2605 VDD VSS.t2373 VDD VDD sg13_lv_pmos ad=0.34p pd=2.68u as=0 ps=0 w=1u l=1u
X2606 VSS.t774 VDD VSS.t773 VSS.t772 sg13_lv_nmos ad=0.1428p pd=1.52u as=0 ps=0 w=0.42u l=1u
X2607 VDD VSS.t1203 VDD VDD sg13_lv_pmos ad=0.34p pd=2.68u as=0 ps=0 w=1u l=1u
X2608 VDD VSS.t2703 VDD VDD sg13_lv_pmos ad=0.34p pd=2.68u as=0 ps=0 w=1u l=1u
X2609 VSS.t2264 VDD VSS.t2263 VSS.t2262 sg13_lv_nmos ad=0.1428p pd=1.52u as=0 ps=0 w=0.42u l=1u
X2610 VSS.t83 a_18106_15960# a_17825_16262# VSS.t3240 sg13_lv_nmos ad=79.8f pd=0.8u as=0.1428p ps=1.52u w=0.42u l=0.5u
X2611 a_32492_15960# sg13cmos5l_dfrbpq_1_7.Q VDD VDD sg13_lv_pmos ad=0.2856p pd=2.36u as=0.2114p ps=1.54u w=0.84u l=0.13u
X2612 VDD VSS.t826 VDD VDD sg13_lv_pmos ad=0.19p pd=1.38u as=0 ps=0 w=1u l=1u
X2613 VSS.t2645 VDD VSS.t2646 VSS.t198 sg13_lv_nmos ad=79.8f pd=0.8u as=0 ps=0 w=0.42u l=1u
X2614 VDD VSS.t2498 VDD VDD sg13_lv_pmos ad=0.34p pd=2.68u as=0 ps=0 w=1u l=1u
X2615 VSS.t556 VDD VSS.t558 VSS.t557 sg13_lv_nmos ad=79.8f pd=0.8u as=0 ps=0 w=0.42u l=1u
X2616 VSS.t1009 VDD VSS.t1008 VSS.t1007 sg13_lv_nmos ad=0.1428p pd=1.52u as=0 ps=0 w=0.42u l=1u
X2617 VSS.t1199 VDD VSS.t1198 VSS.t1154 sg13_lv_nmos ad=0.1428p pd=1.52u as=0 ps=0 w=0.42u l=1u
X2618 VSS.t132 VDD VSS.t132 VSS.t392 sg13_lv_nmos ad=79.8f pd=0.8u as=0 ps=0 w=0.42u l=1u
X2619 VSS.t1231 VDD VSS.t1232 VSS.t1154 sg13_lv_nmos ad=79.8f pd=0.8u as=0 ps=0 w=0.42u l=1u
X2620 VDD VSS.t1180 VDD VDD sg13_lv_pmos ad=0.34p pd=2.68u as=0 ps=0 w=1u l=1u
X2621 VDD VSS.t2026 VDD VDD sg13_lv_pmos ad=0.34p pd=2.68u as=0 ps=0 w=1u l=1u
X2622 VSS.t1204 VDD VSS.t1203 VSS.t1154 sg13_lv_nmos ad=0.1428p pd=1.52u as=0 ps=0 w=0.42u l=1u
X2623 a_2540_15960# sg13cmos5l_dlygate4sd3_1_3.A VDD VDD sg13_lv_pmos ad=0.2856p pd=2.36u as=0.2114p ps=1.54u w=0.84u l=0.13u
X2624 VSS.t789 VDD VSS.t788 VSS.t787 sg13_lv_nmos ad=0.1428p pd=1.52u as=0 ps=0 w=0.42u l=1u
X2625 VSS.t974 VDD VSS.t976 VSS.t975 sg13_lv_nmos ad=79.8f pd=0.8u as=0 ps=0 w=0.42u l=1u
X2626 VSS.t2713 VDD VSS.t2712 VSS.t198 sg13_lv_nmos ad=0.1428p pd=1.52u as=0 ps=0 w=0.42u l=1u
X2627 VDD VSS.t2665 VDD VDD sg13_lv_pmos ad=0.34p pd=2.68u as=0 ps=0 w=1u l=1u
X2628 VDD VSS.t1974 VDD VDD sg13_lv_pmos ad=0.19p pd=1.38u as=0 ps=0 w=1u l=1u
X2629 VSS.t1158 VDD VSS.t1159 VSS.t1154 sg13_lv_nmos ad=79.8f pd=0.8u as=0 ps=0 w=0.42u l=1u
X2630 VDD VSS.t1444 VDD VDD sg13_lv_pmos ad=0.34p pd=2.68u as=0 ps=0 w=1u l=1u
X2631 VDD VSS.t525 VDD VDD sg13_lv_pmos ad=0.34p pd=2.68u as=0 ps=0 w=1u l=1u
X2632 VSS.t2082 VDD VSS.t2084 VSS.t2083 sg13_lv_nmos ad=79.8f pd=0.8u as=0 ps=0 w=0.42u l=1u
X2633 VSS.t1525 VDD VSS.t1524 VSS.t1523 sg13_lv_nmos ad=0.1428p pd=1.52u as=0 ps=0 w=0.42u l=1u
X2634 VSS.t3162 VDD VSS.t3164 VSS.t3163 sg13_lv_nmos ad=79.8f pd=0.8u as=0 ps=0 w=0.42u l=1u
X2635 VDD VSS.t573 VDD VDD sg13_lv_pmos ad=0.34p pd=2.68u as=0 ps=0 w=1u l=1u
X2636 VDD VSS.t981 VDD VDD sg13_lv_pmos ad=0.19p pd=1.38u as=0 ps=0 w=1u l=1u
X2637 VDD VSS.t1484 VDD VDD sg13_lv_pmos ad=0.34p pd=2.68u as=0 ps=0 w=1u l=1u
X2638 VSS.t2676 VDD VSS.t2675 VSS.t198 sg13_lv_nmos ad=0.1428p pd=1.52u as=0 ps=0 w=0.42u l=1u
X2639 VDD VSS.t2393 VDD VDD sg13_lv_pmos ad=0.34p pd=2.68u as=0 ps=0 w=1u l=1u
X2640 VDD VSS.t1657 VDD VDD sg13_lv_pmos ad=0.19p pd=1.38u as=0 ps=0 w=1u l=1u
X2641 VSS.t405 VDD VSS.t404 VSS.t11 sg13_lv_nmos ad=0.1428p pd=1.52u as=0 ps=0 w=0.42u l=1u
X2642 VDD VSS.t793 VDD VDD sg13_lv_pmos ad=0.34p pd=2.68u as=0 ps=0 w=1u l=1u
X2643 VSS.t291 VDD VSS.t286 VSS.t290 sg13_lv_nmos ad=0.1428p pd=1.52u as=0 ps=0 w=0.42u l=1u
X2644 sg13cmos5l_xor2_1_0.X a_2490_14447# VSS.t121 VSS.t120 sg13_lv_nmos ad=0.1628p pd=1.18u as=0.3108p ps=2.32u w=0.74u l=0.13u
X2645 VSS.t561 VDD VSS.t563 VSS.t562 sg13_lv_nmos ad=79.8f pd=0.8u as=0 ps=0 w=0.42u l=1u
X2646 sg13cmos5l_dfrbpq_1_2.Q a_17994_14020# VSS.t87 VSS.t3264 sg13_lv_nmos ad=0.2516p pd=2.16u as=0.1406p ps=1.12u w=0.74u l=0.13u
X2647 VDD VSS.t2341 VDD VDD sg13_lv_pmos ad=0.19p pd=1.38u as=0 ps=0 w=1u l=1u
X2648 VDD VSS.t1999 VDD VDD sg13_lv_pmos ad=0.19p pd=1.38u as=0 ps=0 w=1u l=1u
X2649 VSS.t2002 VDD VSS.t2001 VSS.t2000 sg13_lv_nmos ad=0.1428p pd=1.52u as=0 ps=0 w=0.42u l=1u
X2650 VDD VSS.t908 VDD VDD sg13_lv_pmos ad=0.34p pd=2.68u as=0 ps=0 w=1u l=1u
X2651 VSS.t1176 VDD VSS.t1177 VSS.t1154 sg13_lv_nmos ad=79.8f pd=0.8u as=0 ps=0 w=0.42u l=1u
X2652 VSS.t1213 VDD VSS.t1212 VSS.t1154 sg13_lv_nmos ad=0.1428p pd=1.52u as=0 ps=0 w=0.42u l=1u
X2653 VDD VSS.t1306 VDD VDD sg13_lv_pmos ad=0.34p pd=2.68u as=0 ps=0 w=1u l=1u
X2654 VDD VSS.t503 VDD VDD sg13_lv_pmos ad=0.34p pd=2.68u as=0 ps=0 w=1u l=1u
X2655 a_9444_15552# a_9963_15356# a_10703_15311# VSS.t115 sg13_lv_nmos ad=0.3473p pd=2.71u as=0.12665p ps=1.145u w=0.74u l=0.13u
X2656 a_7888_14726# sg13cmos5l_dfrbpq_1_1.RESET_B VDD VDD sg13_lv_pmos ad=79.8f pd=0.8u as=2.42015p ps=15.68u w=0.42u l=0.13u
X2657 VSS.t635 VDD VSS.t632 VSS.t634 sg13_lv_nmos ad=0.1428p pd=1.52u as=0 ps=0 w=0.42u l=1u
X2658 VSS.t503 VDD VSS.t503 VSS.t505 sg13_lv_nmos ad=79.8f pd=0.8u as=0 ps=0 w=0.42u l=1u
X2659 VDD a_27215_14845# a_27472_14726# VDD sg13_lv_pmos ad=2.42015p pd=15.68u as=79.8f ps=0.8u w=0.42u l=0.13u
X2660 VSS.t899 VDD VSS.t898 VSS.t897 sg13_lv_nmos ad=0.1428p pd=1.52u as=0 ps=0 w=0.42u l=1u
X2661 VSS.t1180 VDD VSS.t1181 VSS.t1154 sg13_lv_nmos ad=79.8f pd=0.8u as=0 ps=0 w=0.42u l=1u
X2662 VDD VSS.t2631 VDD VDD sg13_lv_pmos ad=0.19p pd=1.38u as=0 ps=0 w=1u l=1u
X2663 VDD VSS.t434 VDD VDD sg13_lv_pmos ad=0.34p pd=2.68u as=0 ps=0 w=1u l=1u
X2664 VSS.t1515 VDD VSS.t1514 VSS.t1513 sg13_lv_nmos ad=0.1428p pd=1.52u as=0 ps=0 w=0.42u l=1u
X2665 VSS.t3032 VDD VSS.t3031 VSS.t3030 sg13_lv_nmos ad=0.1428p pd=1.52u as=0 ps=0 w=0.42u l=1u
X2666 VSS.t2249 VDD VSS.t2248 VSS.t2247 sg13_lv_nmos ad=0.1428p pd=1.52u as=0 ps=0 w=0.42u l=1u
X2667 VDD a_7631_14845# a_8298_14484# VDD sg13_lv_pmos ad=0.2128p pd=1.5u as=0.3864p ps=2.93u w=1.12u l=0.13u
X2668 VSS.t944 VDD VSS.t943 VSS.t942 sg13_lv_nmos ad=0.1428p pd=1.52u as=0 ps=0 w=0.42u l=1u
X2669 VDD VSS.t808 VDD VDD sg13_lv_pmos ad=0.34p pd=2.68u as=0 ps=0 w=1u l=1u
X2670 VSS.t1249 VDD VSS.t1250 VSS.t1154 sg13_lv_nmos ad=79.8f pd=0.8u as=0 ps=0 w=0.42u l=1u
X2671 VDD VSS.t3144 VDD VDD sg13_lv_pmos ad=0.19p pd=1.38u as=0 ps=0 w=1u l=1u
X2672 VDD VSS.t1637 VDD VDD sg13_lv_pmos ad=0.19p pd=1.38u as=0 ps=0 w=1u l=1u
X2673 VDD VSS.t3096 VDD VDD sg13_lv_pmos ad=0.34p pd=2.68u as=0 ps=0 w=1u l=1u
X2674 VSS.t2693 VDD VSS.t2694 VSS.t198 sg13_lv_nmos ad=79.8f pd=0.8u as=0 ps=0 w=0.42u l=1u
X2675 VSS.t774 VDD VSS.t773 VSS.t772 sg13_lv_nmos ad=0.1428p pd=1.52u as=0 ps=0 w=0.42u l=1u
X2676 VSS.t341 VDD VSS.t343 VSS.t342 sg13_lv_nmos ad=79.8f pd=0.8u as=0 ps=0 w=0.42u l=1u
X2677 VSS.t2037 VDD VSS.t2036 VSS.t2035 sg13_lv_nmos ad=0.1428p pd=1.52u as=0 ps=0 w=0.42u l=1u
X2678 a_19054_15423# a_19169_15424# VSS.t162 VSS.t18 sg13_lv_nmos ad=0.1428p pd=1.52u as=0.1426p ps=1.16u w=0.42u l=0.5u
X2679 VSS.t508 VDD VSS.t72 VSS.t512 sg13_lv_nmos ad=79.8f pd=0.8u as=0 ps=0 w=0.42u l=1u
X2680 VSS.t1004 VDD VSS.t1006 VSS.t1005 sg13_lv_nmos ad=79.8f pd=0.8u as=0 ps=0 w=0.42u l=1u
X2681 VDD VSS.t1194 VDD VDD sg13_lv_pmos ad=0.19p pd=1.38u as=0 ps=0 w=1u l=1u
X2682 VDD VSS.t1194 VDD VDD sg13_lv_pmos ad=0.34p pd=2.68u as=0 ps=0 w=1u l=1u
X2683 VDD VSS.t2694 VDD VDD sg13_lv_pmos ad=0.34p pd=2.68u as=0 ps=0 w=1u l=1u
X2684 VDD VSS.t2732 VDD VDD sg13_lv_pmos ad=0.19p pd=1.38u as=0 ps=0 w=1u l=1u
X2685 VSS.t1268 VDD VSS.t1269 VSS.t1154 sg13_lv_nmos ad=79.8f pd=0.8u as=0 ps=0 w=0.42u l=1u
X2686 VSS.t1188 VDD VSS.t1190 VSS.t1154 sg13_lv_nmos ad=79.8f pd=0.8u as=0 ps=0 w=0.42u l=1u
X2687 VDD VSS.t2326 VDD VDD sg13_lv_pmos ad=0.19p pd=1.38u as=0 ps=0 w=1u l=1u
X2688 VDD VSS.t871 VDD VDD sg13_lv_pmos ad=0.19p pd=1.38u as=0 ps=0 w=1u l=1u
X2689 VSS.t2786 VDD VSS.t2638 VSS.t198 sg13_lv_nmos ad=79.8f pd=0.8u as=0 ps=0 w=0.42u l=1u
X2690 VDD sg13cmos5l_nand4_1_0.Y a_14261_15238# VDD sg13_lv_pmos ad=0.203p pd=1.5u as=0.1596p ps=1.22u w=0.84u l=0.13u
X2691 VDD VSS.t580 VDD VDD sg13_lv_pmos ad=0.34p pd=2.68u as=0 ps=0 w=1u l=1u
X2692 sg13cmos5l_dfrbpq_1_1.RESET_B a_5886_15486# VDD VDD sg13_lv_pmos ad=0.3927p pd=2.99u as=2.8961p ps=18.25u w=1.155u l=0.13u
X2693 VSS.t423 VDD VSS.t422 VSS.t11 sg13_lv_nmos ad=0.1428p pd=1.52u as=0 ps=0 w=0.42u l=1u
X2694 VSS.t373 VDD VSS.t373 VSS.t374 sg13_lv_nmos ad=79.8f pd=0.8u as=0 ps=0 w=0.42u l=1u
X2695 VSS.t11 sg13cmos5l_dlygate4sd3_1_0.X a_5707_14832# VSS.t81 sg13_lv_nmos ad=0.1331p pd=1.12u as=0.1216p ps=1.02u w=0.64u l=0.13u
X2696 VSS.t789 VDD VSS.t788 VSS.t787 sg13_lv_nmos ad=0.1428p pd=1.52u as=0 ps=0 w=0.42u l=1u
X2697 VSS.t2740 VDD VSS.t2741 VSS.t198 sg13_lv_nmos ad=79.8f pd=0.8u as=0 ps=0 w=0.42u l=1u
X2698 VDD a_25390_16263# sg13cmos5l_a21oi_1_2.A1 VDD sg13_lv_pmos ad=0.2254p pd=1.53u as=0.4256p ps=3u w=1.12u l=0.13u
X2699 VSS.t974 VDD VSS.t976 VSS.t975 sg13_lv_nmos ad=79.8f pd=0.8u as=0 ps=0 w=0.42u l=1u
X2700 VDD VSS.t963 VDD VDD sg13_lv_pmos ad=0.34p pd=2.68u as=0 ps=0 w=1u l=1u
X2701 VDD VSS.t2011 VDD VDD sg13_lv_pmos ad=0.34p pd=2.68u as=0 ps=0 w=1u l=1u
X2702 VDD VSS.t269 VDD VDD sg13_lv_pmos ad=0.34p pd=2.68u as=0 ps=0 w=1u l=1u
X2703 VSS.t546 VDD VSS.t545 VSS.t544 sg13_lv_nmos ad=0.1428p pd=1.52u as=0 ps=0 w=0.42u l=1u
X2704 VDD VSS.t3129 VDD VDD sg13_lv_pmos ad=0.19p pd=1.38u as=0 ps=0 w=1u l=1u
X2705 VSS.t5 a_25094_15238# a_25206_15302# VSS.t64 sg13_lv_nmos ad=0.1426p pd=1.16u as=0.1428p ps=1.52u w=0.42u l=0.5u
X2706 VDD VSS.t387 VDD VDD sg13_lv_pmos ad=0.19p pd=1.38u as=0 ps=0 w=1u l=1u
X2707 a_9861_14521# a_9861_14521# VSS.t11 VSS.t3218 sg13_lv_nmos ad=0.111p pd=1.34u as=4.11262p ps=27.15u w=0.3u l=0.13u
X2708 VDD VSS.t525 VDD VDD sg13_lv_pmos ad=0.34p pd=2.68u as=0 ps=0 w=1u l=1u
X2709 VDD VSS.t2658 VDD VDD sg13_lv_pmos ad=0.34p pd=2.68u as=0 ps=0 w=1u l=1u
X2710 a_10703_15311# a_9861_15213# a_10609_15311# VSS.t94 sg13_lv_nmos ad=0.12665p pd=1.145u as=0.1428p ps=1.52u w=0.42u l=0.13u
X2711 VDD VSS.t180 VDD VDD sg13_lv_pmos ad=0.34p pd=2.68u as=0 ps=0 w=1u l=1u
X2712 VSS.t1460 VDD VSS.t1459 VSS.t1458 sg13_lv_nmos ad=0.1428p pd=1.52u as=0 ps=0 w=0.42u l=1u
X2713 VSS.t227 VDD VSS.t227 VSS.t362 sg13_lv_nmos ad=79.8f pd=0.8u as=0 ps=0 w=0.42u l=1u
X2714 VSS.t1630 VDD VSS.t1632 VSS.t1631 sg13_lv_nmos ad=79.8f pd=0.8u as=0 ps=0 w=0.42u l=1u
X2715 VSS.t3147 VDD VSS.t3149 VSS.t3148 sg13_lv_nmos ad=79.8f pd=0.8u as=0 ps=0 w=0.42u l=1u
X2716 sg13cmos5l_buf_8_2.X a_19323_13726# VDD VDD sg13_lv_pmos ad=0.2128p pd=1.5u as=0.2128p ps=1.5u w=1.12u l=0.13u
X2717 VDD VSS.t1167 VDD VDD sg13_lv_pmos ad=0.34p pd=2.68u as=0 ps=0 w=1u l=1u
X2718 VDD VSS.t1469 VDD VDD sg13_lv_pmos ad=0.34p pd=2.68u as=0 ps=0 w=1u l=1u
X2719 VDD VSS.t2378 VDD VDD sg13_lv_pmos ad=0.34p pd=2.68u as=0 ps=0 w=1u l=1u
X2720 VSS.t432 VDD VSS.t431 VSS.t11 sg13_lv_nmos ad=0.1428p pd=1.52u as=0 ps=0 w=0.42u l=1u
X2721 VDD VSS.t838 VDD VDD sg13_lv_pmos ad=0.34p pd=2.68u as=0 ps=0 w=1u l=1u
X2722 VDD VSS.t1026 VDD VDD sg13_lv_pmos ad=0.19p pd=1.38u as=0 ps=0 w=1u l=1u
X2723 VSS.t2269 VDD VSS.t2268 VSS.t2267 sg13_lv_nmos ad=0.1428p pd=1.52u as=0 ps=0 w=0.42u l=1u
X2724 VDD VSS.t1976 VDD VDD sg13_lv_pmos ad=0.34p pd=2.68u as=0 ps=0 w=1u l=1u
X2725 VSS.t274 VDD VSS.t274 VSS.t275 sg13_lv_nmos ad=79.8f pd=0.8u as=0 ps=0 w=0.42u l=1u
X2726 a_15579_14854# clock_i VDD VDD sg13_lv_pmos ad=0.2128p pd=1.5u as=0.2128p ps=1.5u w=1.12u l=0.13u
X2727 VSS.t2439 VDD VSS.t2441 VSS.t2440 sg13_lv_nmos ad=79.8f pd=0.8u as=0 ps=0 w=0.42u l=1u
X2728 VDD VSS.t2503 VDD VDD sg13_lv_pmos ad=0.34p pd=2.68u as=0 ps=0 w=1u l=1u
X2729 VSS.t1987 VDD VSS.t1986 VSS.t1985 sg13_lv_nmos ad=0.1428p pd=1.52u as=0 ps=0 w=0.42u l=1u
X2730 VSS.t333 VDD VSS.t236 VSS.t334 sg13_lv_nmos ad=79.8f pd=0.8u as=0 ps=0 w=0.42u l=1u
X2731 VSS.t11 a_18021_14495# a_18123_14495# VSS.t51 sg13_lv_nmos ad=4.11262p pd=27.15u as=0.2516p ps=2.16u w=0.74u l=0.13u
X2732 VDD VSS.t629 VDD VDD sg13_lv_pmos ad=0.19p pd=1.38u as=0 ps=0 w=1u l=1u
X2733 VSS.t1937 VDD VSS.t1939 VSS.t1938 sg13_lv_nmos ad=79.8f pd=0.8u as=0 ps=0 w=0.42u l=1u
X2734 VDD VSS.t1659 VDD VDD sg13_lv_pmos ad=0.34p pd=2.68u as=0 ps=0 w=1u l=1u
X2735 VSS.t3017 VDD VSS.t3019 VSS.t3018 sg13_lv_nmos ad=79.8f pd=0.8u as=0 ps=0 w=0.42u l=1u
X2736 VDD sg13cmos5l_dfrbpq_1_6.RESET_B a_21034_14452# VDD sg13_lv_pmos ad=0.1563p pd=1.22u as=0.147p ps=1.54u w=0.42u l=0.13u
X2737 VDD sg13cmos5l_dlygate4sd3_1_8.X sg13cmos5l_nand4_1_0.Y VDD sg13_lv_pmos ad=0.3808p pd=2.92u as=0.2128p ps=1.5u w=1.12u l=0.13u
X2738 a_6680_15242# sg13cmos5l_dlygate4sd3_1_1.A a_6578_15242# VSS.t3174 sg13_lv_nmos ad=0.1406p pd=1.12u as=0.1406p ps=1.12u w=0.74u l=0.13u
X2739 VDD VSS.t596 VDD VDD sg13_lv_pmos ad=0.19p pd=1.38u as=0 ps=0 w=1u l=1u
X2740 VSS.t944 VDD VSS.t943 VSS.t942 sg13_lv_nmos ad=0.1428p pd=1.52u as=0 ps=0 w=0.42u l=1u
X2741 VSS.t1286 VDD VSS.t1287 VSS.t1154 sg13_lv_nmos ad=79.8f pd=0.8u as=0 ps=0 w=0.42u l=1u
X2742 VSS.t1720 VDD VSS.t1722 VSS.t1721 sg13_lv_nmos ad=79.8f pd=0.8u as=0 ps=0 w=0.42u l=1u
X2743 VDD VSS.t2623 VDD VDD sg13_lv_pmos ad=0.19p pd=1.38u as=0 ps=0 w=1u l=1u
X2744 VSS.t2234 VDD VSS.t2233 VSS.t2232 sg13_lv_nmos ad=0.1428p pd=1.52u as=0 ps=0 w=0.42u l=1u
X2745 sg13cmos5l_dfrbpq_1_2.RESET_B a_15870_15486# VDD VDD sg13_lv_pmos ad=0.3927p pd=2.99u as=2.8961p ps=18.25u w=1.155u l=0.13u
X2746 VSS.t39 a_7631_14845# a_8298_14484# VSS.t141 sg13_lv_nmos ad=0.1406p pd=1.12u as=0.2516p ps=2.16u w=0.74u l=0.13u
X2747 VSS.t2715 VDD VSS.t2715 VSS.t198 sg13_lv_nmos ad=0.1428p pd=1.52u as=0 ps=0 w=0.42u l=1u
X2748 VDD VSS.t425 VDD VDD sg13_lv_pmos ad=0.34p pd=2.68u as=0 ps=0 w=1u l=1u
X2749 a_26638_15423# a_26753_15424# VSS.t11 VSS.t10 sg13_lv_nmos ad=0.1428p pd=1.52u as=0.1426p ps=1.16u w=0.42u l=0.5u
X2750 a_16068_14040# a_16587_13844# a_17327_13799# VSS.t54 sg13_lv_nmos ad=0.3473p pd=2.71u as=0.12665p ps=1.145u w=0.74u l=0.13u
X2751 VDD VSS.t3081 VDD VDD sg13_lv_pmos ad=0.34p pd=2.68u as=0 ps=0 w=1u l=1u
X2752 VSS.t2087 VDD VSS.t2089 VSS.t2088 sg13_lv_nmos ad=79.8f pd=0.8u as=0 ps=0 w=0.42u l=1u
X2753 VDD VSS.t308 VDD VDD sg13_lv_pmos ad=0.34p pd=2.68u as=0 ps=0 w=1u l=1u
X2754 VSS.t1004 VDD VSS.t1006 VSS.t1005 sg13_lv_nmos ad=79.8f pd=0.8u as=0 ps=0 w=0.42u l=1u
X2755 VDD VSS.t1258 VDD VDD sg13_lv_pmos ad=0.34p pd=2.68u as=0 ps=0 w=1u l=1u
X2756 VSS.t1650 VDD VSS.t1652 VSS.t1651 sg13_lv_nmos ad=79.8f pd=0.8u as=0 ps=0 w=0.42u l=1u
X2757 VDD VSS.t801 VDD VDD sg13_lv_pmos ad=0.19p pd=1.38u as=0 ps=0 w=1u l=1u
X2758 VDD VSS.t993 VDD VDD sg13_lv_pmos ad=0.34p pd=2.68u as=0 ps=0 w=1u l=1u
X2759 VDD VSS.t1454 VDD VDD sg13_lv_pmos ad=0.34p pd=2.68u as=0 ps=0 w=1u l=1u
X2760 VSS.t1295 VDD VSS.t1295 VSS.t1154 sg13_lv_nmos ad=79.8f pd=0.8u as=0 ps=0 w=0.42u l=1u
X2761 VDD VSS.t1717 VDD VDD sg13_lv_pmos ad=0.19p pd=1.38u as=0 ps=0 w=1u l=1u
X2762 VDD VSS.t608 VDD VDD sg13_lv_pmos ad=0.34p pd=2.68u as=0 ps=0 w=1u l=1u
X2763 VSS.t864 VDD VSS.t863 VSS.t862 sg13_lv_nmos ad=0.1428p pd=1.52u as=0 ps=0 w=0.42u l=1u
X2764 VSS.t1590 VDD VSS.t1589 VSS.t1588 sg13_lv_nmos ad=0.1428p pd=1.52u as=0 ps=0 w=0.42u l=1u
X2765 VDD VSS.t2488 VDD VDD sg13_lv_pmos ad=0.34p pd=2.68u as=0 ps=0 w=1u l=1u
X2766 VDD VSS.t2311 VDD VDD sg13_lv_pmos ad=0.19p pd=1.38u as=0 ps=0 w=1u l=1u
X2767 VSS.t1200 VDD VSS.t1202 VSS.t1154 sg13_lv_nmos ad=79.8f pd=0.8u as=0 ps=0 w=0.42u l=1u
X2768 VDD VSS.t291 VDD VDD sg13_lv_pmos ad=0.34p pd=2.68u as=0 ps=0 w=1u l=1u
X2769 VDD a_6286_13911# sg13cmos5l_dlygate4sd3_1_0.X VDD sg13_lv_pmos ad=0.2254p pd=1.53u as=0.4256p ps=3u w=1.12u l=0.13u
X2770 a_26505_14113# a_26148_14040# VDD VDD sg13_lv_pmos ad=63f pd=0.72u as=0.1563p ps=1.22u w=0.42u l=0.13u
X2771 VSS.t1299 VDD VSS.t1301 VSS.t1154 sg13_lv_nmos ad=79.8f pd=0.8u as=0 ps=0 w=0.42u l=1u
X2772 VDD VSS.t2064 VDD VDD sg13_lv_pmos ad=0.19p pd=1.38u as=0 ps=0 w=1u l=1u
X2773 VDD VSS.t523 VDD VDD sg13_lv_pmos ad=0.19p pd=1.38u as=0 ps=0 w=1u l=1u
X2774 VSS.t103 sg13cmos5l_o21ai_1_2.Y a_24824_15238# VSS.t64 sg13_lv_nmos ad=79.8f pd=0.8u as=0.1428p ps=1.52u w=0.42u l=0.13u
X2775 VDD VSS.t1839 VDD VDD sg13_lv_pmos ad=0.19p pd=1.38u as=0 ps=0 w=1u l=1u
X2776 VSS.t1882 VDD VSS.t1884 VSS.t1883 sg13_lv_nmos ad=79.8f pd=0.8u as=0 ps=0 w=0.42u l=1u
X2777 VSS.t21 sg13cmos5l_inv_1_0.Y a_16596_15280# VSS.t3272 sg13_lv_nmos ad=0.2272p pd=1.99u as=78.39999f ps=0.885u w=0.64u l=0.13u
X2778 VSS.t2424 VDD VSS.t2426 VSS.t2425 sg13_lv_nmos ad=79.8f pd=0.8u as=0 ps=0 w=0.42u l=1u
X2779 VDD VSS.t503 VDD VDD sg13_lv_pmos ad=0.34p pd=2.68u as=0 ps=0 w=1u l=1u
X2780 VDD VSS.t2366 VDD VDD sg13_lv_pmos ad=0.19p pd=1.38u as=0 ps=0 w=1u l=1u
X2781 a_15782_13722# sg13cmos5l_dfrbpq_1_2.D VDD VDD sg13_lv_pmos ad=79.8f pd=0.8u as=0.1428p ps=1.52u w=0.42u l=0.13u
X2782 VSS.t2696 VDD VSS.t2697 VSS.t198 sg13_lv_nmos ad=79.8f pd=0.8u as=0 ps=0 w=0.42u l=1u
X2783 a_4474_14448# sg13cmos5l_dlygate4sd3_1_3.A VDD VDD sg13_lv_pmos ad=0.1428p pd=1.52u as=0.1523p ps=1.38u w=0.42u l=0.13u
X2784 VDD VSS.t956 VDD VDD sg13_lv_pmos ad=0.19p pd=1.38u as=0 ps=0 w=1u l=1u
X2785 VSS.t1445 VDD VSS.t1444 VSS.t1443 sg13_lv_nmos ad=0.1428p pd=1.52u as=0 ps=0 w=0.42u l=1u
X2786 VSS.t1972 VDD VSS.t1974 VSS.t1973 sg13_lv_nmos ad=79.8f pd=0.8u as=0 ps=0 w=0.42u l=1u
X2787 VSS.t824 VDD VSS.t826 VSS.t825 sg13_lv_nmos ad=79.8f pd=0.8u as=0 ps=0 w=0.42u l=1u
X2788 VDD VSS.t1197 VDD VDD sg13_lv_pmos ad=0.34p pd=2.68u as=0 ps=0 w=1u l=1u
X2789 VDD VSS.t2697 VDD VDD sg13_lv_pmos ad=0.34p pd=2.68u as=0 ps=0 w=1u l=1u
X2790 a_27500_15960# sg13cmos5l_dfrbpq_1_6.Q VDD VDD sg13_lv_pmos ad=0.2856p pd=2.36u as=0.2114p ps=1.54u w=0.84u l=0.13u
X2791 VSS.t2254 VDD VSS.t2253 VSS.t2252 sg13_lv_nmos ad=0.1428p pd=1.52u as=0 ps=0 w=0.42u l=1u
X2792 VDD VSS.t433 VDD VDD sg13_lv_pmos ad=0.19p pd=1.38u as=0 ps=0 w=1u l=1u
X2793 VDD VSS.t883 VDD VDD sg13_lv_pmos ad=0.34p pd=2.68u as=0 ps=0 w=1u l=1u
X2794 VSS.t2640 VDD VSS.t2641 VSS.t198 sg13_lv_nmos ad=79.8f pd=0.8u as=0 ps=0 w=0.42u l=1u
X2795 VSS.t2102 VDD VSS.t2101 VSS.t2100 sg13_lv_nmos ad=0.1428p pd=1.52u as=0 ps=0 w=0.42u l=1u
X2796 VSS.t1922 VDD VSS.t1924 VSS.t1923 sg13_lv_nmos ad=79.8f pd=0.8u as=0 ps=0 w=0.42u l=1u
X2797 VDD VSS.t72 VDD VDD sg13_lv_pmos ad=0.34p pd=2.68u as=0 ps=0 w=1u l=1u
X2798 VDD VSS.t623 VDD VDD sg13_lv_pmos ad=0.19p pd=1.38u as=0 ps=0 w=1u l=1u
X2799 VSS.t3002 VDD VSS.t3004 VSS.t3003 sg13_lv_nmos ad=79.8f pd=0.8u as=0 ps=0 w=0.42u l=1u
X2800 VDD sg13cmos5l_dfrbpq_1_6.RESET_B a_20774_14922# VDD sg13_lv_pmos ad=0.36237p pd=2.605u as=79.8f ps=0.8u w=0.42u l=0.13u
X2801 VSS.t617 VDD VSS.t617 VSS.t748 sg13_lv_nmos ad=0.1428p pd=1.52u as=0 ps=0 w=0.42u l=1u
X2802 VDD VSS.t2944 VDD VDD sg13_lv_pmos ad=0.19p pd=1.38u as=0 ps=0 w=1u l=1u
X2803 a_2516_14484# sg13cmos5l_buf_1_0.X VDD VDD sg13_lv_pmos ad=0.3808p pd=2.92u as=0.2128p ps=1.5u w=1.12u l=0.13u
X2804 VSS.t2444 VDD VSS.t2443 VSS.t2442 sg13_lv_nmos ad=0.1428p pd=1.52u as=0 ps=0 w=0.42u l=1u
X2805 VSS.t1705 VDD VSS.t1707 VSS.t1706 sg13_lv_nmos ad=79.8f pd=0.8u as=0 ps=0 w=0.42u l=1u
X2806 VSS.t561 VDD VSS.t563 VSS.t562 sg13_lv_nmos ad=79.8f pd=0.8u as=0 ps=0 w=0.42u l=1u
X2807 VDD VSS.t2358 VDD VDD sg13_lv_pmos ad=0.34p pd=2.68u as=0 ps=0 w=1u l=1u
X2808 a_26313_14531# a_25956_14488# VDD VDD sg13_lv_pmos ad=63f pd=0.72u as=0.1563p ps=1.22u w=0.42u l=0.13u
X2809 VSS.t1234 VDD VSS.t1235 VSS.t1154 sg13_lv_nmos ad=79.8f pd=0.8u as=0 ps=0 w=0.42u l=1u
X2810 VDD VSS.t2016 VDD VDD sg13_lv_pmos ad=0.34p pd=2.68u as=0 ps=0 w=1u l=1u
X2811 VDD VSS.t3134 VDD VDD sg13_lv_pmos ad=0.19p pd=1.38u as=0 ps=0 w=1u l=1u
X2812 VDD VSS.t2660 VDD VDD sg13_lv_pmos ad=0.34p pd=2.68u as=0 ps=0 w=1u l=1u
X2813 VSS.t11 a_9737_14822# a_9658_14725# VSS.t197 sg13_lv_nmos ad=4.11262p pd=27.15u as=0.27427p ps=2.28u w=0.795u l=0.13u
X2814 VDD VSS.t1285 VDD VDD sg13_lv_pmos ad=0.34p pd=2.68u as=0 ps=0 w=1u l=1u
X2815 VSS.t1168 VDD VSS.t1167 VSS.t1154 sg13_lv_nmos ad=0.1428p pd=1.52u as=0 ps=0 w=0.42u l=1u
X2816 VSS.t1575 VDD VSS.t1577 VSS.t1576 sg13_lv_nmos ad=79.8f pd=0.8u as=0 ps=0 w=0.42u l=1u
X2817 VSS.t1635 VDD VSS.t1637 VSS.t1636 sg13_lv_nmos ad=79.8f pd=0.8u as=0 ps=0 w=0.42u l=1u
X2818 VSS.t3152 VDD VSS.t3154 VSS.t3153 sg13_lv_nmos ad=79.8f pd=0.8u as=0 ps=0 w=0.42u l=1u
X2819 VSS.t2072 VDD VSS.t2074 VSS.t2073 sg13_lv_nmos ad=79.8f pd=0.8u as=0 ps=0 w=0.42u l=1u
X2820 VSS.t794 VDD VSS.t793 VSS.t792 sg13_lv_nmos ad=0.1428p pd=1.52u as=0 ps=0 w=0.42u l=1u
X2821 VSS.t2760 VDD VSS.t2759 VSS.t198 sg13_lv_nmos ad=0.1428p pd=1.52u as=0 ps=0 w=0.42u l=1u
X2822 VDD VSS.t413 VDD VDD sg13_lv_pmos ad=0.34p pd=2.68u as=0 ps=0 w=1u l=1u
X2823 VSS.t864 VDD VSS.t863 VSS.t862 sg13_lv_nmos ad=0.1428p pd=1.52u as=0 ps=0 w=0.42u l=1u
X2824 VSS.t1161 VDD VSS.t1162 VSS.t1154 sg13_lv_nmos ad=79.8f pd=0.8u as=0 ps=0 w=0.42u l=1u
X2825 a_21549_14020# sg13cmos5l_or3_1_2.B a_21460_14020# VDD sg13_lv_pmos ad=0.19p pd=1.38u as=0.1575p ps=1.315u w=1u l=0.13u
X2826 VDD VSS.t1702 VDD VDD sg13_lv_pmos ad=0.19p pd=1.38u as=0 ps=0 w=1u l=1u
X2827 VSS.t2239 VDD VSS.t2238 VSS.t2237 sg13_lv_nmos ad=0.1428p pd=1.52u as=0 ps=0 w=0.42u l=1u
X2828 VSS.t680 VDD VSS.t682 VSS.t681 sg13_lv_nmos ad=79.8f pd=0.8u as=0 ps=0 w=0.42u l=1u
X2829 VDD VSS.t135 VDD VDD sg13_lv_pmos ad=0.34p pd=2.68u as=0 ps=0 w=1u l=1u
X2830 VDD VSS.t602 VDD VDD sg13_lv_pmos ad=0.34p pd=2.68u as=0 ps=0 w=1u l=1u
X2831 VDD VSS.t986 VDD VDD sg13_lv_pmos ad=0.19p pd=1.38u as=0 ps=0 w=1u l=1u
X2832 VDD VSS.t1654 VDD VDD sg13_lv_pmos ad=0.34p pd=2.68u as=0 ps=0 w=1u l=1u
X2833 VSS.t2633 VDD VSS.t2634 VSS.t198 sg13_lv_nmos ad=79.8f pd=0.8u as=0 ps=0 w=0.42u l=1u
X2834 VSS.t2705 VDD VSS.t2703 VSS.t198 sg13_lv_nmos ad=0.1428p pd=1.52u as=0 ps=0 w=0.42u l=1u
X2835 VDD VSS.t2473 VDD VDD sg13_lv_pmos ad=0.34p pd=2.68u as=0 ps=0 w=1u l=1u
X2836 VSS.t1942 VDD VSS.t1944 VSS.t1943 sg13_lv_nmos ad=79.8f pd=0.8u as=0 ps=0 w=0.42u l=1u
X2837 VDD VSS.t269 VDD VDD sg13_lv_pmos ad=0.19p pd=1.38u as=0 ps=0 w=1u l=1u
X2838 VDD a_21251_13690# sg13cmos5l_or3_1_2.X VDD sg13_lv_pmos ad=0.3822p pd=1.84u as=0.3808p ps=2.92u w=1.12u l=0.13u
X2839 VDD VSS.t523 VDD VDD sg13_lv_pmos ad=0.19p pd=1.38u as=0 ps=0 w=1u l=1u
X2840 VSS.t252 VDD VSS.t209 VSS.t654 sg13_lv_nmos ad=0.1428p pd=1.52u as=0 ps=0 w=0.42u l=1u
X2841 VSS.t1216 VDD VSS.t1214 VSS.t1154 sg13_lv_nmos ad=0.1428p pd=1.52u as=0 ps=0 w=0.42u l=1u
X2842 sg13cmos5l_xnor2_1_2.B sg13cmos5l_buf_1_0.X a_6202_15238# VSS.t3200 sg13_lv_nmos ad=0.2516p pd=2.16u as=0.1406p ps=1.12u w=0.74u l=0.13u
X2843 sg13cmos5l_xnor2_1_0.Y a_7680_15549# a_7829_15238# VSS.t3194 sg13_lv_nmos ad=0.2516p pd=2.16u as=0.1406p ps=1.12u w=0.74u l=0.13u
X2844 VDD VSS.t1309 VDD VDD sg13_lv_pmos ad=0.34p pd=2.68u as=0 ps=0 w=1u l=1u
X2845 VSS.t2947 VDD VSS.t2949 VSS.t2948 sg13_lv_nmos ad=79.8f pd=0.8u as=0 ps=0 w=0.42u l=1u
X2846 VDD VSS.t503 VDD VDD sg13_lv_pmos ad=0.34p pd=2.68u as=0 ps=0 w=1u l=1u
X2847 VDD VSS.t422 VDD VDD sg13_lv_pmos ad=0.34p pd=2.68u as=0 ps=0 w=1u l=1u
X2848 sg13cmos5l_a21oi_1_3.B1 sg13cmos5l_buf_1_10.X VDD VDD sg13_lv_pmos ad=0.3808p pd=2.92u as=0.3808p ps=2.92u w=1.12u l=0.13u
X2849 VDD VSS.t2690 VDD VDD sg13_lv_pmos ad=0.19p pd=1.38u as=0 ps=0 w=1u l=1u
X2850 VSS.t599 VDD VSS.t599 VSS.t600 sg13_lv_nmos ad=79.8f pd=0.8u as=0 ps=0 w=0.42u l=1u
X2851 VDD VSS.t1001 VDD VDD sg13_lv_pmos ad=0.19p pd=1.38u as=0 ps=0 w=1u l=1u
X2852 VDD VSS.t3086 VDD VDD sg13_lv_pmos ad=0.34p pd=2.68u as=0 ps=0 w=1u l=1u
X2853 VSS.t2364 VDD VSS.t2363 VSS.t2362 sg13_lv_nmos ad=0.1428p pd=1.52u as=0 ps=0 w=0.42u l=1u
X2854 VSS.t2057 VDD VSS.t2059 VSS.t2058 sg13_lv_nmos ad=79.8f pd=0.8u as=0 ps=0 w=0.42u l=1u
X2855 VDD VSS.t571 VDD VDD sg13_lv_pmos ad=0.34p pd=2.68u as=0 ps=0 w=1u l=1u
X2856 VSS.t824 VDD VSS.t826 VSS.t825 sg13_lv_nmos ad=79.8f pd=0.8u as=0 ps=0 w=0.42u l=1u
X2857 VDD VSS.t1459 VDD VDD sg13_lv_pmos ad=0.34p pd=2.68u as=0 ps=0 w=1u l=1u
X2858 VDD VSS.t2368 VDD VDD sg13_lv_pmos ad=0.34p pd=2.68u as=0 ps=0 w=1u l=1u
X2859 VSS.t546 VDD VSS.t545 VSS.t544 sg13_lv_nmos ad=0.1428p pd=1.52u as=0 ps=0 w=0.42u l=1u
X2860 VDD VSS.t1632 VDD VDD sg13_lv_pmos ad=0.19p pd=1.38u as=0 ps=0 w=1u l=1u
X2861 VDD VSS.t1687 VDD VDD sg13_lv_pmos ad=0.19p pd=1.38u as=0 ps=0 w=1u l=1u
X2862 VDD VSS.t1879 VDD VDD sg13_lv_pmos ad=0.19p pd=1.38u as=0 ps=0 w=1u l=1u
X2863 a_27034_15202# sg13cmos5l_dfrbpq_1_7.Q VSS.t11 VSS.t11 sg13_lv_nmos ad=0.1428p pd=1.52u as=79.8f ps=0.8u w=0.42u l=0.13u
X2864 VSS.t1977 VDD VSS.t1976 VSS.t1975 sg13_lv_nmos ad=0.1428p pd=1.52u as=0 ps=0 w=0.42u l=1u
X2865 VDD VSS.t1318 VDD VDD sg13_lv_pmos ad=0.34p pd=2.68u as=0 ps=0 w=1u l=1u
X2866 VSS.t521 VDD VSS.t523 VSS.t522 sg13_lv_nmos ad=79.8f pd=0.8u as=0 ps=0 w=0.42u l=1u
X2867 VDD VSS.t72 VDD VDD sg13_lv_pmos ad=0.34p pd=2.68u as=0 ps=0 w=1u l=1u
X2868 VSS.t2087 VDD VSS.t2086 VSS.t2085 sg13_lv_nmos ad=0.1428p pd=1.52u as=0 ps=0 w=0.42u l=1u
X2869 VSS.t698 VDD VSS.t576 VSS.t699 sg13_lv_nmos ad=79.8f pd=0.8u as=0 ps=0 w=0.42u l=1u
X2870 VSS.t964 VDD VSS.t963 VSS.t962 sg13_lv_nmos ad=0.1428p pd=1.52u as=0 ps=0 w=0.42u l=1u
X2871 VSS.t1887 VDD VSS.t1889 VSS.t1888 sg13_lv_nmos ad=79.8f pd=0.8u as=0 ps=0 w=0.42u l=1u
X2872 VSS.t1396 VDD VSS.t1262 VSS.t1154 sg13_lv_nmos ad=79.8f pd=0.8u as=0 ps=0 w=0.42u l=1u
X2873 VSS.t2735 VDD VSS.t2736 VSS.t198 sg13_lv_nmos ad=79.8f pd=0.8u as=0 ps=0 w=0.42u l=1u
X2874 VSS.t2429 VDD VSS.t2431 VSS.t2430 sg13_lv_nmos ad=79.8f pd=0.8u as=0 ps=0 w=0.42u l=1u
X2875 VDD VSS.t3119 VDD VDD sg13_lv_pmos ad=0.19p pd=1.38u as=0 ps=0 w=1u l=1u
X2876 a_20705_15260# sg13cmos5l_dlygate4sd3_1_9.X sg13cmos5l_a21oi_1_1.Y VSS.t18 sg13_lv_nmos ad=0.1406p pd=1.12u as=0.1406p ps=1.12u w=0.74u l=0.13u
X2877 VSS.t794 VDD VSS.t793 VSS.t792 sg13_lv_nmos ad=0.1428p pd=1.52u as=0 ps=0 w=0.42u l=1u
X2878 VSS.t2299 VDD VSS.t2298 VSS.t2297 sg13_lv_nmos ad=0.1428p pd=1.52u as=0 ps=0 w=0.42u l=1u
X2879 VSS.t1560 VDD VSS.t1562 VSS.t1561 sg13_lv_nmos ad=79.8f pd=0.8u as=0 ps=0 w=0.42u l=1u
X2880 VSS.t1024 VDD VSS.t1026 VSS.t1025 sg13_lv_nmos ad=79.8f pd=0.8u as=0 ps=0 w=0.42u l=1u
X2881 VDD VSS.t593 VDD VDD sg13_lv_pmos ad=0.34p pd=2.68u as=0 ps=0 w=1u l=1u
X2882 VDD VSS.t2989 VDD VDD sg13_lv_pmos ad=0.19p pd=1.38u as=0 ps=0 w=1u l=1u
X2883 VDD VSS.t1864 VDD VDD sg13_lv_pmos ad=0.19p pd=1.38u as=0 ps=0 w=1u l=1u
X2884 VDD VSS.t332 VDD VDD sg13_lv_pmos ad=0.34p pd=2.68u as=0 ps=0 w=1u l=1u
X2885 VDD sg13cmos5l_dfrbpq_1_3.RESET_B a_17578_14452# VDD sg13_lv_pmos ad=0.1563p pd=1.22u as=0.147p ps=1.54u w=0.42u l=0.13u
X2886 a_26122_13945# a_26565_13701# a_25862_13722# VSS.t70 sg13_lv_nmos ad=79.8f pd=0.8u as=0.1296p ps=1.52u w=0.42u l=0.13u
X2887 VSS.t1715 VDD VSS.t1717 VSS.t1716 sg13_lv_nmos ad=79.8f pd=0.8u as=0 ps=0 w=0.42u l=1u
X2888 VDD VSS.t1639 VDD VDD sg13_lv_pmos ad=0.34p pd=2.68u as=0 ps=0 w=1u l=1u
X2889 VSS.t2624 VDD VSS.t2626 VSS.t198 sg13_lv_nmos ad=79.8f pd=0.8u as=0 ps=0 w=0.42u l=1u
X2890 VSS.t2107 VDD VSS.t2106 VSS.t2105 sg13_lv_nmos ad=0.1428p pd=1.52u as=0 ps=0 w=0.42u l=1u
X2891 VSS.t1927 VDD VSS.t1929 VSS.t1928 sg13_lv_nmos ad=79.8f pd=0.8u as=0 ps=0 w=0.42u l=1u
X2892 VSS.t435 VDD VSS.t434 VSS.t11 sg13_lv_nmos ad=0.1428p pd=1.52u as=0 ps=0 w=0.42u l=1u
X2893 VSS.t3007 VDD VSS.t3009 VSS.t3008 sg13_lv_nmos ad=79.8f pd=0.8u as=0 ps=0 w=0.42u l=1u
X2894 VDD VSS.t2771 VDD VDD sg13_lv_pmos ad=0.19p pd=1.38u as=0 ps=0 w=1u l=1u
X2895 VSS.t39 sg13cmos5l_xnor2_1_0.Y a_8312_15238# VSS.t3227 sg13_lv_nmos ad=79.8f pd=0.8u as=0.1428p ps=1.52u w=0.42u l=0.13u
X2896 VDD sg13cmos5l_buf_8_2.A a_19323_13726# VDD sg13_lv_pmos ad=0.2128p pd=1.5u as=0.2128p ps=1.5u w=1.12u l=0.13u
X2897 sg13cmos5l_a21oi_1_3.A2 a_24169_14508# VDD VDD sg13_lv_pmos ad=0.3808p pd=2.92u as=0.3822p ps=1.84u w=1.12u l=0.13u
X2898 VSS.t1243 VDD VSS.t1242 VSS.t1154 sg13_lv_nmos ad=0.1428p pd=1.52u as=0 ps=0 w=0.42u l=1u
X2899 VSS.t1710 VDD VSS.t1712 VSS.t1711 sg13_lv_nmos ad=79.8f pd=0.8u as=0 ps=0 w=0.42u l=1u
X2900 VDD VSS.t2231 VDD VDD sg13_lv_pmos ad=0.19p pd=1.38u as=0 ps=0 w=1u l=1u
X2901 VDD VSS.t2328 VDD VDD sg13_lv_pmos ad=0.34p pd=2.68u as=0 ps=0 w=1u l=1u
X2902 VDD VSS.t2021 VDD VDD sg13_lv_pmos ad=0.34p pd=2.68u as=0 ps=0 w=1u l=1u
X2903 VDD VSS.t3139 VDD VDD sg13_lv_pmos ad=0.19p pd=1.38u as=0 ps=0 w=1u l=1u
X2904 VSS.t1837 VDD VSS.t1839 VSS.t1838 sg13_lv_nmos ad=79.8f pd=0.8u as=0 ps=0 w=0.42u l=1u
X2905 VSS.t201 a_22030_15423# sg13cmos5l_or3_1_2.A VSS.t3206 sg13_lv_nmos ad=0.1426p pd=1.16u as=0.2516p ps=2.16u w=0.74u l=0.13u
X2906 VSS.t1286 VDD VSS.t1285 VSS.t1154 sg13_lv_nmos ad=0.1428p pd=1.52u as=0 ps=0 w=0.42u l=1u
X2907 VDD VSS.t565 VDD VDD sg13_lv_pmos ad=0.34p pd=2.68u as=0 ps=0 w=1u l=1u
X2908 VSS.t72 a_16485_13701# a_16587_13844# VSS.t3183 sg13_lv_nmos ad=15.38618p pd=0.10091m as=0.2516p ps=2.16u w=0.74u l=0.13u
X2909 VSS.t44 VDD VSS.t44 VSS.t651 sg13_lv_nmos ad=0.1428p pd=1.52u as=0 ps=0 w=0.42u l=1u
X2910 VDD VSS.t1969 VDD VDD sg13_lv_pmos ad=0.19p pd=1.38u as=0 ps=0 w=1u l=1u
X2911 VSS.t994 VDD VSS.t993 VSS.t992 sg13_lv_nmos ad=0.1428p pd=1.52u as=0 ps=0 w=0.42u l=1u
X2912 VSS.t299 VDD VSS.t150 VSS.t298 sg13_lv_nmos ad=0.1428p pd=1.52u as=0 ps=0 w=0.42u l=1u
X2913 VSS.t35 a_12010_15202# sg13cmos5l_dfrbpq_1_2.CLK VSS.t34 sg13_lv_nmos ad=0.1406p pd=1.12u as=0.1406p ps=1.12u w=0.74u l=0.13u
X2914 VSS.t1902 VDD VSS.t1901 VSS.t1900 sg13_lv_nmos ad=0.1428p pd=1.52u as=0 ps=0 w=0.42u l=1u
X2915 VDD VSS.t858 VDD VDD sg13_lv_pmos ad=0.34p pd=2.68u as=0 ps=0 w=1u l=1u
X2916 VDD VSS.t1444 VDD VDD sg13_lv_pmos ad=0.34p pd=2.68u as=0 ps=0 w=1u l=1u
X2917 VSS.t2742 VDD VSS.t2742 VSS.t198 sg13_lv_nmos ad=0.1428p pd=1.52u as=0 ps=0 w=0.42u l=1u
X2918 VDD VSS.t836 VDD VDD sg13_lv_pmos ad=0.19p pd=1.38u as=0 ps=0 w=1u l=1u
X2919 a_11122_15234# sg13cmos5l_tiehi_1.L_HI VSS.t129 VSS.t192 sg13_lv_nmos ad=37.8f pd=0.6u as=79.8f ps=0.8u w=0.42u l=0.13u
X2920 VSS.t2244 VDD VSS.t2243 VSS.t2242 sg13_lv_nmos ad=0.1428p pd=1.52u as=0 ps=0 w=0.42u l=1u
X2921 sg13cmos5l_or3_1_2.C sg13cmos5l_dfrbpq_1_3.Q a_20218_15238# VSS.t18 sg13_lv_nmos ad=0.2516p pd=2.16u as=0.1406p ps=1.12u w=0.74u l=0.13u
X2922 VSS.t1700 VDD VSS.t1702 VSS.t1701 sg13_lv_nmos ad=79.8f pd=0.8u as=0 ps=0 w=0.42u l=1u
X2923 VSS.t1505 VDD VSS.t1507 VSS.t1506 sg13_lv_nmos ad=79.8f pd=0.8u as=0 ps=0 w=0.42u l=1u
X2924 VSS.t2414 VDD VSS.t2416 VSS.t2415 sg13_lv_nmos ad=79.8f pd=0.8u as=0 ps=0 w=0.42u l=1u
X2925 VSS.t2708 VDD VSS.t2707 VSS.t198 sg13_lv_nmos ad=0.1428p pd=1.52u as=0 ps=0 w=0.42u l=1u
X2926 a_16175_15238# sg13cmos5l_inv_1_0.Y VSS.t21 VSS.t3270 sg13_lv_nmos ad=0.2516p pd=2.16u as=0.1898p ps=1.36u w=0.74u l=0.13u
X2927 VSS.t964 VDD VSS.t963 VSS.t962 sg13_lv_nmos ad=0.1428p pd=1.52u as=0 ps=0 w=0.42u l=1u
X2928 VDD VSS.t2934 VDD VDD sg13_lv_pmos ad=0.19p pd=1.38u as=0 ps=0 w=1u l=1u
X2929 VSS.t402 VDD VSS.t401 VSS.t11 sg13_lv_nmos ad=0.1428p pd=1.52u as=0 ps=0 w=0.42u l=1u
X2930 VDD VSS.t921 VDD VDD sg13_lv_pmos ad=0.19p pd=1.38u as=0 ps=0 w=1u l=1u
X2931 VSS.t869 VDD VSS.t871 VSS.t870 sg13_lv_nmos ad=79.8f pd=0.8u as=0 ps=0 w=0.42u l=1u
X2932 VDD VSS.t2396 VDD VDD sg13_lv_pmos ad=0.19p pd=1.38u as=0 ps=0 w=1u l=1u
X2933 VSS.t2057 VDD VSS.t2056 VSS.t2055 sg13_lv_nmos ad=0.1428p pd=1.52u as=0 ps=0 w=0.42u l=1u
X2934 VDD VSS.t2054 VDD VDD sg13_lv_pmos ad=0.19p pd=1.38u as=0 ps=0 w=1u l=1u
X2935 VSS.t385 VDD VSS.t387 VSS.t386 sg13_lv_nmos ad=79.8f pd=0.8u as=0 ps=0 w=0.42u l=1u
X2936 VSS.t1872 VDD VSS.t1874 VSS.t1873 sg13_lv_nmos ad=79.8f pd=0.8u as=0 ps=0 w=0.42u l=1u
X2937 VSS.t703 a_21251_13690# sg13cmos5l_or3_1_2.X VSS.t3188 sg13_lv_nmos ad=0.13395p pd=1.12u as=0.2516p ps=2.16u w=0.74u l=0.13u
X2938 VDD VSS.t437 VDD VDD sg13_lv_pmos ad=0.34p pd=2.68u as=0 ps=0 w=1u l=1u
X2939 VDD VSS.t528 VDD VDD sg13_lv_pmos ad=0.19p pd=1.38u as=0 ps=0 w=1u l=1u
X2940 VDD a_4175_15311# a_4842_15532# VDD sg13_lv_pmos ad=0.2128p pd=1.5u as=0.3864p ps=2.93u w=1.12u l=0.13u
X2941 VDD a_10222_14751# sg13cmos5l_dlygate4sd3_1_8.X VDD sg13_lv_pmos ad=0.2254p pd=1.53u as=0.4256p ps=3u w=1.12u l=0.13u
X2942 VDD VSS.t1270 VDD VDD sg13_lv_pmos ad=0.34p pd=2.68u as=0 ps=0 w=1u l=1u
X2943 VDD VSS.t1502 VDD VDD sg13_lv_pmos ad=0.19p pd=1.38u as=0 ps=0 w=1u l=1u
X2944 VSS.t1024 VDD VSS.t1026 VSS.t1025 sg13_lv_nmos ad=79.8f pd=0.8u as=0 ps=0 w=0.42u l=1u
X2945 VSS.t30 a_12010_15202# sg13cmos5l_dfrbpq_1_2.CLK VSS.t29 sg13_lv_nmos ad=0.1406p pd=1.12u as=0.1406p ps=1.12u w=0.74u l=0.13u
X2946 VSS.t2655 VDD VSS.t2656 VSS.t198 sg13_lv_nmos ad=79.8f pd=0.8u as=0 ps=0 w=0.42u l=1u
X2947 VDD VSS.t620 VDD VDD sg13_lv_pmos ad=0.34p pd=2.68u as=0 ps=0 w=1u l=1u
X2948 VDD VSS.t1637 VDD VDD sg13_lv_pmos ad=0.19p pd=1.38u as=0 ps=0 w=1u l=1u
X2949 sg13cmos5l_dfrbpq_1_5.Q a_28074_14020# VDD VDD sg13_lv_pmos ad=0.3808p pd=2.92u as=0.2128p ps=1.5u w=1.12u l=0.13u
X2950 VDD VSS.t1692 VDD VDD sg13_lv_pmos ad=0.19p pd=1.38u as=0 ps=0 w=1u l=1u
X2951 VDD VSS.t2974 VDD VDD sg13_lv_pmos ad=0.19p pd=1.38u as=0 ps=0 w=1u l=1u
X2952 VDD VSS.t3151 VDD VDD sg13_lv_pmos ad=0.34p pd=2.68u as=0 ps=0 w=1u l=1u
X2953 VDD VSS.t1849 VDD VDD sg13_lv_pmos ad=0.19p pd=1.38u as=0 ps=0 w=1u l=1u
X2954 VSS.t2434 VDD VSS.t2436 VSS.t2435 sg13_lv_nmos ad=79.8f pd=0.8u as=0 ps=0 w=0.42u l=1u
X2955 VDD VSS.t2762 VDD VDD sg13_lv_pmos ad=0.19p pd=1.38u as=0 ps=0 w=1u l=1u
X2956 VSS.t2092 VDD VSS.t2091 VSS.t2090 sg13_lv_nmos ad=0.1428p pd=1.52u as=0 ps=0 w=0.42u l=1u
X2957 VDD VSS.t891 VDD VDD sg13_lv_pmos ad=0.19p pd=1.38u as=0 ps=0 w=1u l=1u
X2958 VSS.t1655 VDD VSS.t1654 VSS.t1653 sg13_lv_nmos ad=0.1428p pd=1.52u as=0 ps=0 w=0.42u l=1u
X2959 VDD VSS.t2381 VDD VDD sg13_lv_pmos ad=0.19p pd=1.38u as=0 ps=0 w=1u l=1u
X2960 VDD VSS.t3 VDD VDD sg13_lv_pmos ad=0.19p pd=1.38u as=0 ps=0 w=1u l=1u
X2961 VDD VSS.t72 VDD VDD sg13_lv_pmos ad=0.34p pd=2.68u as=0 ps=0 w=1u l=1u
X2962 VSS.t620 VDD VSS.t623 VSS.t751 sg13_lv_nmos ad=79.8f pd=0.8u as=0 ps=0 w=0.42u l=1u
X2963 VDD VSS.t2006 VDD VDD sg13_lv_pmos ad=0.34p pd=2.68u as=0 ps=0 w=1u l=1u
X2964 VSS.t994 VDD VSS.t993 VSS.t992 sg13_lv_nmos ad=0.1428p pd=1.52u as=0 ps=0 w=0.42u l=1u
X2965 VDD VSS.t828 VDD VDD sg13_lv_pmos ad=0.34p pd=2.68u as=0 ps=0 w=1u l=1u
X2966 VDD VSS.t3124 VDD VDD sg13_lv_pmos ad=0.19p pd=1.38u as=0 ps=0 w=1u l=1u
X2967 VSS.t2399 VDD VSS.t2401 VSS.t2400 sg13_lv_nmos ad=79.8f pd=0.8u as=0 ps=0 w=0.42u l=1u
X2968 VDD VSS.t565 VDD VDD sg13_lv_pmos ad=0.34p pd=2.68u as=0 ps=0 w=1u l=1u
X2969 VDD VSS.t121 VDD VDD sg13_lv_pmos ad=0.19p pd=1.38u as=0 ps=0 w=1u l=1u
X2970 VDD VSS.t766 VDD VDD sg13_lv_pmos ad=0.19p pd=1.38u as=0 ps=0 w=1u l=1u
X2971 VSS.t1565 VDD VSS.t1567 VSS.t1566 sg13_lv_nmos ad=79.8f pd=0.8u as=0 ps=0 w=0.42u l=1u
X2972 sg13cmos5l_buf_8_2.X a_19323_13726# VDD VDD sg13_lv_pmos ad=0.2128p pd=1.5u as=0.2128p ps=1.5u w=1.12u l=0.13u
X2973 VSS.t1887 VDD VSS.t1886 VSS.t1885 sg13_lv_nmos ad=0.1428p pd=1.52u as=0 ps=0 w=0.42u l=1u
X2974 VDD VSS.t370 VDD VDD sg13_lv_pmos ad=0.19p pd=1.38u as=0 ps=0 w=1u l=1u
X2975 VSS.t1195 VDD VSS.t1194 VSS.t1154 sg13_lv_nmos ad=0.1428p pd=1.52u as=0 ps=0 w=0.42u l=1u
X2976 VDD VSS.t1841 VDD VDD sg13_lv_pmos ad=0.34p pd=2.68u as=0 ps=0 w=1u l=1u
X2977 sg13cmos5l_dlygate4sd3_1_0.A a_6540_13238# VDD VDD sg13_lv_pmos ad=0.2408p pd=1.55u as=0.3808p ps=2.92u w=1.12u l=0.13u
X2978 VDD VSS.t283 VDD VDD sg13_lv_pmos ad=0.19p pd=1.38u as=0 ps=0 w=1u l=1u
X2979 a_8685_14832# sg13cmos5l_buf_1_10.X VDD VDD sg13_lv_pmos ad=0.1596p pd=1.22u as=0.2856p ps=2.36u w=0.84u l=0.13u
X2980 a_21060_14488# a_21579_14495# a_22319_14845# VSS.t4 sg13_lv_nmos ad=0.3473p pd=2.71u as=0.12665p ps=1.145u w=0.74u l=0.13u
X2981 VDD VSS.t1288 VDD VDD sg13_lv_pmos ad=0.34p pd=2.68u as=0 ps=0 w=1u l=1u
X2982 VSS.t2229 VDD VSS.t2228 VSS.t2227 sg13_lv_nmos ad=0.1428p pd=1.52u as=0 ps=0 w=0.42u l=1u
X2983 VSS.t617 VDD VSS.t614 VSS.t616 sg13_lv_nmos ad=0.1428p pd=1.52u as=0 ps=0 w=0.42u l=1u
X2984 VDD VSS.t1644 VDD VDD sg13_lv_pmos ad=0.34p pd=2.68u as=0 ps=0 w=1u l=1u
X2985 VSS.t1685 VDD VSS.t1687 VSS.t1686 sg13_lv_nmos ad=79.8f pd=0.8u as=0 ps=0 w=0.42u l=1u
X2986 VSS.t2628 VDD VSS.t2629 VSS.t198 sg13_lv_nmos ad=79.8f pd=0.8u as=0 ps=0 w=0.42u l=1u
X2987 VSS.t2699 VDD VSS.t2697 VSS.t198 sg13_lv_nmos ad=0.1428p pd=1.52u as=0 ps=0 w=0.42u l=1u
X2988 VSS.t869 VDD VSS.t871 VSS.t870 sg13_lv_nmos ad=79.8f pd=0.8u as=0 ps=0 w=0.42u l=1u
X2989 VSS.t3012 VDD VSS.t3014 VSS.t3013 sg13_lv_nmos ad=79.8f pd=0.8u as=0 ps=0 w=0.42u l=1u
X2990 VDD VSS.t2919 VDD VDD sg13_lv_pmos ad=0.19p pd=1.38u as=0 ps=0 w=1u l=1u
X2991 a_21166_16263# a_21281_16262# VDD VDD sg13_lv_pmos ad=0.34p pd=2.68u as=0.2254p ps=1.53u w=1u l=0.5u
X2992 VDD a_5687_15315# a_5687_15549# VDD sg13_lv_pmos ad=2.8961p pd=18.25u as=0.2442p ps=2.06u w=0.66u l=0.13u
X2993 VDD VSS.t2333 VDD VDD sg13_lv_pmos ad=0.34p pd=2.68u as=0 ps=0 w=1u l=1u
X2994 VDD VSS.t1991 VDD VDD sg13_lv_pmos ad=0.34p pd=2.68u as=0 ps=0 w=1u l=1u
X2995 VDD a_22508_15960# counter_value_o[4] VDD sg13_lv_pmos ad=0.2114p pd=1.54u as=0.42p ps=2.99u w=1.12u l=0.13u
X2996 VDD VSS.t593 VDD VDD sg13_lv_pmos ad=0.19p pd=1.38u as=0 ps=0 w=1u l=1u
X2997 VSS.t521 VDD VSS.t523 VSS.t522 sg13_lv_nmos ad=79.8f pd=0.8u as=0 ps=0 w=0.42u l=1u
X2998 VDD VSS.t528 VDD VDD sg13_lv_pmos ad=0.19p pd=1.38u as=0 ps=0 w=1u l=1u
X2999 VDD VSS.t1319 VDD VDD sg13_lv_pmos ad=0.19p pd=1.38u as=0 ps=0 w=1u l=1u
X3000 VDD VSS.t1214 VDD VDD sg13_lv_pmos ad=0.19p pd=1.38u as=0 ps=0 w=1u l=1u
X3001 VSS.t1179 VDD VSS.t1178 VSS.t1154 sg13_lv_nmos ad=0.1428p pd=1.52u as=0 ps=0 w=0.42u l=1u
X3002 VDD VSS.t3109 VDD VDD sg13_lv_pmos ad=0.19p pd=1.38u as=0 ps=0 w=1u l=1u
X3003 VDD VSS.t2684 VDD VDD sg13_lv_pmos ad=0.19p pd=1.38u as=0 ps=0 w=1u l=1u
X3004 VDD VSS.t1909 VDD VDD sg13_lv_pmos ad=0.19p pd=1.38u as=0 ps=0 w=1u l=1u
X3005 VSS.t2354 VDD VSS.t2353 VSS.t2352 sg13_lv_nmos ad=0.1428p pd=1.52u as=0 ps=0 w=0.42u l=1u
X3006 a_27664_13942# sg13cmos5l_dfrbpq_1_5.RESET_B VDD VDD sg13_lv_pmos ad=79.8f pd=0.8u as=2.42015p ps=15.68u w=0.42u l=0.13u
X3007 VSS.t1172 VDD VSS.t1173 VSS.t1154 sg13_lv_nmos ad=79.8f pd=0.8u as=0 ps=0 w=0.42u l=1u
X3008 sg13cmos5l_nand4_1_0.Y sg13cmos5l_xor2_1_0.B VDD VDD sg13_lv_pmos ad=0.2128p pd=1.5u as=0.3808p ps=2.92u w=1.12u l=0.13u
X3009 VSS.t432 VDD VSS.t433 VSS.t11 sg13_lv_nmos ad=79.8f pd=0.8u as=0 ps=0 w=0.42u l=1u
X3010 VDD VSS.t425 VDD VDD sg13_lv_pmos ad=0.34p pd=2.68u as=0 ps=0 w=1u l=1u
X3011 a_15782_13722# a_16587_13844# a_16042_13945# VDD sg13_lv_pmos ad=0.1428p pd=1.52u as=79.8f ps=0.8u w=0.42u l=0.13u
X3012 VSS.t2745 VDD VSS.t2744 VSS.t198 sg13_lv_nmos ad=0.1428p pd=1.52u as=0 ps=0 w=0.42u l=1u
X3013 VDD VSS.t2034 VDD VDD sg13_lv_pmos ad=0.19p pd=1.38u as=0 ps=0 w=1u l=1u
X3014 VDD VSS.t3136 VDD VDD sg13_lv_pmos ad=0.34p pd=2.68u as=0 ps=0 w=1u l=1u
X3015 VDD VSS.t279 VDD VDD sg13_lv_pmos ad=0.19p pd=1.38u as=0 ps=0 w=1u l=1u
X3016 VDD VSS.t1677 VDD VDD sg13_lv_pmos ad=0.19p pd=1.38u as=0 ps=0 w=1u l=1u
X3017 VSS.t2419 VDD VSS.t2421 VSS.t2420 sg13_lv_nmos ad=79.8f pd=0.8u as=0 ps=0 w=0.42u l=1u
X3018 a_10222_14751# a_10337_14750# VDD VDD sg13_lv_pmos ad=0.34p pd=2.68u as=0.2254p ps=1.53u w=1u l=0.5u
X3019 VDD VSS.t1717 VDD VDD sg13_lv_pmos ad=0.19p pd=1.38u as=0 ps=0 w=1u l=1u
X3020 VSS.t1917 VDD VSS.t1919 VSS.t1918 sg13_lv_nmos ad=79.8f pd=0.8u as=0 ps=0 w=0.42u l=1u
X3021 VDD VSS.t2939 VDD VDD sg13_lv_pmos ad=0.19p pd=1.38u as=0 ps=0 w=1u l=1u
X3022 VDD VSS.t1547 VDD VDD sg13_lv_pmos ad=0.19p pd=1.38u as=0 ps=0 w=1u l=1u
X3023 VDD a_26565_13701# a_26667_13844# VDD sg13_lv_pmos ad=2.42015p pd=15.68u as=0.3864p ps=2.93u w=1.12u l=0.13u
X3024 VDD VSS.t72 VDD VDD sg13_lv_pmos ad=0.34p pd=2.68u as=0 ps=0 w=1u l=1u
X3025 VSS.t11 a_21477_14495# a_21579_14495# VSS.t3283 sg13_lv_nmos ad=4.11262p pd=27.15u as=0.2516p ps=2.16u w=0.74u l=0.13u
X3026 VDD VSS.t322 VDD VDD sg13_lv_pmos ad=0.34p pd=2.68u as=0 ps=0 w=1u l=1u
X3027 VSS.t1271 VDD VSS.t1270 VSS.t1154 sg13_lv_nmos ad=0.1428p pd=1.52u as=0 ps=0 w=0.42u l=1u
X3028 VDD VSS.t1310 VDD VDD sg13_lv_pmos ad=0.19p pd=1.38u as=0 ps=0 w=1u l=1u
X3029 VSS.t2635 VDD VSS.t2635 VSS.t198 sg13_lv_nmos ad=0.1428p pd=1.52u as=0 ps=0 w=0.42u l=1u
X3030 VDD VSS.t576 VDD VDD sg13_lv_pmos ad=0.34p pd=2.68u as=0 ps=0 w=1u l=1u
X3031 VDD VSS.t2679 VDD VDD sg13_lv_pmos ad=0.19p pd=1.38u as=0 ps=0 w=1u l=1u
X3032 VDD VSS.t2361 VDD VDD sg13_lv_pmos ad=0.19p pd=1.38u as=0 ps=0 w=1u l=1u
X3033 VSS.t414 VDD VSS.t413 VSS.t11 sg13_lv_nmos ad=0.1428p pd=1.52u as=0 ps=0 w=0.42u l=1u
X3034 a_4474_14448# sg13cmos5l_dlygate4sd3_1_3.A VSS.t11 VSS.t3234 sg13_lv_nmos ad=0.1428p pd=1.52u as=79.8f ps=0.8u w=0.42u l=0.13u
X3035 VSS.t227 VDD VSS.t366 VSS.t365 sg13_lv_nmos ad=79.8f pd=0.8u as=0 ps=0 w=0.42u l=1u
X3036 VSS.t583 VDD VSS.t586 VSS.t585 sg13_lv_nmos ad=79.8f pd=0.8u as=0 ps=0 w=0.42u l=1u
X3037 VSS.t2657 VDD VSS.t2658 VSS.t198 sg13_lv_nmos ad=79.8f pd=0.8u as=0 ps=0 w=0.42u l=1u
X3038 VSS.t2690 VDD VSS.t2691 VSS.t198 sg13_lv_nmos ad=79.8f pd=0.8u as=0 ps=0 w=0.42u l=1u
X3039 VSS.t1307 VDD VSS.t1308 VSS.t1154 sg13_lv_nmos ad=79.8f pd=0.8u as=0 ps=0 w=0.42u l=1u
X3040 VDD VSS.t1697 VDD VDD sg13_lv_pmos ad=0.19p pd=1.38u as=0 ps=0 w=1u l=1u
X3041 VDD VSS.t2979 VDD VDD sg13_lv_pmos ad=0.19p pd=1.38u as=0 ps=0 w=1u l=1u
X3042 VDD VSS.t1854 VDD VDD sg13_lv_pmos ad=0.19p pd=1.38u as=0 ps=0 w=1u l=1u
X3043 VSS.t1857 VDD VSS.t1856 VSS.t1855 sg13_lv_nmos ad=0.1428p pd=1.52u as=0 ps=0 w=0.42u l=1u
X3044 VSS.t286 VDD VSS.t286 VSS.t288 sg13_lv_nmos ad=0.1428p pd=1.52u as=0 ps=0 w=0.42u l=1u
X3045 VDD VSS.t35 VDD VDD sg13_lv_pmos ad=0.19p pd=1.38u as=0 ps=0 w=1u l=1u
X3046 VDD VSS.t98 VDD VDD sg13_lv_pmos ad=0.34p pd=2.68u as=0 ps=0 w=1u l=1u
X3047 VDD VSS.t2691 VDD VDD sg13_lv_pmos ad=0.34p pd=2.68u as=0 ps=0 w=1u l=1u
X3048 a_27215_14845# a_26373_14495# a_25956_14488# VDD sg13_lv_pmos ad=0.2048p pd=1.63u as=0.34p ps=2.68u w=1u l=0.13u
X3049 VSS.t2997 VDD VSS.t2999 VSS.t2998 sg13_lv_nmos ad=79.8f pd=0.8u as=0 ps=0 w=0.42u l=1u
X3050 VDD VSS.t2765 VDD VDD sg13_lv_pmos ad=0.19p pd=1.38u as=0 ps=0 w=1u l=1u
X3051 VSS.t2062 VDD VSS.t2061 VSS.t2060 sg13_lv_nmos ad=0.1428p pd=1.52u as=0 ps=0 w=0.42u l=1u
X3052 VSS.t583 VDD VSS.t583 VSS.t709 sg13_lv_nmos ad=79.8f pd=0.8u as=0 ps=0 w=0.42u l=1u
X3053 VDD VSS.t409 VDD VDD sg13_lv_pmos ad=0.19p pd=1.38u as=0 ps=0 w=1u l=1u
X3054 VDD VSS.t1028 VDD VDD sg13_lv_pmos ad=0.34p pd=2.68u as=0 ps=0 w=1u l=1u
X3055 VDD VSS.t620 VDD VDD sg13_lv_pmos ad=0.19p pd=1.38u as=0 ps=0 w=1u l=1u
X3056 VSS.t1316 VDD VSS.t1317 VSS.t1154 sg13_lv_nmos ad=79.8f pd=0.8u as=0 ps=0 w=0.42u l=1u
X3057 VSS.t2404 VDD VSS.t2406 VSS.t2405 sg13_lv_nmos ad=79.8f pd=0.8u as=0 ps=0 w=0.42u l=1u
X3058 VDD VSS.t1492 VDD VDD sg13_lv_pmos ad=0.19p pd=1.38u as=0 ps=0 w=1u l=1u
X3059 VDD VSS.t2951 VDD VDD sg13_lv_pmos ad=0.34p pd=2.68u as=0 ps=0 w=1u l=1u
X3060 VDD VSS.t596 VDD VDD sg13_lv_pmos ad=0.34p pd=2.68u as=0 ps=0 w=1u l=1u
X3061 VSS.t1570 VDD VSS.t1572 VSS.t1571 sg13_lv_nmos ad=79.8f pd=0.8u as=0 ps=0 w=0.42u l=1u
X3062 VDD VSS.t2071 VDD VDD sg13_lv_pmos ad=0.34p pd=2.68u as=0 ps=0 w=1u l=1u
X3063 VSS.t834 VDD VSS.t836 VSS.t835 sg13_lv_nmos ad=79.8f pd=0.8u as=0 ps=0 w=0.42u l=1u
X3064 VSS.t1892 VDD VSS.t1891 VSS.t1890 sg13_lv_nmos ad=0.1428p pd=1.52u as=0 ps=0 w=0.42u l=1u
X3065 a_4078_14751# a_4193_14750# VSS.t37 VSS.t90 sg13_lv_nmos ad=0.1428p pd=1.52u as=0.1426p ps=1.16u w=0.42u l=0.5u
X3066 VSS.t2737 VDD VSS.t2737 VSS.t198 sg13_lv_nmos ad=0.1428p pd=1.52u as=0 ps=0 w=0.42u l=1u
X3067 VDD VSS.t2652 VDD VDD sg13_lv_pmos ad=0.19p pd=1.38u as=0 ps=0 w=1u l=1u
X3068 a_21286_14909# sg13cmos5l_dfrbpq_1_6.RESET_B VSS.t172 VSS.t215 sg13_lv_nmos ad=37.8f pd=0.6u as=0.1701p ps=1.65u w=0.42u l=0.13u
X3069 VDD VSS.t1232 VDD VDD sg13_lv_pmos ad=0.19p pd=1.38u as=0 ps=0 w=1u l=1u
X3070 VDD VSS.t2019 VDD VDD sg13_lv_pmos ad=0.19p pd=1.38u as=0 ps=0 w=1u l=1u
X3071 VSS.t2434 VDD VSS.t2433 VSS.t2432 sg13_lv_nmos ad=0.1428p pd=1.52u as=0 ps=0 w=0.42u l=1u
X3072 VDD VSS.t1971 VDD VDD sg13_lv_pmos ad=0.34p pd=2.68u as=0 ps=0 w=1u l=1u
X3073 VSS.t1690 VDD VSS.t1692 VSS.t1691 sg13_lv_nmos ad=79.8f pd=0.8u as=0 ps=0 w=0.42u l=1u
X3074 VDD VSS.t1702 VDD VDD sg13_lv_pmos ad=0.19p pd=1.38u as=0 ps=0 w=1u l=1u
X3075 VSS.t2082 VDD VSS.t2081 VSS.t2080 sg13_lv_nmos ad=0.1428p pd=1.52u as=0 ps=0 w=0.42u l=1u
X3076 VSS.t1902 VDD VSS.t1904 VSS.t1903 sg13_lv_nmos ad=79.8f pd=0.8u as=0 ps=0 w=0.42u l=1u
X3077 a_16955_14484# sg13cmos5l_a21oi_1_0.A2 VDD VDD sg13_lv_pmos ad=0.3808p pd=2.92u as=0.2128p ps=1.5u w=1.12u l=0.13u
X3078 VDD VSS.t2924 VDD VDD sg13_lv_pmos ad=0.19p pd=1.38u as=0 ps=0 w=1u l=1u
X3079 VSS.t2982 VDD VSS.t2984 VSS.t2983 sg13_lv_nmos ad=79.8f pd=0.8u as=0 ps=0 w=0.42u l=1u
X3080 VDD VSS.t1654 VDD VDD sg13_lv_pmos ad=0.34p pd=2.68u as=0 ps=0 w=1u l=1u
X3081 VSS.t2499 VDD VSS.t2501 VSS.t2500 sg13_lv_nmos ad=79.8f pd=0.8u as=0 ps=0 w=0.42u l=1u
X3082 a_2942_14484# sg13cmos5l_xor2_1_0.B a_2490_14447# VDD sg13_lv_pmos ad=0.1225p pd=1.245u as=0.34p ps=2.68u w=1u l=0.13u
X3083 VSS.t21 a_15579_14854# sg13cmos5l_buf_8_2.A VSS.t3250 sg13_lv_nmos ad=0.2516p pd=2.16u as=0.1406p ps=1.12u w=0.74u l=0.13u
X3084 VDD VSS.t803 VDD VDD sg13_lv_pmos ad=0.34p pd=2.68u as=0 ps=0 w=1u l=1u
X3085 VDD VSS.t1532 VDD VDD sg13_lv_pmos ad=0.19p pd=1.38u as=0 ps=0 w=1u l=1u
X3086 VDD VSS.t1709 VDD VDD sg13_lv_pmos ad=0.34p pd=2.68u as=0 ps=0 w=1u l=1u
X3087 VDD VSS.t599 VDD VDD sg13_lv_pmos ad=0.34p pd=2.68u as=0 ps=0 w=1u l=1u
X3088 a_5613_14832# sg13cmos5l_buf_1_10.X VDD VDD sg13_lv_pmos ad=0.1596p pd=1.22u as=0.2856p ps=2.36u w=0.84u l=0.13u
X3089 VSS.t1298 VDD VSS.t1297 VSS.t1154 sg13_lv_nmos ad=0.1428p pd=1.52u as=0 ps=0 w=0.42u l=1u
X3090 VDD VSS.t2338 VDD VDD sg13_lv_pmos ad=0.34p pd=2.68u as=0 ps=0 w=1u l=1u
X3091 a_18665_15180# a_18789_15277# VDD VDD sg13_lv_pmos ad=0.2442p pd=2.06u as=2.8961p ps=18.25u w=0.66u l=0.13u
X3092 VDD sg13cmos5l_buf_1_0.X sg13cmos5l_xnor2_1_2.B VDD sg13_lv_pmos ad=0.3808p pd=2.92u as=0.2128p ps=1.5u w=1.12u l=0.13u
X3093 VSS.t119 VDD VSS.t121 VSS.t389 sg13_lv_nmos ad=79.8f pd=0.8u as=0 ps=0 w=0.42u l=1u
X3094 VDD VSS.t635 VDD VDD sg13_lv_pmos ad=0.34p pd=2.68u as=0 ps=0 w=1u l=1u
X3095 VSS.t1420 VDD VSS.t1292 VSS.t1154 sg13_lv_nmos ad=79.8f pd=0.8u as=0 ps=0 w=0.42u l=1u
X3096 VDD VSS.t1914 VDD VDD sg13_lv_pmos ad=0.19p pd=1.38u as=0 ps=0 w=1u l=1u
X3097 VSS.t319 VDD VSS.t318 VSS.t317 sg13_lv_nmos ad=0.1428p pd=1.52u as=0 ps=0 w=0.42u l=1u
X3098 a_5886_15486# a_5687_15549# VSS.t11 VSS.t3169 sg13_lv_nmos ad=0.27427p pd=2.28u as=4.11262p ps=27.15u w=0.795u l=0.13u
X3099 VDD VSS.t442 VDD VDD sg13_lv_pmos ad=0.19p pd=1.38u as=0 ps=0 w=1u l=1u
X3100 VDD VSS.t856 VDD VDD sg13_lv_pmos ad=0.19p pd=1.38u as=0 ps=0 w=1u l=1u
X3101 VDD VSS.t2233 VDD VDD sg13_lv_pmos ad=0.34p pd=2.68u as=0 ps=0 w=1u l=1u
X3102 VSS.t2747 VDD VSS.t2747 VSS.t198 sg13_lv_nmos ad=0.1428p pd=1.52u as=0 ps=0 w=0.42u l=1u
X3103 VSS.t172 a_21070_15423# sg13cmos5l_dlygate4sd3_1_9.X VSS.t217 sg13_lv_nmos ad=0.1426p pd=1.16u as=0.2516p ps=2.16u w=0.74u l=0.13u
X3104 VDD VSS.t1274 VDD VDD sg13_lv_pmos ad=0.19p pd=1.38u as=0 ps=0 w=1u l=1u
X3105 VDD VSS.t1223 VDD VDD sg13_lv_pmos ad=0.19p pd=1.38u as=0 ps=0 w=1u l=1u
X3106 VDD VSS.t2723 VDD VDD sg13_lv_pmos ad=0.19p pd=1.38u as=0 ps=0 w=1u l=1u
X3107 VDD VSS.t2039 VDD VDD sg13_lv_pmos ad=0.19p pd=1.38u as=0 ps=0 w=1u l=1u
X3108 VDD VSS.t3141 VDD VDD sg13_lv_pmos ad=0.34p pd=2.68u as=0 ps=0 w=1u l=1u
X3109 VSS.t2419 VDD VSS.t2418 VSS.t2417 sg13_lv_nmos ad=0.1428p pd=1.52u as=0 ps=0 w=0.42u l=1u
X3110 VSS.t1842 VDD VSS.t1841 VSS.t1840 sg13_lv_nmos ad=0.1428p pd=1.52u as=0 ps=0 w=0.42u l=1u
X3111 VDD a_7822_13911# sg13cmos5l_xnor2_1_2.A VDD sg13_lv_pmos ad=0.2254p pd=1.53u as=0.4256p ps=3u w=1.12u l=0.13u
X3112 VSS.t573 VDD VSS.t135 VSS.t694 sg13_lv_nmos ad=79.8f pd=0.8u as=0 ps=0 w=0.42u l=1u
X3113 VSS.t599 VDD VSS.t602 VSS.t737 sg13_lv_nmos ad=79.8f pd=0.8u as=0 ps=0 w=0.42u l=1u
X3114 VDD VSS.t1682 VDD VDD sg13_lv_pmos ad=0.19p pd=1.38u as=0 ps=0 w=1u l=1u
X3115 VSS.t2693 VDD VSS.t2691 VSS.t198 sg13_lv_nmos ad=0.1428p pd=1.52u as=0 ps=0 w=0.42u l=1u
X3116 VSS.t142 sg13cmos5l_or3_1_2.X a_20705_15260# VSS.t18 sg13_lv_nmos ad=0.2516p pd=2.16u as=0.1406p ps=1.12u w=0.74u l=0.13u
X3117 VDD VSS.t1687 VDD VDD sg13_lv_pmos ad=0.19p pd=1.38u as=0 ps=0 w=1u l=1u
X3118 VSS.t889 VDD VSS.t891 VSS.t890 sg13_lv_nmos ad=79.8f pd=0.8u as=0 ps=0 w=0.42u l=1u
X3119 VSS.t1645 VDD VSS.t1644 VSS.t1643 sg13_lv_nmos ad=0.1428p pd=1.52u as=0 ps=0 w=0.42u l=1u
X3120 VSS.t3162 VDD VSS.t3161 VSS.t3160 sg13_lv_nmos ad=0.1428p pd=1.52u as=0 ps=0 w=0.42u l=1u
X3121 VSS.t2484 VDD VSS.t2486 VSS.t2485 sg13_lv_nmos ad=79.8f pd=0.8u as=0 ps=0 w=0.42u l=1u
X3122 VDD VSS.t2371 VDD VDD sg13_lv_pmos ad=0.19p pd=1.38u as=0 ps=0 w=1u l=1u
X3123 a_22508_15960# sg13cmos5l_dfrbpq_1_3.Q VSS.t101 VSS.t100 sg13_lv_nmos ad=0.187p pd=1.78u as=0.14875p ps=1.16u w=0.55u l=0.13u
X3124 a_7631_14845# a_6789_14495# a_7537_14845# VSS.t62 sg13_lv_nmos ad=0.12665p pd=1.145u as=0.1428p ps=1.52u w=0.42u l=0.13u
X3125 VSS.t829 VDD VSS.t828 VSS.t827 sg13_lv_nmos ad=0.1428p pd=1.52u as=0 ps=0 w=0.42u l=1u
X3126 VSS.t2786 VDD VSS.t2637 VSS.t198 sg13_lv_nmos ad=0.1428p pd=1.52u as=0 ps=0 w=0.42u l=1u
X3127 VSS.t764 VDD VSS.t766 VSS.t765 sg13_lv_nmos ad=79.8f pd=0.8u as=0 ps=0 w=0.42u l=1u
X3128 VSS.t2730 VDD VSS.t2731 VSS.t198 sg13_lv_nmos ad=79.8f pd=0.8u as=0 ps=0 w=0.42u l=1u
X3129 VDD VSS.t2682 VDD VDD sg13_lv_pmos ad=0.19p pd=1.38u as=0 ps=0 w=1u l=1u
X3130 VSS.t2389 VDD VSS.t2391 VSS.t2390 sg13_lv_nmos ad=79.8f pd=0.8u as=0 ps=0 w=0.42u l=1u
X3131 VSS.t1952 VDD VSS.t1951 VSS.t1950 sg13_lv_nmos ad=0.1428p pd=1.52u as=0 ps=0 w=0.42u l=1u
X3132 VDD VSS.t1477 VDD VDD sg13_lv_pmos ad=0.19p pd=1.38u as=0 ps=0 w=1u l=1u
X3133 VDD VSS.t2936 VDD VDD sg13_lv_pmos ad=0.34p pd=2.68u as=0 ps=0 w=1u l=1u
X3134 VDD VSS.t623 VDD VDD sg13_lv_pmos ad=0.34p pd=2.68u as=0 ps=0 w=1u l=1u
X3135 VSS.t834 VDD VSS.t836 VSS.t835 sg13_lv_nmos ad=79.8f pd=0.8u as=0 ps=0 w=0.42u l=1u
X3136 VSS.t1232 VDD VSS.t1231 VSS.t1154 sg13_lv_nmos ad=0.1428p pd=1.52u as=0 ps=0 w=0.42u l=1u
X3137 a_21562_15960# sg13cmos5l_a21oi_1_1.Y VDD VDD sg13_lv_pmos ad=0.1428p pd=1.52u as=0.1523p ps=1.38u w=0.42u l=0.13u
X3138 VSS.t1555 VDD VSS.t1557 VSS.t1556 sg13_lv_nmos ad=79.8f pd=0.8u as=0 ps=0 w=0.42u l=1u
X3139 VDD VSS.t2056 VDD VDD sg13_lv_pmos ad=0.34p pd=2.68u as=0 ps=0 w=1u l=1u
X3140 VSS.t155 sg13cmos5l_or3_1_1.X a_25025_16344# VSS.t154 sg13_lv_nmos ad=0.2516p pd=2.16u as=0.1406p ps=1.12u w=0.74u l=0.13u
X3141 VDD VSS.t355 VDD VDD sg13_lv_pmos ad=0.19p pd=1.38u as=0 ps=0 w=1u l=1u
X3142 a_17604_14488# a_18123_14495# a_18863_14845# VSS.t9 sg13_lv_nmos ad=0.3473p pd=2.71u as=0.12665p ps=1.145u w=0.74u l=0.13u
X3143 VDD VSS.t2426 VDD VDD sg13_lv_pmos ad=0.19p pd=1.38u as=0 ps=0 w=1u l=1u
X3144 VDD VSS.t1859 VDD VDD sg13_lv_pmos ad=0.19p pd=1.38u as=0 ps=0 w=1u l=1u
X3145 VSS.t1237 VDD VSS.t1236 VSS.t1154 sg13_lv_nmos ad=0.1428p pd=1.52u as=0 ps=0 w=0.42u l=1u
X3146 VDD VSS.t1667 VDD VDD sg13_lv_pmos ad=0.19p pd=1.38u as=0 ps=0 w=1u l=1u
X3147 VSS.t2032 VDD VSS.t2034 VSS.t2033 sg13_lv_nmos ad=79.8f pd=0.8u as=0 ps=0 w=0.42u l=1u
X3148 VSS.t859 VDD VSS.t858 VSS.t857 sg13_lv_nmos ad=0.1428p pd=1.52u as=0 ps=0 w=0.42u l=1u
X3149 VDD VSS.t1956 VDD VDD sg13_lv_pmos ad=0.34p pd=2.68u as=0 ps=0 w=1u l=1u
X3150 VSS.t1159 VDD VSS.t1158 VSS.t1154 sg13_lv_nmos ad=0.1428p pd=1.52u as=0 ps=0 w=0.42u l=1u
X3151 VSS.t1353 VDD VSS.t1199 VSS.t1154 sg13_lv_nmos ad=79.8f pd=0.8u as=0 ps=0 w=0.42u l=1u
X3152 VSS.t2067 VDD VSS.t2066 VSS.t2065 sg13_lv_nmos ad=0.1428p pd=1.52u as=0 ps=0 w=0.42u l=1u
X3153 VSS.t3147 VDD VSS.t3146 VSS.t3145 sg13_lv_nmos ad=0.1428p pd=1.52u as=0 ps=0 w=0.42u l=1u
X3154 VDD VSS.t1036 VDD VDD sg13_lv_pmos ad=0.19p pd=1.38u as=0 ps=0 w=1u l=1u
X3155 sg13cmos5l_buf_1_10.X a_1192_9948# VDD VDD sg13_lv_pmos ad=0.42p pd=2.99u as=0.2114p ps=1.54u w=1.12u l=0.13u
X3156 VSS.t620 VDD VSS.t620 VSS.t621 sg13_lv_nmos ad=79.8f pd=0.8u as=0 ps=0 w=0.42u l=1u
X3157 VSS.t632 VDD VSS.t635 VSS.t759 sg13_lv_nmos ad=79.8f pd=0.8u as=0 ps=0 w=0.42u l=1u
X3158 VDD VSS.t1639 VDD VDD sg13_lv_pmos ad=0.34p pd=2.68u as=0 ps=0 w=1u l=1u
X3159 VSS.t1164 VDD VSS.t1162 VSS.t1154 sg13_lv_nmos ad=0.1428p pd=1.52u as=0 ps=0 w=0.42u l=1u
X3160 VDD VSS.t1694 VDD VDD sg13_lv_pmos ad=0.34p pd=2.68u as=0 ps=0 w=1u l=1u
X3161 VSS.t1545 VDD VSS.t1547 VSS.t1546 sg13_lv_nmos ad=79.8f pd=0.8u as=0 ps=0 w=0.42u l=1u
X3162 VSS.t2439 VDD VSS.t2438 VSS.t2437 sg13_lv_nmos ad=0.1428p pd=1.52u as=0 ps=0 w=0.42u l=1u
X3163 a_27417_14607# a_26475_14495# a_27215_14845# VDD sg13_lv_pmos ad=93.45f pd=0.865u as=0.2048p ps=1.63u w=0.42u l=0.13u
X3164 VDD VSS.t688 VDD VDD sg13_lv_pmos ad=0.34p pd=2.68u as=0 ps=0 w=1u l=1u
X3165 VSS.t919 VDD VSS.t921 VSS.t920 sg13_lv_nmos ad=79.8f pd=0.8u as=0 ps=0 w=0.42u l=1u
X3166 VDD VSS.t2323 VDD VDD sg13_lv_pmos ad=0.34p pd=2.68u as=0 ps=0 w=1u l=1u
X3167 VSS.t685 VDD VSS.t684 VSS.t683 sg13_lv_nmos ad=0.1428p pd=1.52u as=0 ps=0 w=0.42u l=1u
X3168 VDD VSS.t786 VDD VDD sg13_lv_pmos ad=0.19p pd=1.38u as=0 ps=0 w=1u l=1u
X3169 VDD VSS.t1497 VDD VDD sg13_lv_pmos ad=0.19p pd=1.38u as=0 ps=0 w=1u l=1u
X3170 VSS.t2620 VDD VSS.t2621 VSS.t198 sg13_lv_nmos ad=79.8f pd=0.8u as=0 ps=0 w=0.42u l=1u
X3171 VSS.t286 VDD VSS.t286 VSS.t287 sg13_lv_nmos ad=79.8f pd=0.8u as=0 ps=0 w=0.42u l=1u
X3172 VSS.t1540 VDD VSS.t1542 VSS.t1541 sg13_lv_nmos ad=79.8f pd=0.8u as=0 ps=0 w=0.42u l=1u
X3173 VDD VSS.t2076 VDD VDD sg13_lv_pmos ad=0.34p pd=2.68u as=0 ps=0 w=1u l=1u
X3174 VSS.t1897 VDD VSS.t1896 VSS.t1895 sg13_lv_nmos ad=0.1428p pd=1.52u as=0 ps=0 w=0.42u l=1u
X3175 VDD a_12010_15202# sg13cmos5l_dfrbpq_1_2.CLK VDD sg13_lv_pmos ad=0.2128p pd=1.5u as=0.2128p ps=1.5u w=1.12u l=0.13u
X3176 VDD VSS.t1300 VDD VDD sg13_lv_pmos ad=0.34p pd=2.68u as=0 ps=0 w=1u l=1u
X3177 VSS.t1181 VDD VSS.t1181 VSS.t1154 sg13_lv_nmos ad=0.1428p pd=1.52u as=0 ps=0 w=0.42u l=1u
X3178 VSS.t2740 VDD VSS.t2739 VSS.t198 sg13_lv_nmos ad=0.1428p pd=1.52u as=0 ps=0 w=0.42u l=1u
X3179 VDD VSS.t2621 VDD VDD sg13_lv_pmos ad=0.34p pd=2.68u as=0 ps=0 w=1u l=1u
X3180 VSS.t72 VDD VSS.t72 VSS.t514 sg13_lv_nmos ad=79.8f pd=0.8u as=0 ps=0 w=0.42u l=1u
X3181 VDD VSS.t1214 VDD VDD sg13_lv_pmos ad=0.19p pd=1.38u as=0 ps=0 w=1u l=1u
X3182 VDD VSS.t2714 VDD VDD sg13_lv_pmos ad=0.19p pd=1.38u as=0 ps=0 w=1u l=1u
X3183 VSS.t2404 VDD VSS.t2403 VSS.t2402 sg13_lv_nmos ad=0.1428p pd=1.52u as=0 ps=0 w=0.42u l=1u
X3184 VSS.t889 VDD VSS.t891 VSS.t890 sg13_lv_nmos ad=79.8f pd=0.8u as=0 ps=0 w=0.42u l=1u
X3185 VSS.t1250 VDD VSS.t1249 VSS.t1154 sg13_lv_nmos ad=0.1428p pd=1.52u as=0 ps=0 w=0.42u l=1u
X3186 VSS.t441 VDD VSS.t440 VSS.t11 sg13_lv_nmos ad=0.1428p pd=1.52u as=0 ps=0 w=0.42u l=1u
X3187 VSS.t1695 VDD VSS.t1697 VSS.t1696 sg13_lv_nmos ad=79.8f pd=0.8u as=0 ps=0 w=0.42u l=1u
X3188 VDD sg13cmos5l_dfrbpq_1_3.Q sg13cmos5l_or3_1_2.C VDD sg13_lv_pmos ad=0.3808p pd=2.92u as=0.2128p ps=1.5u w=1.12u l=0.13u
X3189 VDD sg13cmos5l_inv_1_0.Y a_16314_15532# VDD sg13_lv_pmos ad=0.2891p pd=1.695u as=0.1428p ps=1.375u w=1.12u l=0.13u
X3190 VDD VSS.t1003 VDD VDD sg13_lv_pmos ad=0.34p pd=2.68u as=0 ps=0 w=1u l=1u
X3191 VSS.t2469 VDD VSS.t2471 VSS.t2470 sg13_lv_nmos ad=79.8f pd=0.8u as=0 ps=0 w=0.42u l=1u
X3192 VSS.t829 VDD VSS.t828 VSS.t827 sg13_lv_nmos ad=0.1428p pd=1.52u as=0 ps=0 w=0.42u l=1u
X3193 VDD VSS.t1537 VDD VDD sg13_lv_pmos ad=0.19p pd=1.38u as=0 ps=0 w=1u l=1u
X3194 VSS.t2738 VDD VSS.t2738 VSS.t198 sg13_lv_nmos ad=0.1428p pd=1.52u as=0 ps=0 w=0.42u l=1u
X3195 VDD VSS.t1871 VDD VDD sg13_lv_pmos ad=0.34p pd=2.68u as=0 ps=0 w=1u l=1u
X3196 a_24841_13726# sg13cmos5l_or3_1_1.B VSS.t67 VSS.t3185 sg13_lv_nmos ad=0.198p pd=1.27u as=0.1045p ps=0.93u w=0.55u l=0.13u
X3197 VSS.t764 VDD VSS.t766 VSS.t765 sg13_lv_nmos ad=79.8f pd=0.8u as=0 ps=0 w=0.42u l=1u
X3198 VDD VSS.t1226 VDD VDD sg13_lv_pmos ad=0.19p pd=1.38u as=0 ps=0 w=1u l=1u
X3199 VSS.t1190 VDD VSS.t1189 VSS.t1154 sg13_lv_nmos ad=0.1428p pd=1.52u as=0 ps=0 w=0.42u l=1u
X3200 sg13cmos5l_or3_1_1.C sg13cmos5l_dfrbpq_1_6.Q VDD VDD sg13_lv_pmos ad=0.2128p pd=1.5u as=0.2128p ps=1.5u w=1.12u l=0.13u
X3201 a_23378_15242# sg13cmos5l_dfrbpq_1_2.Q VSS.t3226 VSS.t64 sg13_lv_nmos ad=0.1406p pd=1.12u as=0.2886p ps=2.26u w=0.74u l=0.13u
X3202 VDD a_19120_14726# a_19065_14607# VDD sg13_lv_pmos ad=2.42015p pd=15.68u as=93.45f ps=0.865u w=0.42u l=0.13u
X3203 VDD VSS.t941 VDD VDD sg13_lv_pmos ad=0.19p pd=1.38u as=0 ps=0 w=1u l=1u
X3204 VSS.t2779 VDD VSS.t2630 VSS.t198 sg13_lv_nmos ad=0.1428p pd=1.52u as=0 ps=0 w=0.42u l=1u
X3205 VDD VSS.t2674 VDD VDD sg13_lv_pmos ad=0.19p pd=1.38u as=0 ps=0 w=1u l=1u
X3206 VDD sg13cmos5l_dfrbpq_1_0.RESET_B a_2630_15234# VDD sg13_lv_pmos ad=0.36237p pd=2.605u as=79.8f ps=0.8u w=0.42u l=0.13u
X3207 VSS.t3017 VDD VSS.t3016 VSS.t3015 sg13_lv_nmos ad=0.1428p pd=1.52u as=0 ps=0 w=0.42u l=1u
X3208 VDD VSS.t437 VDD VDD sg13_lv_pmos ad=0.34p pd=2.68u as=0 ps=0 w=1u l=1u
X3209 VSS.t1490 VDD VSS.t1492 VSS.t1491 sg13_lv_nmos ad=79.8f pd=0.8u as=0 ps=0 w=0.42u l=1u
X3210 VDD VSS.t340 VDD VDD sg13_lv_pmos ad=0.34p pd=2.68u as=0 ps=0 w=1u l=1u
X3211 VSS.t1720 VDD VSS.t1719 VSS.t1718 sg13_lv_nmos ad=0.1428p pd=1.52u as=0 ps=0 w=0.42u l=1u
X3212 VDD VSS.t1502 VDD VDD sg13_lv_pmos ad=0.19p pd=1.38u as=0 ps=0 w=1u l=1u
X3213 VDD VSS.t2411 VDD VDD sg13_lv_pmos ad=0.19p pd=1.38u as=0 ps=0 w=1u l=1u
X3214 VSS.t1882 VDD VSS.t1881 VSS.t1880 sg13_lv_nmos ad=0.1428p pd=1.52u as=0 ps=0 w=0.42u l=1u
X3215 VSS.t576 VDD VSS.t576 VSS.t700 sg13_lv_nmos ad=0.1428p pd=1.52u as=0 ps=0 w=0.42u l=1u
X3216 VDD VSS.t1226 VDD VDD sg13_lv_pmos ad=0.19p pd=1.38u as=0 ps=0 w=1u l=1u
X3217 VDD VSS.t2726 VDD VDD sg13_lv_pmos ad=0.19p pd=1.38u as=0 ps=0 w=1u l=1u
X3218 VDD VSS.t2009 VDD VDD sg13_lv_pmos ad=0.19p pd=1.38u as=0 ps=0 w=1u l=1u
X3219 VDD a_12010_15202# sg13cmos5l_dfrbpq_1_2.CLK VDD sg13_lv_pmos ad=0.2128p pd=1.5u as=0.2128p ps=1.5u w=1.12u l=0.13u
X3220 VSS.t859 VDD VSS.t858 VSS.t857 sg13_lv_nmos ad=0.1428p pd=1.52u as=0 ps=0 w=0.42u l=1u
X3221 VSS.t1399 VDD VSS.t1262 VSS.t1154 sg13_lv_nmos ad=0.1428p pd=1.52u as=0 ps=0 w=0.42u l=1u
X3222 VDD VSS.t2363 VDD VDD sg13_lv_pmos ad=0.34p pd=2.68u as=0 ps=0 w=1u l=1u
X3223 VSS.t2424 VDD VSS.t2423 VSS.t2422 sg13_lv_nmos ad=0.1428p pd=1.52u as=0 ps=0 w=0.42u l=1u
X3224 VSS.t588 VDD VSS.t590 VSS.t589 sg13_lv_nmos ad=79.8f pd=0.8u as=0 ps=0 w=0.42u l=1u
X3225 VDD VSS.t1509 VDD VDD sg13_lv_pmos ad=0.34p pd=2.68u as=0 ps=0 w=1u l=1u
X3226 VDD VSS.t3111 VDD VDD sg13_lv_pmos ad=0.34p pd=2.68u as=0 ps=0 w=1u l=1u
X3227 VDD VSS.t1844 VDD VDD sg13_lv_pmos ad=0.19p pd=1.38u as=0 ps=0 w=1u l=1u
X3228 VSS.t346 VDD VSS.t16 VSS.t347 sg13_lv_nmos ad=79.8f pd=0.8u as=0 ps=0 w=0.42u l=1u
X3229 VDD VSS.t1692 VDD VDD sg13_lv_pmos ad=0.19p pd=1.38u as=0 ps=0 w=1u l=1u
X3230 VSS.t1972 VDD VSS.t1971 VSS.t1970 sg13_lv_nmos ad=0.1428p pd=1.52u as=0 ps=0 w=0.42u l=1u
X3231 a_21060_14488# a_21034_14452# VSS.t142 VSS.t173 sg13_lv_nmos ad=0.2516p pd=2.16u as=0.1626p ps=1.415u w=0.74u l=0.13u
X3232 sg13cmos5l_buf_8_2.A a_15579_14854# VDD VDD sg13_lv_pmos ad=0.2128p pd=1.5u as=0.2128p ps=1.5u w=1.12u l=0.13u
X3233 sg13cmos5l_dfrbpq_1_2.CLK a_12010_15202# VSS.t25 VSS.t24 sg13_lv_nmos ad=0.1406p pd=1.12u as=0.2516p ps=2.16u w=0.74u l=0.13u
X3234 VSS.t1029 VDD VSS.t1028 VSS.t1027 sg13_lv_nmos ad=0.1428p pd=1.52u as=0 ps=0 w=0.42u l=1u
X3235 VDD VSS.t2376 VDD VDD sg13_lv_pmos ad=0.19p pd=1.38u as=0 ps=0 w=1u l=1u
X3236 VSS.t919 VDD VSS.t921 VSS.t920 sg13_lv_nmos ad=79.8f pd=0.8u as=0 ps=0 w=0.42u l=1u
X3237 VDD VSS.t1207 VDD VDD sg13_lv_pmos ad=0.34p pd=2.68u as=0 ps=0 w=1u l=1u
X3238 VDD VSS.t538 VDD VDD sg13_lv_pmos ad=0.19p pd=1.38u as=0 ps=0 w=1u l=1u
X3239 VDD VSS.t893 VDD VDD sg13_lv_pmos ad=0.34p pd=2.68u as=0 ps=0 w=1u l=1u
X3240 a_6682_13690# sg13cmos5l_dlygate4sd3_1_0.A VSS.t44 VSS.t43 sg13_lv_nmos ad=0.1428p pd=1.52u as=79.8f ps=0.8u w=0.42u l=0.13u
X3241 VSS.t1530 VDD VSS.t1532 VSS.t1531 sg13_lv_nmos ad=79.8f pd=0.8u as=0 ps=0 w=0.42u l=1u
X3242 VSS.t1710 VDD VSS.t1709 VSS.t1708 sg13_lv_nmos ad=0.1428p pd=1.52u as=0 ps=0 w=0.42u l=1u
X3243 VSS.t2640 VDD VSS.t2639 VSS.t198 sg13_lv_nmos ad=0.1428p pd=1.52u as=0 ps=0 w=0.42u l=1u
X3244 VSS.t2732 VDD VSS.t2733 VSS.t198 sg13_lv_nmos ad=79.8f pd=0.8u as=0 ps=0 w=0.42u l=1u
X3245 VDD VSS.t2685 VDD VDD sg13_lv_pmos ad=0.19p pd=1.38u as=0 ps=0 w=1u l=1u
X3246 VSS.t1922 VDD VSS.t1921 VSS.t1920 sg13_lv_nmos ad=0.1428p pd=1.52u as=0 ps=0 w=0.42u l=1u
X3247 VSS.t426 VDD VSS.t425 VSS.t11 sg13_lv_nmos ad=0.1428p pd=1.52u as=0 ps=0 w=0.42u l=1u
X3248 VDD VSS.t1482 VDD VDD sg13_lv_pmos ad=0.19p pd=1.38u as=0 ps=0 w=1u l=1u
X3249 VDD VSS.t2941 VDD VDD sg13_lv_pmos ad=0.34p pd=2.68u as=0 ps=0 w=1u l=1u
X3250 VDD VSS.t227 VDD VDD sg13_lv_pmos ad=0.34p pd=2.68u as=0 ps=0 w=1u l=1u
X3251 VDD VSS.t412 VDD VDD sg13_lv_pmos ad=0.19p pd=1.38u as=0 ps=0 w=1u l=1u
X3252 VDD VSS.t1245 VDD VDD sg13_lv_pmos ad=0.19p pd=1.38u as=0 ps=0 w=1u l=1u
X3253 VSS.t1319 VDD VSS.t1320 VSS.t1154 sg13_lv_nmos ad=79.8f pd=0.8u as=0 ps=0 w=0.42u l=1u
X3254 VSS.t1705 VDD VSS.t1704 VSS.t1703 sg13_lv_nmos ad=0.1428p pd=1.52u as=0 ps=0 w=0.42u l=1u
X3255 VDD VSS.t2431 VDD VDD sg13_lv_pmos ad=0.19p pd=1.38u as=0 ps=0 w=1u l=1u
X3256 VSS.t2454 VDD VSS.t2456 VSS.t2455 sg13_lv_nmos ad=79.8f pd=0.8u as=0 ps=0 w=0.42u l=1u
X3257 VDD VSS.t768 VDD VDD sg13_lv_pmos ad=0.34p pd=2.68u as=0 ps=0 w=1u l=1u
X3258 VSS.t724 VDD VSS.t726 VSS.t725 sg13_lv_nmos ad=79.8f pd=0.8u as=0 ps=0 w=0.42u l=1u
X3259 VDD VSS.t1311 VDD VDD sg13_lv_pmos ad=0.34p pd=2.68u as=0 ps=0 w=1u l=1u
X3260 VDD VSS.t2954 VDD VDD sg13_lv_pmos ad=0.19p pd=1.38u as=0 ps=0 w=1u l=1u
X3261 VSS.t2037 VDD VSS.t2039 VSS.t2038 sg13_lv_nmos ad=79.8f pd=0.8u as=0 ps=0 w=0.42u l=1u
X3262 VDD VSS.t1961 VDD VDD sg13_lv_pmos ad=0.34p pd=2.68u as=0 ps=0 w=1u l=1u
X3263 VSS.t147 a_27664_13942# a_27313_13799# VSS.t182 sg13_lv_nmos ad=79.8f pd=0.8u as=0.1428p ps=1.52u w=0.42u l=0.13u
X3264 VSS.t1680 VDD VSS.t1682 VSS.t1681 sg13_lv_nmos ad=79.8f pd=0.8u as=0 ps=0 w=0.42u l=1u
X3265 VSS.t25 VDD VSS.t458 VSS.t457 sg13_lv_nmos ad=0.1428p pd=1.52u as=0 ps=0 w=0.42u l=1u
X3266 VDD VSS.t262 VDD VDD sg13_lv_pmos ad=0.34p pd=2.68u as=0 ps=0 w=1u l=1u
X3267 VDD VSS.t1185 VDD VDD sg13_lv_pmos ad=0.19p pd=1.38u as=0 ps=0 w=1u l=1u
X3268 VSS.t2660 VDD VSS.t2659 VSS.t198 sg13_lv_nmos ad=0.1428p pd=1.52u as=0 ps=0 w=0.42u l=1u
X3269 VDD VSS.t421 VDD VDD sg13_lv_pmos ad=0.19p pd=1.38u as=0 ps=0 w=1u l=1u
X3270 sg13cmos5l_buf_8_2.A a_15579_14854# VDD VDD sg13_lv_pmos ad=0.2128p pd=1.5u as=0.2128p ps=1.5u w=1.12u l=0.13u
X3271 a_6714_12972# sg13cmos5l_xnor2_1_2.B sg13cmos5l_dlygate4sd3_1_0.A VDD sg13_lv_pmos ad=0.1428p pd=1.375u as=0.2408p ps=1.55u w=1.12u l=0.13u
X3272 VDD VSS.t1644 VDD VDD sg13_lv_pmos ad=0.34p pd=2.68u as=0 ps=0 w=1u l=1u
X3273 a_25094_15238# a_24824_15238# VDD VDD sg13_lv_pmos ad=0.34p pd=2.68u as=0.1523p ps=1.38u w=1u l=0.5u
X3274 VDD VSS.t1254 VDD VDD sg13_lv_pmos ad=0.19p pd=1.38u as=0 ps=0 w=1u l=1u
X3275 VDD VSS.t1699 VDD VDD sg13_lv_pmos ad=0.34p pd=2.68u as=0 ps=0 w=1u l=1u
X3276 VSS.t1550 VDD VSS.t1552 VSS.t1551 sg13_lv_nmos ad=79.8f pd=0.8u as=0 ps=0 w=0.42u l=1u
X3277 VSS.t3067 VDD VSS.t3069 VSS.t3068 sg13_lv_nmos ad=79.8f pd=0.8u as=0 ps=0 w=0.42u l=1u
X3278 VSS.t2284 VDD VSS.t2286 VSS.t2285 sg13_lv_nmos ad=79.8f pd=0.8u as=0 ps=0 w=0.42u l=1u
X3279 VDD VSS.t1856 VDD VDD sg13_lv_pmos ad=0.34p pd=2.68u as=0 ps=0 w=1u l=1u
X3280 a_6575_13342# sg13cmos5l_xnor2_1_2.A VSS.t44 VSS.t99 sg13_lv_nmos ad=0.2516p pd=2.16u as=0.1898p ps=1.36u w=0.74u l=0.13u
X3281 a_26244_14909# a_26475_14495# a_25930_14452# VSS.t122 sg13_lv_nmos ad=0.2373p pd=1.97u as=79.8f ps=0.8u w=0.42u l=0.13u
X3282 VDD VSS.t2766 VDD VDD sg13_lv_pmos ad=0.34p pd=2.68u as=0 ps=0 w=1u l=1u
X3283 VSS.t854 VDD VSS.t856 VSS.t855 sg13_lv_nmos ad=79.8f pd=0.8u as=0 ps=0 w=0.42u l=1u
X3284 a_25670_14922# sg13cmos5l_dfrbpq_1_7.D VDD VDD sg13_lv_pmos ad=79.8f pd=0.8u as=0.1428p ps=1.52u w=0.42u l=0.13u
X3285 VSS.t1301 VDD VSS.t1300 VSS.t1154 sg13_lv_nmos ad=0.1428p pd=1.52u as=0 ps=0 w=0.42u l=1u
X3286 VDD VSS.t2388 VDD VDD sg13_lv_pmos ad=0.34p pd=2.68u as=0 ps=0 w=1u l=1u
X3287 VDD VSS.t129 VDD VDD sg13_lv_pmos ad=0.34p pd=2.68u as=0 ps=0 w=1u l=1u
X3288 VDD VSS.t578 VDD VDD sg13_lv_pmos ad=0.34p pd=2.68u as=0 ps=0 w=1u l=1u
X3289 VDD VSS.t923 VDD VDD sg13_lv_pmos ad=0.34p pd=2.68u as=0 ps=0 w=1u l=1u
X3290 VDD VSS.t2624 VDD VDD sg13_lv_pmos ad=0.34p pd=2.68u as=0 ps=0 w=1u l=1u
X3291 VSS.t1867 VDD VSS.t1866 VSS.t1865 sg13_lv_nmos ad=0.1428p pd=1.52u as=0 ps=0 w=0.42u l=1u
X3292 VDD VSS.t1217 VDD VDD sg13_lv_pmos ad=0.19p pd=1.38u as=0 ps=0 w=1u l=1u
X3293 VDD VSS.t2717 VDD VDD sg13_lv_pmos ad=0.19p pd=1.38u as=0 ps=0 w=1u l=1u
X3294 VDD VSS.t1994 VDD VDD sg13_lv_pmos ad=0.19p pd=1.38u as=0 ps=0 w=1u l=1u
X3295 a_24169_14508# sg13cmos5l_or3_1_2.B VSS.t65 VSS.t4 sg13_lv_nmos ad=0.198p pd=1.27u as=0.1045p ps=0.93u w=0.55u l=0.13u
X3296 VSS.t67 VDD VSS.t67 VSS.t715 sg13_lv_nmos ad=0.1428p pd=1.52u as=0 ps=0 w=0.42u l=1u
X3297 VSS.t2409 VDD VSS.t2408 VSS.t2407 sg13_lv_nmos ad=0.1428p pd=1.52u as=0 ps=0 w=0.42u l=1u
X3298 VDD VSS.t861 VDD VDD sg13_lv_pmos ad=0.19p pd=1.38u as=0 ps=0 w=1u l=1u
X3299 VDD VSS.t1494 VDD VDD sg13_lv_pmos ad=0.34p pd=2.68u as=0 ps=0 w=1u l=1u
X3300 VDD VSS.t2348 VDD VDD sg13_lv_pmos ad=0.34p pd=2.68u as=0 ps=0 w=1u l=1u
X3301 VDD VSS.t530 VDD VDD sg13_lv_pmos ad=0.34p pd=2.68u as=0 ps=0 w=1u l=1u
X3302 VSS.t1665 VDD VSS.t1667 VSS.t1666 sg13_lv_nmos ad=79.8f pd=0.8u as=0 ps=0 w=0.42u l=1u
X3303 VSS.t1575 VDD VSS.t1574 VSS.t1573 sg13_lv_nmos ad=0.1428p pd=1.52u as=0 ps=0 w=0.42u l=1u
X3304 a_18106_15960# sg13cmos5l_dlygate4sd3_1_5.A VSS.t83 VSS.t82 sg13_lv_nmos ad=0.1428p pd=1.52u as=79.8f ps=0.8u w=0.42u l=0.13u
X3305 VDD VSS.t503 VDD VDD sg13_lv_pmos ad=0.19p pd=1.38u as=0 ps=0 w=1u l=1u
X3306 a_6996_13320# sg13cmos5l_xnor2_1_2.B a_6540_13238# VSS.t3193 sg13_lv_nmos ad=78.39999f pd=0.885u as=0.2176p ps=1.96u w=0.64u l=0.13u
X3307 VDD VSS.t823 VDD VDD sg13_lv_pmos ad=0.34p pd=2.68u as=0 ps=0 w=1u l=1u
X3308 VSS.t1029 VDD VSS.t1028 VSS.t1027 sg13_lv_nmos ad=0.1428p pd=1.52u as=0 ps=0 w=0.42u l=1u
X3309 VDD VSS.t1677 VDD VDD sg13_lv_pmos ad=0.19p pd=1.38u as=0 ps=0 w=1u l=1u
X3310 VDD VSS.t611 VDD VDD sg13_lv_pmos ad=0.34p pd=2.68u as=0 ps=0 w=1u l=1u
X3311 VSS.t602 VDD VSS.t605 VSS.t739 sg13_lv_nmos ad=79.8f pd=0.8u as=0 ps=0 w=0.42u l=1u
X3312 sg13cmos5l_buf_1_0.X a_1192_3900# VSS.t199 VSS.t198 sg13_lv_nmos ad=0.2886p pd=2.26u as=0.14875p ps=1.16u w=0.74u l=0.13u
X3313 VSS.t2474 VDD VSS.t2476 VSS.t2475 sg13_lv_nmos ad=79.8f pd=0.8u as=0 ps=0 w=0.42u l=1u
X3314 VDD VSS.t3001 VDD VDD sg13_lv_pmos ad=0.34p pd=2.68u as=0 ps=0 w=1u l=1u
X3315 VDD VSS.t1876 VDD VDD sg13_lv_pmos ad=0.34p pd=2.68u as=0 ps=0 w=1u l=1u
X3316 VDD VSS.t538 VDD VDD sg13_lv_pmos ad=0.19p pd=1.38u as=0 ps=0 w=1u l=1u
X3317 VDD VSS.t2049 VDD VDD sg13_lv_pmos ad=0.19p pd=1.38u as=0 ps=0 w=1u l=1u
X3318 VSS.t1695 VDD VSS.t1694 VSS.t1693 sg13_lv_nmos ad=0.1428p pd=1.52u as=0 ps=0 w=0.42u l=1u
X3319 VDD VSS.t1547 VDD VDD sg13_lv_pmos ad=0.19p pd=1.38u as=0 ps=0 w=1u l=1u
X3320 VSS.t2633 VDD VSS.t2632 VSS.t198 sg13_lv_nmos ad=0.1428p pd=1.52u as=0 ps=0 w=0.42u l=1u
X3321 VDD VSS.t2677 VDD VDD sg13_lv_pmos ad=0.19p pd=1.38u as=0 ps=0 w=1u l=1u
X3322 VSS.t1 a_8582_15238# a_8694_15302# VSS.t106 sg13_lv_nmos ad=0.1426p pd=1.16u as=0.1428p ps=1.52u w=0.42u l=0.5u
X3323 VDD VSS.t876 VDD VDD sg13_lv_pmos ad=0.19p pd=1.38u as=0 ps=0 w=1u l=1u
X3324 VSS.t2987 VDD VSS.t2986 VSS.t2985 sg13_lv_nmos ad=0.1428p pd=1.52u as=0 ps=0 w=0.42u l=1u
X3325 VSS.t1495 VDD VSS.t1497 VSS.t1496 sg13_lv_nmos ad=79.8f pd=0.8u as=0 ps=0 w=0.42u l=1u
X3326 VSS.t611 VDD VSS.t614 VSS.t745 sg13_lv_nmos ad=79.8f pd=0.8u as=0 ps=0 w=0.42u l=1u
X3327 VSS.t769 VDD VSS.t771 VSS.t770 sg13_lv_nmos ad=79.8f pd=0.8u as=0 ps=0 w=0.42u l=1u
X3328 VDD VSS.t2014 VDD VDD sg13_lv_pmos ad=0.19p pd=1.38u as=0 ps=0 w=1u l=1u
X3329 VDD VSS.t813 VDD VDD sg13_lv_pmos ad=0.34p pd=2.68u as=0 ps=0 w=1u l=1u
X3330 VSS.t1235 VDD VSS.t1234 VSS.t1154 sg13_lv_nmos ad=0.1428p pd=1.52u as=0 ps=0 w=0.42u l=1u
X3331 VDD VSS.t626 VDD VDD sg13_lv_pmos ad=0.34p pd=2.68u as=0 ps=0 w=1u l=1u
X3332 VDD VSS.t3116 VDD VDD sg13_lv_pmos ad=0.34p pd=2.68u as=0 ps=0 w=1u l=1u
X3333 VSS.t2631 VDD VSS.t2631 VSS.t198 sg13_lv_nmos ad=0.1428p pd=1.52u as=0 ps=0 w=0.42u l=1u
X3334 a_9158_15234# a_9963_15356# a_9418_15457# VDD sg13_lv_pmos ad=0.1428p pd=1.52u as=79.8f ps=0.8u w=0.42u l=0.13u
X3335 VSS.t11 sg13cmos5l_dfrbpq_1_1.RESET_B a_6180_14922# VSS.t211 sg13_lv_nmos ad=0.1626p pd=1.415u as=60.89999f ps=0.71u w=0.42u l=0.13u
X3336 sg13cmos5l_o21ai_1_2.Y sg13cmos5l_o21ai_1_2.A2 a_23736_14464# VDD sg13_lv_pmos ad=0.2128p pd=1.5u as=0.2128p ps=1.5u w=1.12u l=0.15u
X3337 VDD VSS.t1697 VDD VDD sg13_lv_pmos ad=0.19p pd=1.38u as=0 ps=0 w=1u l=1u
X3338 VDD a_17327_13799# a_17994_14020# VDD sg13_lv_pmos ad=0.2128p pd=1.5u as=0.3864p ps=2.93u w=1.12u l=0.13u
X3339 VSS.t72 VDD VSS.t72 VSS.t514 sg13_lv_nmos ad=79.8f pd=0.8u as=0 ps=0 w=0.42u l=1u
X3340 VDD VSS.t2041 VDD VDD sg13_lv_pmos ad=0.34p pd=2.68u as=0 ps=0 w=1u l=1u
X3341 VSS.t1162 VDD VSS.t1161 VSS.t1154 sg13_lv_nmos ad=0.1428p pd=1.52u as=0 ps=0 w=0.42u l=1u
X3342 VSS.t1192 VDD VSS.t1193 VSS.t1154 sg13_lv_nmos ad=79.8f pd=0.8u as=0 ps=0 w=0.42u l=1u
X3343 a_23858_15242# sg13cmos5l_dfrbpq_1_2.Q VSS.t3207 VSS.t64 sg13_lv_nmos ad=0.1406p pd=1.12u as=0.2516p ps=2.16u w=0.74u l=0.13u
X3344 VSS.t2429 VDD VSS.t2428 VSS.t2427 sg13_lv_nmos ad=0.1428p pd=1.52u as=0 ps=0 w=0.42u l=1u
X3345 VSS.t2269 VDD VSS.t2271 VSS.t2270 sg13_lv_nmos ad=79.8f pd=0.8u as=0 ps=0 w=0.42u l=1u
X3346 VDD VSS.t283 VDD VDD sg13_lv_pmos ad=0.34p pd=2.68u as=0 ps=0 w=1u l=1u
X3347 a_7643_15280# sg13cmos5l_dlygate4sd3_1_8.X VSS.t184 VSS.t3190 sg13_lv_nmos ad=78.39999f pd=0.885u as=0.2272p ps=1.99u w=0.64u l=0.13u
X3348 VSS.t784 VDD VSS.t786 VSS.t785 sg13_lv_nmos ad=79.8f pd=0.8u as=0 ps=0 w=0.42u l=1u
X3349 VSS.t1535 VDD VSS.t1537 VSS.t1536 sg13_lv_nmos ad=79.8f pd=0.8u as=0 ps=0 w=0.42u l=1u
X3350 VSS.t1715 VDD VSS.t1714 VSS.t1713 sg13_lv_nmos ad=0.1428p pd=1.52u as=0 ps=0 w=0.42u l=1u
X3351 VSS.t3052 VDD VSS.t3054 VSS.t3053 sg13_lv_nmos ad=79.8f pd=0.8u as=0 ps=0 w=0.42u l=1u
X3352 VDD VSS.t409 VDD VDD sg13_lv_pmos ad=0.19p pd=1.38u as=0 ps=0 w=1u l=1u
X3353 VDD VSS.t1041 VDD VDD sg13_lv_pmos ad=0.19p pd=1.38u as=0 ps=0 w=1u l=1u
X3354 VSS.t854 VDD VSS.t856 VSS.t855 sg13_lv_nmos ad=79.8f pd=0.8u as=0 ps=0 w=0.42u l=1u
X3355 VDD VSS.t843 VDD VDD sg13_lv_pmos ad=0.34p pd=2.68u as=0 ps=0 w=1u l=1u
X3356 VDD VSS.t2669 VDD VDD sg13_lv_pmos ad=0.19p pd=1.38u as=0 ps=0 w=1u l=1u
X3357 VSS.t1927 VDD VSS.t1926 VSS.t1925 sg13_lv_nmos ad=0.1428p pd=1.52u as=0 ps=0 w=0.42u l=1u
X3358 VSS.t241 a_27898_15202# a_27617_15424# VSS.t11 sg13_lv_nmos ad=79.8f pd=0.8u as=0.1428p ps=1.52u w=0.42u l=0.5u
X3359 VDD VSS.t2946 VDD VDD sg13_lv_pmos ad=0.34p pd=2.68u as=0 ps=0 w=1u l=1u
X3360 VSS.t3007 VDD VSS.t3006 VSS.t3005 sg13_lv_nmos ad=0.1428p pd=1.52u as=0 ps=0 w=0.42u l=1u
X3361 VSS.t21 sg13cmos5l_inv_1_0.A sg13cmos5l_inv_1_0.Y VSS.t40 sg13_lv_nmos ad=0.2516p pd=2.16u as=0.2516p ps=2.16u w=0.74u l=0.13u
X3362 VSS.t3 VDD VSS.t3 VSS.t376 sg13_lv_nmos ad=79.8f pd=0.8u as=0 ps=0 w=0.42u l=1u
X3363 VDD VSS.t573 VDD VDD sg13_lv_pmos ad=0.19p pd=1.38u as=0 ps=0 w=1u l=1u
X3364 VDD VSS.t2373 VDD VDD sg13_lv_pmos ad=0.34p pd=2.68u as=0 ps=0 w=1u l=1u
X3365 VSS.t689 VDD VSS.t688 VSS.t687 sg13_lv_nmos ad=0.1428p pd=1.52u as=0 ps=0 w=0.42u l=1u
X3366 VDD VSS.t1492 VDD VDD sg13_lv_pmos ad=0.19p pd=1.38u as=0 ps=0 w=1u l=1u
X3367 VDD VSS.t2401 VDD VDD sg13_lv_pmos ad=0.19p pd=1.38u as=0 ps=0 w=1u l=1u
X3368 VSS.t2459 VDD VSS.t2461 VSS.t2460 sg13_lv_nmos ad=79.8f pd=0.8u as=0 ps=0 w=0.42u l=1u
X3369 VDD a_17806_15423# sg13cmos5l_inv_1_0.A VDD sg13_lv_pmos ad=0.2254p pd=1.53u as=0.4256p ps=3u w=1.12u l=0.13u
X3370 VSS.t286 VDD VSS.t286 VSS.t289 sg13_lv_nmos ad=79.8f pd=0.8u as=0 ps=0 w=0.42u l=1u
X3371 VSS.t551 VDD VSS.t550 VSS.t549 sg13_lv_nmos ad=0.1428p pd=1.52u as=0 ps=0 w=0.42u l=1u
X3372 a_25956_14488# a_26475_14495# a_27215_14845# VSS.t11 sg13_lv_nmos ad=0.3473p pd=2.71u as=0.12665p ps=1.145u w=0.74u l=0.13u
X3373 VDD VSS.t530 VDD VDD sg13_lv_pmos ad=0.34p pd=2.68u as=0 ps=0 w=1u l=1u
X3374 VDD VSS.t906 VDD VDD sg13_lv_pmos ad=0.19p pd=1.38u as=0 ps=0 w=1u l=1u
X3375 VDD VSS.t1206 VDD VDD sg13_lv_pmos ad=0.19p pd=1.38u as=0 ps=0 w=1u l=1u
X3376 VSS.t1171 VDD VSS.t1170 VSS.t1154 sg13_lv_nmos ad=0.1428p pd=1.52u as=0 ps=0 w=0.42u l=1u
X3377 VSS.t1280 VDD VSS.t1281 VSS.t1154 sg13_lv_nmos ad=79.8f pd=0.8u as=0 ps=0 w=0.42u l=1u
X3378 VDD VSS.t1314 VDD VDD sg13_lv_pmos ad=0.34p pd=2.68u as=0 ps=0 w=1u l=1u
X3379 VSS.t1625 VDD VSS.t1627 VSS.t1626 sg13_lv_nmos ad=79.8f pd=0.8u as=0 ps=0 w=0.42u l=1u
X3380 VSS.t2007 VDD VSS.t2009 VSS.t2008 sg13_lv_nmos ad=79.8f pd=0.8u as=0 ps=0 w=0.42u l=1u
X3381 sg13cmos5l_nand3_1_0.Y sg13cmos5l_dlygate4sd3_1_3.A VDD VDD sg13_lv_pmos ad=0.2128p pd=1.5u as=0.3808p ps=2.92u w=1.12u l=0.13u
X3382 VSS.t1210 VDD VSS.t1211 VSS.t1154 sg13_lv_nmos ad=79.8f pd=0.8u as=0 ps=0 w=0.42u l=1u
X3383 VDD VSS.t1304 VDD VDD sg13_lv_pmos ad=0.19p pd=1.38u as=0 ps=0 w=1u l=1u
X3384 VSS.t1510 VDD VSS.t1509 VSS.t1508 sg13_lv_nmos ad=0.1428p pd=1.52u as=0 ps=0 w=0.42u l=1u
X3385 VDD VSS.t2679 VDD VDD sg13_lv_pmos ad=0.34p pd=2.68u as=0 ps=0 w=1u l=1u
X3386 VDD VSS.t503 VDD VDD sg13_lv_pmos ad=0.19p pd=1.38u as=0 ps=0 w=1u l=1u
X3387 a_15876_13722# sg13cmos5l_dfrbpq_1_2.D a_15782_13722# VSS.t3266 sg13_lv_nmos ad=60.89999f pd=0.71u as=0.1428p ps=1.52u w=0.42u l=0.13u
X3388 VSS.t632 VDD VSS.t632 VSS.t633 sg13_lv_nmos ad=79.8f pd=0.8u as=0 ps=0 w=0.42u l=1u
X3389 VSS.t1335 VDD VSS.t1174 VSS.t1154 sg13_lv_nmos ad=0.1428p pd=1.52u as=0 ps=0 w=0.42u l=1u
X3390 VDD VSS.t2026 VDD VDD sg13_lv_pmos ad=0.34p pd=2.68u as=0 ps=0 w=1u l=1u
X3391 VSS.t939 VDD VSS.t941 VSS.t940 sg13_lv_nmos ad=79.8f pd=0.8u as=0 ps=0 w=0.42u l=1u
X3392 VDD VSS.t1669 VDD VDD sg13_lv_pmos ad=0.34p pd=2.68u as=0 ps=0 w=1u l=1u
X3393 VDD VSS.t1861 VDD VDD sg13_lv_pmos ad=0.34p pd=2.68u as=0 ps=0 w=1u l=1u
X3394 VSS.t11 VDD VSS.t11 VSS.t452 sg13_lv_nmos ad=79.8f pd=0.8u as=0 ps=0 w=0.42u l=1u
X3395 VSS.t3037 VDD VSS.t3039 VSS.t3038 sg13_lv_nmos ad=79.8f pd=0.8u as=0 ps=0 w=0.42u l=1u
X3396 VSS.t2254 VDD VSS.t2256 VSS.t2255 sg13_lv_nmos ad=79.8f pd=0.8u as=0 ps=0 w=0.42u l=1u
X3397 VDD VSS.t1532 VDD VDD sg13_lv_pmos ad=0.19p pd=1.38u as=0 ps=0 w=1u l=1u
X3398 VDD VSS.t1709 VDD VDD sg13_lv_pmos ad=0.34p pd=2.68u as=0 ps=0 w=1u l=1u
X3399 VDD VSS.t2769 VDD VDD sg13_lv_pmos ad=0.34p pd=2.68u as=0 ps=0 w=1u l=1u
X3400 VSS.t2329 VDD VSS.t2331 VSS.t2330 sg13_lv_nmos ad=79.8f pd=0.8u as=0 ps=0 w=0.42u l=1u
X3401 VSS.t769 VDD VSS.t771 VSS.t770 sg13_lv_nmos ad=79.8f pd=0.8u as=0 ps=0 w=0.42u l=1u
X3402 VDD VSS.t2393 VDD VDD sg13_lv_pmos ad=0.34p pd=2.68u as=0 ps=0 w=1u l=1u
X3403 VDD VSS.t2051 VDD VDD sg13_lv_pmos ad=0.34p pd=2.68u as=0 ps=0 w=1u l=1u
X3404 VSS.t1480 VDD VSS.t1482 VSS.t1481 sg13_lv_nmos ad=79.8f pd=0.8u as=0 ps=0 w=0.42u l=1u
X3405 a_9732_15247# a_9444_15552# a_9670_15247# VSS.t92 sg13_lv_nmos ad=0.1428p pd=1.52u as=37.8f ps=0.6u w=0.42u l=0.13u
X3406 sg13cmos5l_buf_8_2.A a_15579_14854# VSS.t21 VSS.t3247 sg13_lv_nmos ad=0.1406p pd=1.12u as=0.1406p ps=1.12u w=0.74u l=0.13u
X3407 VSS.t1262 VDD VSS.t1261 VSS.t1154 sg13_lv_nmos ad=0.1428p pd=1.52u as=0 ps=0 w=0.42u l=1u
X3408 VDD VSS.t1220 VDD VDD sg13_lv_pmos ad=0.19p pd=1.38u as=0 ps=0 w=1u l=1u
X3409 VDD VSS.t2720 VDD VDD sg13_lv_pmos ad=0.19p pd=1.38u as=0 ps=0 w=1u l=1u
X3410 VDD VSS.t1999 VDD VDD sg13_lv_pmos ad=0.19p pd=1.38u as=0 ps=0 w=1u l=1u
X3411 a_17604_14488# a_17578_14452# VSS.t13 VSS.t95 sg13_lv_nmos ad=0.2516p pd=2.16u as=0.1626p ps=1.415u w=0.74u l=0.13u
X3412 VDD VSS.t442 VDD VDD sg13_lv_pmos ad=0.19p pd=1.38u as=0 ps=0 w=1u l=1u
X3413 VSS.t2414 VDD VSS.t2413 VSS.t2412 sg13_lv_nmos ad=0.1428p pd=1.52u as=0 ps=0 w=0.42u l=1u
X3414 VDD VSS.t345 VDD VDD sg13_lv_pmos ad=0.34p pd=2.68u as=0 ps=0 w=1u l=1u
X3415 VDD VSS.t1499 VDD VDD sg13_lv_pmos ad=0.34p pd=2.68u as=0 ps=0 w=1u l=1u
X3416 VSS.t2623 VDD VSS.t2622 VSS.t198 sg13_lv_nmos ad=0.1428p pd=1.52u as=0 ps=0 w=0.42u l=1u
X3417 VDD VSS.t2353 VDD VDD sg13_lv_pmos ad=0.34p pd=2.68u as=0 ps=0 w=1u l=1u
X3418 a_16140_15424# sg13cmos5l_or3_1_2.B VDD VDD sg13_lv_pmos ad=0.1596p pd=1.22u as=0.2891p ps=1.695u w=0.84u l=0.13u
X3419 VDD VSS.t313 VDD VDD sg13_lv_pmos ad=0.34p pd=2.68u as=0 ps=0 w=1u l=1u
X3420 VSS.t614 VDD VSS.t611 VSS.t613 sg13_lv_nmos ad=0.1428p pd=1.52u as=0 ps=0 w=0.42u l=1u
X3421 VSS.t1962 VDD VSS.t1961 VSS.t1960 sg13_lv_nmos ad=0.1428p pd=1.52u as=0 ps=0 w=0.42u l=1u
X3422 a_22319_14845# a_21477_14495# a_22225_14845# VSS.t4 sg13_lv_nmos ad=0.12665p pd=1.145u as=0.1428p ps=1.52u w=0.42u l=0.13u
X3423 VSS.t1266 VDD VSS.t1266 VSS.t1154 sg13_lv_nmos ad=0.1428p pd=1.52u as=0 ps=0 w=0.42u l=1u
X3424 VSS.t1545 VDD VSS.t1544 VSS.t1543 sg13_lv_nmos ad=0.1428p pd=1.52u as=0 ps=0 w=0.42u l=1u
X3425 VDD VSS.t1682 VDD VDD sg13_lv_pmos ad=0.19p pd=1.38u as=0 ps=0 w=1u l=1u
X3426 VSS.t366 VDD VSS.t366 VSS.t367 sg13_lv_nmos ad=0.1428p pd=1.52u as=0 ps=0 w=0.42u l=1u
X3427 a_25774_15423# a_25889_15424# VSS.t42 VSS.t41 sg13_lv_nmos ad=0.1428p pd=1.52u as=0.1426p ps=1.16u w=0.42u l=0.5u
X3428 a_19282_14922# sg13cmos5l_dfrbpq_1_3.RESET_B VSS.t162 VSS.t9 sg13_lv_nmos ad=37.8f pd=0.6u as=79.8f ps=0.8u w=0.42u l=0.13u
X3429 VSS.t588 VDD VSS.t588 VSS.t587 sg13_lv_nmos ad=0.1428p pd=1.52u as=0 ps=0 w=0.42u l=1u
X3430 VSS.t2479 VDD VSS.t2481 VSS.t2480 sg13_lv_nmos ad=79.8f pd=0.8u as=0 ps=0 w=0.42u l=1u
X3431 a_8582_15238# a_8312_15238# VDD VDD sg13_lv_pmos ad=0.34p pd=2.68u as=0.1523p ps=1.38u w=1u l=0.5u
X3432 VSS.t784 VDD VSS.t786 VSS.t785 sg13_lv_nmos ad=79.8f pd=0.8u as=0 ps=0 w=0.42u l=1u
X3433 VSS.t1298 VDD VSS.t1299 VSS.t1154 sg13_lv_nmos ad=79.8f pd=0.8u as=0 ps=0 w=0.42u l=1u
X3434 VDD VSS.t1512 VDD VDD sg13_lv_pmos ad=0.19p pd=1.38u as=0 ps=0 w=1u l=1u
X3435 VDD VSS.t2971 VDD VDD sg13_lv_pmos ad=0.34p pd=2.68u as=0 ps=0 w=1u l=1u
X3436 VDD VSS.t1846 VDD VDD sg13_lv_pmos ad=0.34p pd=2.68u as=0 ps=0 w=1u l=1u
X3437 VDD a_4078_14751# sg13cmos5l_xor2_1_0.B VDD sg13_lv_pmos ad=0.2254p pd=1.53u as=0.4256p ps=3u w=1.12u l=0.13u
X3438 VSS.t1700 VDD VSS.t1699 VSS.t1698 sg13_lv_nmos ad=0.1428p pd=1.52u as=0 ps=0 w=0.42u l=1u
X3439 VSS.t448 VDD VSS.t450 VSS.t449 sg13_lv_nmos ad=79.8f pd=0.8u as=0 ps=0 w=0.42u l=1u
X3440 VDD VSS.t2760 VDD VDD sg13_lv_pmos ad=0.34p pd=2.68u as=0 ps=0 w=1u l=1u
X3441 VDD VSS.t2662 VDD VDD sg13_lv_pmos ad=0.19p pd=1.38u as=0 ps=0 w=1u l=1u
X3442 VSS.t1912 VDD VSS.t1911 VSS.t1910 sg13_lv_nmos ad=0.1428p pd=1.52u as=0 ps=0 w=0.42u l=1u
X3443 VDD VSS.t2931 VDD VDD sg13_lv_pmos ad=0.34p pd=2.68u as=0 ps=0 w=1u l=1u
X3444 VSS.t2992 VDD VSS.t2991 VSS.t2990 sg13_lv_nmos ad=0.1428p pd=1.52u as=0 ps=0 w=0.42u l=1u
X3445 VDD a_18586_15455# sg13cmos5l_dfrbpq_1_3.RESET_B VDD sg13_lv_pmos ad=2.8961p pd=18.25u as=0.3927p ps=2.99u w=1.155u l=0.13u
X3446 VSS.t508 VDD VSS.t508 VSS.t509 sg13_lv_nmos ad=0.1428p pd=1.52u as=0 ps=0 w=0.42u l=1u
X3447 VDD VSS.t898 VDD VDD sg13_lv_pmos ad=0.34p pd=2.68u as=0 ps=0 w=1u l=1u
X3448 sg13cmos5l_o21ai_1_3.Y sg13cmos5l_or3_1_1.A a_24310_15230# VSS.t64 sg13_lv_nmos ad=0.2516p pd=2.16u as=0.1406p ps=1.12u w=0.74u l=0.15u
X3449 VSS.t586 VDD VSS.t583 VSS.t710 sg13_lv_nmos ad=0.1428p pd=1.52u as=0 ps=0 w=0.42u l=1u
X3450 VDD VSS.t1166 VDD VDD sg13_lv_pmos ad=0.19p pd=1.38u as=0 ps=0 w=1u l=1u
X3451 VSS.t429 VDD VSS.t430 VSS.t11 sg13_lv_nmos ad=79.8f pd=0.8u as=0 ps=0 w=0.42u l=1u
X3452 VDD VSS.t821 VDD VDD sg13_lv_pmos ad=0.19p pd=1.38u as=0 ps=0 w=1u l=1u
X3453 VDD VSS.t1013 VDD VDD sg13_lv_pmos ad=0.34p pd=2.68u as=0 ps=0 w=1u l=1u
X3454 VSS.t1409 VDD VSS.t1274 VSS.t1154 sg13_lv_nmos ad=0.1428p pd=1.52u as=0 ps=0 w=0.42u l=1u
X3455 VDD VSS.t1477 VDD VDD sg13_lv_pmos ad=0.19p pd=1.38u as=0 ps=0 w=1u l=1u
X3456 VSS.t2444 VDD VSS.t2446 VSS.t2445 sg13_lv_nmos ad=79.8f pd=0.8u as=0 ps=0 w=0.42u l=1u
X3457 VSS.t269 VDD VSS.t269 VSS.t268 sg13_lv_nmos ad=0.1428p pd=1.52u as=0 ps=0 w=0.42u l=1u
X3458 VDD sg13cmos5l_dfrbpq_1_5.RESET_B a_26122_13945# VDD sg13_lv_pmos ad=0.1563p pd=1.22u as=0.147p ps=1.54u w=0.42u l=0.13u
X3459 VSS.t98 sg13cmos5l_xnor2_1_2.A a_6996_13320# VSS.t97 sg13_lv_nmos ad=0.2272p pd=1.99u as=78.39999f ps=0.885u w=0.64u l=0.13u
X3460 VDD VSS.t2386 VDD VDD sg13_lv_pmos ad=0.19p pd=1.38u as=0 ps=0 w=1u l=1u
X3461 VDD VSS.t2711 VDD VDD sg13_lv_pmos ad=0.19p pd=1.38u as=0 ps=0 w=1u l=1u
X3462 VSS.t2274 VDD VSS.t2276 VSS.t2275 sg13_lv_nmos ad=79.8f pd=0.8u as=0 ps=0 w=0.42u l=1u
X3463 VSS.t2399 VDD VSS.t2398 VSS.t2397 sg13_lv_nmos ad=0.1428p pd=1.52u as=0 ps=0 w=0.42u l=1u
X3464 VSS.t1610 VDD VSS.t1612 VSS.t1611 sg13_lv_nmos ad=79.8f pd=0.8u as=0 ps=0 w=0.42u l=1u
X3465 VSS.t2726 VDD VSS.t2727 VSS.t198 sg13_lv_nmos ad=79.8f pd=0.8u as=0 ps=0 w=0.42u l=1u
X3466 VSS.t67 sg13cmos5l_or3_1_1.C a_24841_13726# VSS.t66 sg13_lv_nmos ad=0.1045p pd=0.93u as=0.187p ps=1.78u w=0.55u l=0.13u
X3467 VDD VSS.t147 VDD VDD sg13_lv_pmos ad=0.34p pd=2.68u as=0 ps=0 w=1u l=1u
X3468 VDD VSS.t773 VDD VDD sg13_lv_pmos ad=0.34p pd=2.68u as=0 ps=0 w=1u l=1u
X3469 VSS.t1565 VDD VSS.t1564 VSS.t1563 sg13_lv_nmos ad=0.1428p pd=1.52u as=0 ps=0 w=0.42u l=1u
X3470 VSS.t1495 VDD VSS.t1494 VSS.t1493 sg13_lv_nmos ad=0.1428p pd=1.52u as=0 ps=0 w=0.42u l=1u
X3471 VDD VSS.t1667 VDD VDD sg13_lv_pmos ad=0.19p pd=1.38u as=0 ps=0 w=1u l=1u
X3472 a_37484_15960# sg13cmos5l_dfrbpq_1_5.Q VDD VDD sg13_lv_pmos ad=0.2856p pd=2.36u as=0.2114p ps=1.54u w=0.84u l=0.13u
X3473 VSS.t939 VDD VSS.t941 VSS.t940 sg13_lv_nmos ad=79.8f pd=0.8u as=0 ps=0 w=0.42u l=1u
X3474 VDD VSS.t1219 VDD VDD sg13_lv_pmos ad=0.34p pd=2.68u as=0 ps=0 w=1u l=1u
X3475 VSS.t1312 VDD VSS.t1313 VSS.t1154 sg13_lv_nmos ad=79.8f pd=0.8u as=0 ps=0 w=0.42u l=1u
X3476 VDD VSS.t558 VDD VDD sg13_lv_pmos ad=0.19p pd=1.38u as=0 ps=0 w=1u l=1u
X3477 VDD VSS.t1226 VDD VDD sg13_lv_pmos ad=0.34p pd=2.68u as=0 ps=0 w=1u l=1u
X3478 VDD VSS.t2727 VDD VDD sg13_lv_pmos ad=0.34p pd=2.68u as=0 ps=0 w=1u l=1u
X3479 VDD VSS.t2011 VDD VDD sg13_lv_pmos ad=0.34p pd=2.68u as=0 ps=0 w=1u l=1u
X3480 VSS.t573 VDD VSS.t573 VSS.t572 sg13_lv_nmos ad=0.1428p pd=1.52u as=0 ps=0 w=0.42u l=1u
X3481 VSS.t111 a_14261_15238# sg13cmos5l_or3_1_1.B VSS.t207 sg13_lv_nmos ad=0.2516p pd=2.16u as=0.1406p ps=1.12u w=0.74u l=0.13u
X3482 VSS.t30 VDD VSS.t30 VSS.t460 sg13_lv_nmos ad=0.1428p pd=1.52u as=0 ps=0 w=0.42u l=1u
X3483 VSS.t2239 VDD VSS.t2241 VSS.t2240 sg13_lv_nmos ad=79.8f pd=0.8u as=0 ps=0 w=0.42u l=1u
X3484 VSS.t1932 VDD VSS.t1931 VSS.t1930 sg13_lv_nmos ad=0.1428p pd=1.52u as=0 ps=0 w=0.42u l=1u
X3485 VDD VSS.t626 VDD VDD sg13_lv_pmos ad=0.19p pd=1.38u as=0 ps=0 w=1u l=1u
X3486 VDD VSS.t1694 VDD VDD sg13_lv_pmos ad=0.34p pd=2.68u as=0 ps=0 w=1u l=1u
X3487 VDD VSS.t1257 VDD VDD sg13_lv_pmos ad=0.19p pd=1.38u as=0 ps=0 w=1u l=1u
X3488 VDD VSS.t2916 VDD VDD sg13_lv_pmos ad=0.34p pd=2.68u as=0 ps=0 w=1u l=1u
X3489 VSS.t2494 VDD VSS.t2493 VSS.t2492 sg13_lv_nmos ad=0.1428p pd=1.52u as=0 ps=0 w=0.42u l=1u
X3490 VSS.t2314 VDD VSS.t2316 VSS.t2315 sg13_lv_nmos ad=79.8f pd=0.8u as=0 ps=0 w=0.42u l=1u
X3491 VDD sg13cmos5l_a21oi_1_2.A1 a_24923_15996# VDD sg13_lv_pmos ad=0.2128p pd=1.5u as=0.2128p ps=1.5u w=1.12u l=0.13u
X3492 VDD VSS.t788 VDD VDD sg13_lv_pmos ad=0.34p pd=2.68u as=0 ps=0 w=1u l=1u
X3493 VDD VSS.t976 VDD VDD sg13_lv_pmos ad=0.19p pd=1.38u as=0 ps=0 w=1u l=1u
X3494 VDD VSS.t1559 VDD VDD sg13_lv_pmos ad=0.34p pd=2.68u as=0 ps=0 w=1u l=1u
X3495 VDD VSS.t2378 VDD VDD sg13_lv_pmos ad=0.34p pd=2.68u as=0 ps=0 w=1u l=1u
X3496 VDD VSS.t1497 VDD VDD sg13_lv_pmos ad=0.19p pd=1.38u as=0 ps=0 w=1u l=1u
X3497 VDD VSS.t2406 VDD VDD sg13_lv_pmos ad=0.19p pd=1.38u as=0 ps=0 w=1u l=1u
X3498 VSS.t859 VDD VSS.t861 VSS.t860 sg13_lv_nmos ad=79.8f pd=0.8u as=0 ps=0 w=0.42u l=1u
X3499 VSS.t1595 VDD VSS.t1597 VSS.t1596 sg13_lv_nmos ad=79.8f pd=0.8u as=0 ps=0 w=0.42u l=1u
X3500 VDD VSS.t2685 VDD VDD sg13_lv_pmos ad=0.34p pd=2.68u as=0 ps=0 w=1u l=1u
X3501 VSS.t2012 VDD VSS.t2014 VSS.t2013 sg13_lv_nmos ad=79.8f pd=0.8u as=0 ps=0 w=0.42u l=1u
X3502 a_6372_14488# a_6346_14452# VDD VDD sg13_lv_pmos ad=0.34p pd=2.68u as=0.36237p ps=2.605u w=1u l=0.13u
X3503 VDD VSS.t291 VDD VDD sg13_lv_pmos ad=0.19p pd=1.38u as=0 ps=0 w=1u l=1u
X3504 VDD sg13cmos5l_dfrbpq_1_7.RESET_B a_25930_14452# VDD sg13_lv_pmos ad=0.1563p pd=1.22u as=0.147p ps=1.54u w=0.42u l=0.13u
X3505 VSS.t1423 VDD VSS.t1292 VSS.t1154 sg13_lv_nmos ad=0.1428p pd=1.52u as=0 ps=0 w=0.42u l=1u
X3506 a_4432_15454# sg13cmos5l_dfrbpq_1_0.RESET_B VDD VDD sg13_lv_pmos ad=79.8f pd=0.8u as=2.8961p ps=18.25u w=0.42u l=0.13u
X3507 VDD VSS.t2433 VDD VDD sg13_lv_pmos ad=0.34p pd=2.68u as=0 ps=0 w=1u l=1u
X3508 VSS.t2464 VDD VSS.t2466 VSS.t2465 sg13_lv_nmos ad=79.8f pd=0.8u as=0 ps=0 w=0.42u l=1u
X3509 VSS.t685 VDD VSS.t686 VSS.t683 sg13_lv_nmos ad=79.8f pd=0.8u as=0 ps=0 w=0.42u l=1u
X3510 VDD VSS.t1674 VDD VDD sg13_lv_pmos ad=0.34p pd=2.68u as=0 ps=0 w=1u l=1u
X3511 VDD VSS.t2956 VDD VDD sg13_lv_pmos ad=0.34p pd=2.68u as=0 ps=0 w=1u l=1u
X3512 VSS.t2042 VDD VSS.t2041 VSS.t2040 sg13_lv_nmos ad=0.1428p pd=1.52u as=0 ps=0 w=0.42u l=1u
X3513 VDD VSS.t605 VDD VDD sg13_lv_pmos ad=0.34p pd=2.68u as=0 ps=0 w=1u l=1u
X3514 VSS.t1214 VDD VSS.t1213 VSS.t1154 sg13_lv_nmos ad=0.1428p pd=1.52u as=0 ps=0 w=0.42u l=1u
X3515 VSS.t1525 VDD VSS.t1527 VSS.t1526 sg13_lv_nmos ad=79.8f pd=0.8u as=0 ps=0 w=0.42u l=1u
X3516 VSS.t3042 VDD VSS.t3044 VSS.t3043 sg13_lv_nmos ad=79.8f pd=0.8u as=0 ps=0 w=0.42u l=1u
X3517 VSS.t2259 VDD VSS.t2261 VSS.t2260 sg13_lv_nmos ad=79.8f pd=0.8u as=0 ps=0 w=0.42u l=1u
X3518 a_22576_14726# a_22319_14845# a_22738_14922# VSS.t4 sg13_lv_nmos ad=0.1428p pd=1.52u as=37.8f ps=0.6u w=0.42u l=0.13u
X3519 VDD VSS.t1537 VDD VDD sg13_lv_pmos ad=0.19p pd=1.38u as=0 ps=0 w=1u l=1u
X3520 VSS.t874 VDD VSS.t876 VSS.t875 sg13_lv_nmos ad=79.8f pd=0.8u as=0 ps=0 w=0.42u l=1u
X3521 VDD VSS.t1237 VDD VDD sg13_lv_pmos ad=0.34p pd=2.68u as=0 ps=0 w=1u l=1u
X3522 VDD VSS.t2750 VDD VDD sg13_lv_pmos ad=0.34p pd=2.68u as=0 ps=0 w=1u l=1u
X3523 VDD VSS.t943 VDD VDD sg13_lv_pmos ad=0.34p pd=2.68u as=0 ps=0 w=1u l=1u
X3524 VSS.t2334 VDD VSS.t2336 VSS.t2335 sg13_lv_nmos ad=79.8f pd=0.8u as=0 ps=0 w=0.42u l=1u
X3525 VSS.t814 VDD VSS.t813 VSS.t812 sg13_lv_nmos ad=0.1428p pd=1.52u as=0 ps=0 w=0.42u l=1u
X3526 VDD VSS.t2702 VDD VDD sg13_lv_pmos ad=0.19p pd=1.38u as=0 ps=0 w=1u l=1u
X3527 VSS.t2384 VDD VSS.t2383 VSS.t2382 sg13_lv_nmos ad=0.1428p pd=1.52u as=0 ps=0 w=0.42u l=1u
X3528 VDD VSS.t1504 VDD VDD sg13_lv_pmos ad=0.34p pd=2.68u as=0 ps=0 w=1u l=1u
X3529 VDD VSS.t72 VDD VDD sg13_lv_pmos ad=0.19p pd=1.38u as=0 ps=0 w=1u l=1u
X3530 VDD VSS.t614 VDD VDD sg13_lv_pmos ad=0.34p pd=2.68u as=0 ps=0 w=1u l=1u
X3531 VDD VSS.t1006 VDD VDD sg13_lv_pmos ad=0.19p pd=1.38u as=0 ps=0 w=1u l=1u
X3532 VDD VSS.t2064 VDD VDD sg13_lv_pmos ad=0.19p pd=1.38u as=0 ps=0 w=1u l=1u
X3533 VSS.t1550 VDD VSS.t1549 VSS.t1548 sg13_lv_nmos ad=0.1428p pd=1.52u as=0 ps=0 w=0.42u l=1u
X3534 VDD VSS.t1509 VDD VDD sg13_lv_pmos ad=0.34p pd=2.68u as=0 ps=0 w=1u l=1u
X3535 VSS.t2690 VDD VSS.t2689 VSS.t198 sg13_lv_nmos ad=0.1428p pd=1.52u as=0 ps=0 w=0.42u l=1u
X3536 VDD VSS.t2418 VDD VDD sg13_lv_pmos ad=0.34p pd=2.68u as=0 ps=0 w=1u l=1u
X3537 VSS.t2299 VDD VSS.t2301 VSS.t2300 sg13_lv_nmos ad=79.8f pd=0.8u as=0 ps=0 w=0.42u l=1u
X3538 VSS.t414 VDD VSS.t415 VSS.t11 sg13_lv_nmos ad=79.8f pd=0.8u as=0 ps=0 w=0.42u l=1u
X3539 VDD VSS.t558 VDD VDD sg13_lv_pmos ad=0.19p pd=1.38u as=0 ps=0 w=1u l=1u
X3540 VSS.t551 VDD VSS.t550 VSS.t549 sg13_lv_nmos ad=0.1428p pd=1.52u as=0 ps=0 w=0.42u l=1u
X3541 VSS.t2449 VDD VSS.t2451 VSS.t2450 sg13_lv_nmos ad=79.8f pd=0.8u as=0 ps=0 w=0.42u l=1u
X3542 VSS.t1190 VDD VSS.t1191 VSS.t1154 sg13_lv_nmos ad=79.8f pd=0.8u as=0 ps=0 w=0.42u l=1u
X3543 VSS.t1228 VDD VSS.t1226 VSS.t1154 sg13_lv_nmos ad=0.1428p pd=1.52u as=0 ps=0 w=0.42u l=1u
X3544 VDD VSS.t2976 VDD VDD sg13_lv_pmos ad=0.34p pd=2.68u as=0 ps=0 w=1u l=1u
X3545 VDD VSS.t1851 VDD VDD sg13_lv_pmos ad=0.34p pd=2.68u as=0 ps=0 w=1u l=1u
X3546 VSS.t2027 VDD VSS.t2026 VSS.t2025 sg13_lv_nmos ad=0.1428p pd=1.52u as=0 ps=0 w=0.42u l=1u
X3547 sg13cmos5l_dfrbpq_1_2.CLK a_12010_15202# VDD VDD sg13_lv_pmos ad=0.2128p pd=1.5u as=0.3864p ps=2.93u w=1.12u l=0.13u
X3548 VSS.t844 VDD VSS.t843 VSS.t842 sg13_lv_nmos ad=0.1428p pd=1.52u as=0 ps=0 w=0.42u l=1u
X3549 VDD VSS.t2366 VDD VDD sg13_lv_pmos ad=0.19p pd=1.38u as=0 ps=0 w=1u l=1u
X3550 VDD VSS.t2024 VDD VDD sg13_lv_pmos ad=0.19p pd=1.38u as=0 ps=0 w=1u l=1u
X3551 VSS.t1670 VDD VSS.t1669 VSS.t1668 sg13_lv_nmos ad=0.1428p pd=1.52u as=0 ps=0 w=0.42u l=1u
X3552 VDD VSS.t896 VDD VDD sg13_lv_pmos ad=0.19p pd=1.38u as=0 ps=0 w=1u l=1u
X3553 VSS.t1917 VDD VSS.t1916 VSS.t1915 sg13_lv_nmos ad=0.1428p pd=1.52u as=0 ps=0 w=0.42u l=1u
X3554 VDD VSS.t1284 VDD VDD sg13_lv_pmos ad=0.19p pd=1.38u as=0 ps=0 w=1u l=1u
X3555 VSS.t2997 VDD VSS.t2996 VSS.t2995 sg13_lv_nmos ad=0.1428p pd=1.52u as=0 ps=0 w=0.42u l=1u
X3556 a_9861_15213# sg13cmos5l_dfrbpq_1_2.CLK VSS.t11 VSS.t93 sg13_lv_nmos ad=0.2516p pd=2.16u as=3.8707p ps=25.555u w=0.74u l=0.13u
X3557 VDD VSS.t1021 VDD VDD sg13_lv_pmos ad=0.19p pd=1.38u as=0 ps=0 w=1u l=1u
X3558 VSS.t2479 VDD VSS.t2478 VSS.t2477 sg13_lv_nmos ad=0.1428p pd=1.52u as=0 ps=0 w=0.42u l=1u
X3559 VDD a_15579_14854# sg13cmos5l_buf_8_2.A VDD sg13_lv_pmos ad=0.2128p pd=1.5u as=0.2128p ps=1.5u w=1.12u l=0.13u
X3560 VSS.t611 VDD VSS.t611 VSS.t612 sg13_lv_nmos ad=79.8f pd=0.8u as=0 ps=0 w=0.42u l=1u
X3561 VDD a_22576_14726# a_22521_14607# VDD sg13_lv_pmos ad=2.42015p pd=15.68u as=93.45f ps=0.865u w=0.42u l=0.13u
X3562 VSS.t859 VDD VSS.t861 VSS.t860 sg13_lv_nmos ad=79.8f pd=0.8u as=0 ps=0 w=0.42u l=1u
X3563 VDD VSS.t1482 VDD VDD sg13_lv_pmos ad=0.19p pd=1.38u as=0 ps=0 w=1u l=1u
X3564 VSS.t2763 VDD VSS.t2764 VSS.t198 sg13_lv_nmos ad=79.8f pd=0.8u as=0 ps=0 w=0.42u l=1u
X3565 VDD VSS.t412 VDD VDD sg13_lv_pmos ad=0.19p pd=1.38u as=0 ps=0 w=1u l=1u
X3566 VSS.t904 VDD VSS.t906 VSS.t905 sg13_lv_nmos ad=79.8f pd=0.8u as=0 ps=0 w=0.42u l=1u
X3567 VDD VSS.t2391 VDD VDD sg13_lv_pmos ad=0.19p pd=1.38u as=0 ps=0 w=1u l=1u
X3568 VDD sg13cmos5l_a21oi_1_0.Y a_16856_15238# VDD sg13_lv_pmos ad=0.1523p pd=1.38u as=0.1428p ps=1.52u w=0.42u l=0.13u
X3569 VSS.t2279 VDD VSS.t2281 VSS.t2280 sg13_lv_nmos ad=79.8f pd=0.8u as=0 ps=0 w=0.42u l=1u
X3570 VSS.t468 VDD VSS.t467 VSS.t9 sg13_lv_nmos ad=0.1428p pd=1.52u as=0 ps=0 w=0.42u l=1u
X3571 VDD VSS.t771 VDD VDD sg13_lv_pmos ad=0.19p pd=1.38u as=0 ps=0 w=1u l=1u
X3572 VSS.t1997 VDD VSS.t1999 VSS.t1998 sg13_lv_nmos ad=79.8f pd=0.8u as=0 ps=0 w=0.42u l=1u
X3573 VDD VSS.t443 VDD VDD sg13_lv_pmos ad=0.34p pd=2.68u as=0 ps=0 w=1u l=1u
X3574 VSS.t2728 VDD VSS.t2729 VSS.t198 sg13_lv_nmos ad=79.8f pd=0.8u as=0 ps=0 w=0.42u l=1u
X3575 sg13cmos5l_a21oi_1_3.A1 a_25206_15302# VDD VDD sg13_lv_pmos ad=0.4256p pd=3u as=0.2254p ps=1.53u w=1.12u l=0.13u
X3576 a_6086_14922# sg13cmos5l_and2_1_1.X VDD VDD sg13_lv_pmos ad=79.8f pd=0.8u as=0.1428p ps=1.52u w=0.42u l=0.13u
X3577 a_21034_14452# a_21477_14495# a_21417_14531# VDD sg13_lv_pmos ad=79.8f pd=0.8u as=63f ps=0.72u w=0.42u l=0.13u
X3578 VSS.t209 VDD VSS.t209 VSS.t653 sg13_lv_nmos ad=79.8f pd=0.8u as=0 ps=0 w=0.42u l=1u
X3579 VSS.t1500 VDD VSS.t1499 VSS.t1498 sg13_lv_nmos ad=0.1428p pd=1.52u as=0 ps=0 w=0.42u l=1u
X3580 VDD sg13cmos5l_dfrbpq_1_7.RESET_B a_25670_14922# VDD sg13_lv_pmos ad=0.36237p pd=2.605u as=79.8f ps=0.8u w=0.42u l=0.13u
X3581 VSS.t1173 VDD VSS.t1173 VSS.t1154 sg13_lv_nmos ad=0.1428p pd=1.52u as=0 ps=0 w=0.42u l=1u
X3582 VSS.t503 VDD VSS.t508 VSS.t507 sg13_lv_nmos ad=79.8f pd=0.8u as=0 ps=0 w=0.42u l=1u
X3583 VDD VSS.t1230 VDD VDD sg13_lv_pmos ad=0.34p pd=2.68u as=0 ps=0 w=1u l=1u
X3584 VDD VSS.t2729 VDD VDD sg13_lv_pmos ad=0.34p pd=2.68u as=0 ps=0 w=1u l=1u
X3585 VDD VSS.t2016 VDD VDD sg13_lv_pmos ad=0.34p pd=2.68u as=0 ps=0 w=1u l=1u
X3586 VSS.t698 a_19323_13726# sg13cmos5l_buf_8_2.X VSS.t3256 sg13_lv_nmos ad=0.1406p pd=1.12u as=0.1406p ps=1.12u w=0.74u l=0.13u
X3587 VSS.t874 VDD VSS.t876 VSS.t875 sg13_lv_nmos ad=79.8f pd=0.8u as=0 ps=0 w=0.42u l=1u
X3588 VDD VSS.t421 VDD VDD sg13_lv_pmos ad=0.19p pd=1.38u as=0 ps=0 w=1u l=1u
X3589 VSS.t635 VDD VSS.t635 VSS.t636 sg13_lv_nmos ad=79.8f pd=0.8u as=0 ps=0 w=0.42u l=1u
X3590 VSS.t1510 VDD VSS.t1512 VSS.t1511 sg13_lv_nmos ad=79.8f pd=0.8u as=0 ps=0 w=0.42u l=1u
X3591 VSS.t1690 VDD VSS.t1689 VSS.t1688 sg13_lv_nmos ad=0.1428p pd=1.52u as=0 ps=0 w=0.42u l=1u
X3592 VSS.t3027 VDD VSS.t3029 VSS.t3028 sg13_lv_nmos ad=79.8f pd=0.8u as=0 ps=0 w=0.42u l=1u
X3593 VSS.t2244 VDD VSS.t2246 VSS.t2245 sg13_lv_nmos ad=79.8f pd=0.8u as=0 ps=0 w=0.42u l=1u
X3594 VDD VSS.t227 VDD VDD sg13_lv_pmos ad=0.19p pd=1.38u as=0 ps=0 w=1u l=1u
X3595 a_19065_14607# a_18123_14495# a_18863_14845# VDD sg13_lv_pmos ad=93.45f pd=0.865u as=0.2048p ps=1.63u w=0.42u l=0.13u
X3596 VDD VSS.t1699 VDD VDD sg13_lv_pmos ad=0.34p pd=2.68u as=0 ps=0 w=1u l=1u
X3597 VSS.t2499 VDD VSS.t2498 VSS.t2497 sg13_lv_nmos ad=0.1428p pd=1.52u as=0 ps=0 w=0.42u l=1u
X3598 VSS.t2319 VDD VSS.t2321 VSS.t2320 sg13_lv_nmos ad=79.8f pd=0.8u as=0 ps=0 w=0.42u l=1u
X3599 VSS.t83 sg13cmos5l_dlygate4sd3_1_4.X a_16969_16020# VSS.t3262 sg13_lv_nmos ad=0.13395p pd=1.12u as=0.198p ps=1.27u w=0.55u l=0.13u
X3600 a_2916_15552# a_2890_15457# VSS.t187 VSS.t3219 sg13_lv_nmos ad=0.2516p pd=2.16u as=0.1626p ps=1.415u w=0.74u l=0.13u
X3601 VDD VSS.t132 VDD VDD sg13_lv_pmos ad=0.34p pd=2.68u as=0 ps=0 w=1u l=1u
X3602 sg13cmos5l_o21ai_1_2.A2 sg13cmos5l_dfrbpq_1_6.Q VDD VDD sg13_lv_pmos ad=0.3808p pd=2.92u as=0.2128p ps=1.5u w=1.12u l=0.13u
X3603 VSS.t814 VDD VSS.t813 VSS.t812 sg13_lv_nmos ad=0.1428p pd=1.52u as=0 ps=0 w=0.42u l=1u
X3604 VSS.t1246 VDD VSS.t1245 VSS.t1154 sg13_lv_nmos ad=0.1428p pd=1.52u as=0 ps=0 w=0.42u l=1u
X3605 VDD VSS.t3094 VDD VDD sg13_lv_pmos ad=0.19p pd=1.38u as=0 ps=0 w=1u l=1u
X3606 VDD VSS.t1529 VDD VDD sg13_lv_pmos ad=0.34p pd=2.68u as=0 ps=0 w=1u l=1u
X3607 VDD VSS.t1218 VDD VDD sg13_lv_pmos ad=0.19p pd=1.38u as=0 ps=0 w=1u l=1u
X3608 VDD VSS.t926 VDD VDD sg13_lv_pmos ad=0.19p pd=1.38u as=0 ps=0 w=1u l=1u
X3609 VSS.t1600 VDD VSS.t1602 VSS.t1601 sg13_lv_nmos ad=79.8f pd=0.8u as=0 ps=0 w=0.42u l=1u
X3610 VDD VSS.t2670 VDD VDD sg13_lv_pmos ad=0.34p pd=2.68u as=0 ps=0 w=1u l=1u
X3611 VSS.t25 VDD VSS.t27 VSS.t459 sg13_lv_nmos ad=79.8f pd=0.8u as=0 ps=0 w=0.42u l=1u
X3612 VDD VSS.t72 VDD VDD sg13_lv_pmos ad=0.19p pd=1.38u as=0 ps=0 w=1u l=1u
X3613 VSS.t508 VDD VSS.t508 VSS.t509 sg13_lv_nmos ad=0.1428p pd=1.52u as=0 ps=0 w=0.42u l=1u
X3614 VDD VSS.t1489 VDD VDD sg13_lv_pmos ad=0.34p pd=2.68u as=0 ps=0 w=1u l=1u
X3615 VSS.t1185 VDD VSS.t1185 VSS.t1154 sg13_lv_nmos ad=0.1428p pd=1.52u as=0 ps=0 w=0.42u l=1u
X3616 VDD VSS.t1250 VDD VDD sg13_lv_pmos ad=0.19p pd=1.38u as=0 ps=0 w=1u l=1u
X3617 VDD VSS.t2746 VDD VDD sg13_lv_pmos ad=0.19p pd=1.38u as=0 ps=0 w=1u l=1u
X3618 VSS.t351 VDD VSS.t351 VSS.t352 sg13_lv_nmos ad=0.1428p pd=1.52u as=0 ps=0 w=0.42u l=1u
X3619 VDD VSS.t863 VDD VDD sg13_lv_pmos ad=0.34p pd=2.68u as=0 ps=0 w=1u l=1u
X3620 VDD VSS.t1494 VDD VDD sg13_lv_pmos ad=0.34p pd=2.68u as=0 ps=0 w=1u l=1u
X3621 VSS.t2464 VDD VSS.t2463 VSS.t2462 sg13_lv_nmos ad=0.1428p pd=1.52u as=0 ps=0 w=0.42u l=1u
X3622 a_2646_14842# sg13cmos5l_xor2_1_0.B sg13cmos5l_xor2_1_0.X VSS.t185 sg13_lv_nmos ad=88.8f pd=0.98u as=0.1628p ps=1.18u w=0.74u l=0.13u
X3623 VDD VSS.t2403 VDD VDD sg13_lv_pmos ad=0.34p pd=2.68u as=0 ps=0 w=1u l=1u
X3624 VSS.t408 VDD VSS.t409 VSS.t11 sg13_lv_nmos ad=79.8f pd=0.8u as=0 ps=0 w=0.42u l=1u
X3625 VSS.t844 VDD VSS.t843 VSS.t842 sg13_lv_nmos ad=0.1428p pd=1.52u as=0 ps=0 w=0.42u l=1u
X3626 VSS.t1254 VDD VSS.t1254 VSS.t1154 sg13_lv_nmos ad=0.1428p pd=1.52u as=0 ps=0 w=0.42u l=1u
X3627 VSS.t2294 VDD VSS.t2293 VSS.t2292 sg13_lv_nmos ad=0.1428p pd=1.52u as=0 ps=0 w=0.42u l=1u
X3628 VDD VSS.t2961 VDD VDD sg13_lv_pmos ad=0.34p pd=2.68u as=0 ps=0 w=1u l=1u
X3629 VDD VSS.t1836 VDD VDD sg13_lv_pmos ad=0.34p pd=2.68u as=0 ps=0 w=1u l=1u
X3630 VSS.t2012 VDD VSS.t2011 VSS.t2010 sg13_lv_nmos ad=0.1428p pd=1.52u as=0 ps=0 w=0.42u l=1u
X3631 VSS.t370 VDD VSS.t366 VSS.t369 sg13_lv_nmos ad=0.1428p pd=1.52u as=0 ps=0 w=0.42u l=1u
X3632 a_23638_14862# sg13cmos5l_o21ai_1_2.A2 VSS.t3207 VSS.t4 sg13_lv_nmos ad=0.1406p pd=1.12u as=0.1406p ps=1.12u w=0.74u l=0.15u
X3633 VSS.t571 VDD VSS.t570 VSS.t569 sg13_lv_nmos ad=0.1428p pd=1.52u as=0 ps=0 w=0.42u l=1u
X3634 a_3273_15625# a_2916_15552# VDD VDD sg13_lv_pmos ad=63f pd=0.72u as=0.1563p ps=1.22u w=0.42u l=0.13u
X3635 VSS.t1014 VDD VSS.t1013 VSS.t1012 sg13_lv_nmos ad=0.1428p pd=1.52u as=0 ps=0 w=0.42u l=1u
X3636 VDD VSS.t2368 VDD VDD sg13_lv_pmos ad=0.34p pd=2.68u as=0 ps=0 w=1u l=1u
X3637 VSS.t904 VDD VSS.t906 VSS.t905 sg13_lv_nmos ad=79.8f pd=0.8u as=0 ps=0 w=0.42u l=1u
X3638 VDD VSS.t1198 VDD VDD sg13_lv_pmos ad=0.34p pd=2.68u as=0 ps=0 w=1u l=1u
X3639 VSS.t1274 VDD VSS.t1273 VSS.t1154 sg13_lv_nmos ad=0.1428p pd=1.52u as=0 ps=0 w=0.42u l=1u
X3640 VDD VSS.t1879 VDD VDD sg13_lv_pmos ad=0.19p pd=1.38u as=0 ps=0 w=1u l=1u
X3641 VDD VSS.t2709 VDD VDD sg13_lv_pmos ad=0.19p pd=1.38u as=0 ps=0 w=1u l=1u
X3642 a_17578_14452# a_18021_14495# a_17961_14531# VDD sg13_lv_pmos ad=79.8f pd=0.8u as=63f ps=0.72u w=0.42u l=0.13u
X3643 VSS.t1560 VDD VSS.t1559 VSS.t1558 sg13_lv_nmos ad=0.1428p pd=1.52u as=0 ps=0 w=0.42u l=1u
X3644 a_9861_15213# sg13cmos5l_dfrbpq_1_2.CLK VDD VDD sg13_lv_pmos ad=0.4088p pd=2.97u as=2.77542p ps=17.49u w=1.12u l=0.13u
X3645 VSS.t2264 VDD VSS.t2266 VSS.t2265 sg13_lv_nmos ad=79.8f pd=0.8u as=0 ps=0 w=0.42u l=1u
X3646 VSS.t713 VDD VSS.t588 VSS.t712 sg13_lv_nmos ad=0.1428p pd=1.52u as=0 ps=0 w=0.42u l=1u
X3647 VSS.t1279 VDD VSS.t1278 VSS.t1154 sg13_lv_nmos ad=0.1428p pd=1.52u as=0 ps=0 w=0.42u l=1u
X3648 VDD VSS.t1474 VDD VDD sg13_lv_pmos ad=0.34p pd=2.68u as=0 ps=0 w=1u l=1u
X3649 VDD VSS.t826 VDD VDD sg13_lv_pmos ad=0.19p pd=1.38u as=0 ps=0 w=1u l=1u
X3650 VSS.t2112 VDD VSS.t2114 VSS.t2113 sg13_lv_nmos ad=79.8f pd=0.8u as=0 ps=0 w=0.42u l=1u
X3651 VDD a_26554_16237# sg13cmos5l_dfrbpq_1_5.RESET_B VDD sg13_lv_pmos ad=2.8961p pd=18.25u as=0.3927p ps=2.99u w=1.155u l=0.13u
X3652 VSS.t1310 VDD VSS.t1311 VSS.t1154 sg13_lv_nmos ad=79.8f pd=0.8u as=0 ps=0 w=0.42u l=1u
X3653 VSS.t1555 VDD VSS.t1554 VSS.t1553 sg13_lv_nmos ad=0.1428p pd=1.52u as=0 ps=0 w=0.42u l=1u
X3654 VSS.t2304 VDD VSS.t2306 VSS.t2305 sg13_lv_nmos ad=79.8f pd=0.8u as=0 ps=0 w=0.42u l=1u
X3655 VDD VSS.t1220 VDD VDD sg13_lv_pmos ad=0.34p pd=2.68u as=0 ps=0 w=1u l=1u
X3656 VDD VSS.t2721 VDD VDD sg13_lv_pmos ad=0.34p pd=2.68u as=0 ps=0 w=1u l=1u
X3657 VSS.t2032 VDD VSS.t2031 VSS.t2030 sg13_lv_nmos ad=0.1428p pd=1.52u as=0 ps=0 w=0.42u l=1u
X3658 VDD VSS.t2029 VDD VDD sg13_lv_pmos ad=0.19p pd=1.38u as=0 ps=0 w=1u l=1u
X3659 VSS.t283 a_7532_15960# counter_value_o[1] VSS.t3167 sg13_lv_nmos ad=0.14875p pd=1.16u as=0.2886p ps=2.26u w=0.74u l=0.13u
X3660 VSS.t1675 VDD VSS.t1674 VSS.t1673 sg13_lv_nmos ad=0.1428p pd=1.52u as=0 ps=0 w=0.42u l=1u
X3661 VDD VSS.t563 VDD VDD sg13_lv_pmos ad=0.19p pd=1.38u as=0 ps=0 w=1u l=1u
X3662 VDD VSS.t1177 VDD VDD sg13_lv_pmos ad=0.19p pd=1.38u as=0 ps=0 w=1u l=1u
X3663 VDD VSS.t1033 VDD VDD sg13_lv_pmos ad=0.34p pd=2.68u as=0 ps=0 w=1u l=1u
X3664 VSS.t2484 VDD VSS.t2483 VSS.t2482 sg13_lv_nmos ad=0.1428p pd=1.52u as=0 ps=0 w=0.42u l=1u
X3665 VSS.t279 VDD VSS.t274 VSS.t278 sg13_lv_nmos ad=0.1428p pd=1.52u as=0 ps=0 w=0.42u l=1u
X3666 VSS.t441 VDD VSS.t442 VSS.t11 sg13_lv_nmos ad=79.8f pd=0.8u as=0 ps=0 w=0.42u l=1u
X3667 VDD VSS.t1514 VDD VDD sg13_lv_pmos ad=0.34p pd=2.68u as=0 ps=0 w=1u l=1u
X3668 VDD VSS.t1864 VDD VDD sg13_lv_pmos ad=0.19p pd=1.38u as=0 ps=0 w=1u l=1u
X3669 VSS.t2766 VDD VSS.t2767 VSS.t198 sg13_lv_nmos ad=79.8f pd=0.8u as=0 ps=0 w=0.42u l=1u
X3670 VDD VSS.t2700 VDD VDD sg13_lv_pmos ad=0.19p pd=1.38u as=0 ps=0 w=1u l=1u
X3671 VSS.t1982 VDD VSS.t1981 VSS.t1980 sg13_lv_nmos ad=0.1428p pd=1.52u as=0 ps=0 w=0.42u l=1u
X3672 VDD VSS.t632 VDD VDD sg13_lv_pmos ad=0.34p pd=2.68u as=0 ps=0 w=1u l=1u
X3673 VDD VSS.t793 VDD VDD sg13_lv_pmos ad=0.34p pd=2.68u as=0 ps=0 w=1u l=1u
X3674 VSS.t1585 VDD VSS.t1587 VSS.t1586 sg13_lv_nmos ad=79.8f pd=0.8u as=0 ps=0 w=0.42u l=1u
X3675 VSS.t2711 VDD VSS.t2712 VSS.t198 sg13_lv_nmos ad=79.8f pd=0.8u as=0 ps=0 w=0.42u l=1u
X3676 VSS.t1292 VDD VSS.t1291 VSS.t1154 sg13_lv_nmos ad=0.1428p pd=1.52u as=0 ps=0 w=0.42u l=1u
X3677 VDD VSS.t2456 VDD VDD sg13_lv_pmos ad=0.19p pd=1.38u as=0 ps=0 w=1u l=1u
X3678 VDD a_19054_15423# sg13cmos5l_dlygate4sd3_1_4.X VDD sg13_lv_pmos ad=0.2254p pd=1.53u as=0.4256p ps=3u w=1.12u l=0.13u
X3679 VSS.t399 VDD VSS.t400 VSS.t11 sg13_lv_nmos ad=79.8f pd=0.8u as=0 ps=0 w=0.42u l=1u
X3680 VDD VSS.t908 VDD VDD sg13_lv_pmos ad=0.34p pd=2.68u as=0 ps=0 w=1u l=1u
X3681 VSS.t1505 VDD VSS.t1504 VSS.t1503 sg13_lv_nmos ad=0.1428p pd=1.52u as=0 ps=0 w=0.42u l=1u
X3682 VDD VSS.t2231 VDD VDD sg13_lv_pmos ad=0.19p pd=1.38u as=0 ps=0 w=1u l=1u
X3683 VSS.t2062 VDD VSS.t2064 VSS.t2063 sg13_lv_nmos ad=79.8f pd=0.8u as=0 ps=0 w=0.42u l=1u
X3684 VDD VSS.t1233 VDD VDD sg13_lv_pmos ad=0.34p pd=2.68u as=0 ps=0 w=1u l=1u
X3685 VDD VSS.t2021 VDD VDD sg13_lv_pmos ad=0.34p pd=2.68u as=0 ps=0 w=1u l=1u
X3686 VDD VSS.t2712 VDD VDD sg13_lv_pmos ad=0.34p pd=2.68u as=0 ps=0 w=1u l=1u
X3687 VSS.t2279 VDD VSS.t2278 VSS.t2277 sg13_lv_nmos ad=0.1428p pd=1.52u as=0 ps=0 w=0.42u l=1u
X3688 VSS.t11 a_5687_15315# a_5687_15315# VSS.t3175 sg13_lv_nmos ad=4.11262p pd=27.15u as=0.111p ps=1.34u w=0.3u l=0.13u
X3689 VDD VSS.t846 VDD VDD sg13_lv_pmos ad=0.19p pd=1.38u as=0 ps=0 w=1u l=1u
X3690 VSS.t3032 VDD VSS.t3034 VSS.t3033 sg13_lv_nmos ad=79.8f pd=0.8u as=0 ps=0 w=0.42u l=1u
X3691 VSS.t2652 VDD VSS.t2653 VSS.t198 sg13_lv_nmos ad=79.8f pd=0.8u as=0 ps=0 w=0.42u l=1u
X3692 VSS.t2249 VDD VSS.t2251 VSS.t2250 sg13_lv_nmos ad=79.8f pd=0.8u as=0 ps=0 w=0.42u l=1u
X3693 a_21251_13690# sg13cmos5l_or3_1_2.C VSS.t703 VSS.t3176 sg13_lv_nmos ad=0.187p pd=1.78u as=0.1045p ps=0.93u w=0.55u l=0.13u
X3694 VDD VSS.t1269 VDD VDD sg13_lv_pmos ad=0.19p pd=1.38u as=0 ps=0 w=1u l=1u
X3695 VDD VSS.t808 VDD VDD sg13_lv_pmos ad=0.34p pd=2.68u as=0 ps=0 w=1u l=1u
X3696 VSS.t1014 VDD VSS.t1013 VSS.t1012 sg13_lv_nmos ad=0.1428p pd=1.52u as=0 ps=0 w=0.42u l=1u
X3697 VDD VSS.t1669 VDD VDD sg13_lv_pmos ad=0.34p pd=2.68u as=0 ps=0 w=1u l=1u
X3698 VSS.t596 VDD VSS.t596 VSS.t597 sg13_lv_nmos ad=79.8f pd=0.8u as=0 ps=0 w=0.42u l=1u
X3699 VSS.t1217 VDD VSS.t1218 VSS.t1154 sg13_lv_nmos ad=79.8f pd=0.8u as=0 ps=0 w=0.42u l=1u
X3700 VSS.t291 VDD VSS.t291 VSS.t294 sg13_lv_nmos ad=79.8f pd=0.8u as=0 ps=0 w=0.42u l=1u
X3701 VDD VSS.t1534 VDD VDD sg13_lv_pmos ad=0.34p pd=2.68u as=0 ps=0 w=1u l=1u
X3702 VSS.t1892 VDD VSS.t1894 VSS.t1893 sg13_lv_nmos ad=79.8f pd=0.8u as=0 ps=0 w=0.42u l=1u
X3703 VDD VSS.t2673 VDD VDD sg13_lv_pmos ad=0.34p pd=2.68u as=0 ps=0 w=1u l=1u
X3704 VSS.t1306 VDD VSS.t1304 VSS.t1154 sg13_lv_nmos ad=0.1428p pd=1.52u as=0 ps=0 w=0.42u l=1u
X3705 VDD VSS.t545 VDD VDD sg13_lv_pmos ad=0.34p pd=2.68u as=0 ps=0 w=1u l=1u
X3706 VSS.t819 VDD VSS.t821 VSS.t820 sg13_lv_nmos ad=79.8f pd=0.8u as=0 ps=0 w=0.42u l=1u
X3707 a_9158_15234# sg13cmos5l_and2_1_2.X VDD VDD sg13_lv_pmos ad=79.8f pd=0.8u as=0.1428p ps=1.52u w=0.42u l=0.13u
X3708 VSS.t119 sg13cmos5l_xor2_1_0.X a_2059_14832# VSS.t118 sg13_lv_nmos ad=0.1331p pd=1.12u as=0.1216p ps=1.02u w=0.64u l=0.13u
X3709 VDD VSS.t878 VDD VDD sg13_lv_pmos ad=0.34p pd=2.68u as=0 ps=0 w=1u l=1u
X3710 VDD VSS.t1253 VDD VDD sg13_lv_pmos ad=0.19p pd=1.38u as=0 ps=0 w=1u l=1u
X3711 VSS.t1490 VDD VSS.t1489 VSS.t1488 sg13_lv_nmos ad=0.1428p pd=1.52u as=0 ps=0 w=0.42u l=1u
X3712 VSS.t2097 VDD VSS.t2099 VSS.t2098 sg13_lv_nmos ad=79.8f pd=0.8u as=0 ps=0 w=0.42u l=1u
X3713 VDD VSS.t2054 VDD VDD sg13_lv_pmos ad=0.19p pd=1.38u as=0 ps=0 w=1u l=1u
X3714 VDD VSS.t1499 VDD VDD sg13_lv_pmos ad=0.34p pd=2.68u as=0 ps=0 w=1u l=1u
X3715 VSS.t2469 VDD VSS.t2468 VSS.t2467 sg13_lv_nmos ad=0.1428p pd=1.52u as=0 ps=0 w=0.42u l=1u
X3716 VSS.t138 VDD VSS.t138 VSS.t696 sg13_lv_nmos ad=79.8f pd=0.8u as=0 ps=0 w=0.42u l=1u
X3717 VSS.t2684 VDD VSS.t2683 VSS.t198 sg13_lv_nmos ad=0.1428p pd=1.52u as=0 ps=0 w=0.42u l=1u
X3718 VDD VSS.t2408 VDD VDD sg13_lv_pmos ad=0.34p pd=2.68u as=0 ps=0 w=1u l=1u
X3719 VDD VSS.t617 VDD VDD sg13_lv_pmos ad=0.34p pd=2.68u as=0 ps=0 w=1u l=1u
X3720 VDD VSS.t2966 VDD VDD sg13_lv_pmos ad=0.34p pd=2.68u as=0 ps=0 w=1u l=1u
X3721 a_10222_14751# a_10337_14750# VSS.t129 VSS.t159 sg13_lv_nmos ad=0.1428p pd=1.52u as=0.1426p ps=1.16u w=0.42u l=0.5u
X3722 VSS.t2234 VDD VSS.t2236 VSS.t2235 sg13_lv_nmos ad=79.8f pd=0.8u as=0 ps=0 w=0.42u l=1u
X3723 VSS.t2017 VDD VSS.t2016 VSS.t2015 sg13_lv_nmos ad=0.1428p pd=1.52u as=0 ps=0 w=0.42u l=1u
X3724 VDD VSS.t563 VDD VDD sg13_lv_pmos ad=0.19p pd=1.38u as=0 ps=0 w=1u l=1u
X3725 VDD VSS.t963 VDD VDD sg13_lv_pmos ad=0.34p pd=2.68u as=0 ps=0 w=1u l=1u
X3726 VSS.t1967 VDD VSS.t1969 VSS.t1968 sg13_lv_nmos ad=79.8f pd=0.8u as=0 ps=0 w=0.42u l=1u
X3727 VDD VSS.t1512 VDD VDD sg13_lv_pmos ad=0.19p pd=1.38u as=0 ps=0 w=1u l=1u
X3728 VSS.t2309 VDD VSS.t2311 VSS.t2310 sg13_lv_nmos ad=79.8f pd=0.8u as=0 ps=0 w=0.42u l=1u
X3729 VSS.t503 VDD VSS.t508 VSS.t507 sg13_lv_nmos ad=79.8f pd=0.8u as=0 ps=0 w=0.42u l=1u
X3730 VDD VSS.t2109 VDD VDD sg13_lv_pmos ad=0.19p pd=1.38u as=0 ps=0 w=1u l=1u
X3731 VDD VSS.t227 VDD VDD sg13_lv_pmos ad=0.34p pd=2.68u as=0 ps=0 w=1u l=1u
X3732 a_25037_14020# sg13cmos5l_or3_1_1.B a_24935_14020# VDD sg13_lv_pmos ad=0.1575p pd=1.315u as=0.19p ps=1.38u w=1u l=0.13u
X3733 VDD VSS.t1849 VDD VDD sg13_lv_pmos ad=0.19p pd=1.38u as=0 ps=0 w=1u l=1u
X3734 VSS.t2757 VDD VSS.t2758 VSS.t198 sg13_lv_nmos ad=79.8f pd=0.8u as=0 ps=0 w=0.42u l=1u
X3735 VDD VSS.t2638 VDD VDD sg13_lv_pmos ad=0.19p pd=1.38u as=0 ps=0 w=1u l=1u
X3736 VDD VSS.t327 VDD VDD sg13_lv_pmos ad=0.34p pd=2.68u as=0 ps=0 w=1u l=1u
X3737 VDD VSS.t1287 VDD VDD sg13_lv_pmos ad=0.19p pd=1.38u as=0 ps=0 w=1u l=1u
X3738 VSS.t1530 VDD VSS.t1529 VSS.t1528 sg13_lv_nmos ad=0.1428p pd=1.52u as=0 ps=0 w=0.42u l=1u
X3739 VSS.t3047 VDD VSS.t3046 VSS.t3045 sg13_lv_nmos ad=0.1428p pd=1.52u as=0 ps=0 w=0.42u l=1u
X3740 VSS.t2264 VDD VSS.t2263 VSS.t2262 sg13_lv_nmos ad=0.1428p pd=1.52u as=0 ps=0 w=0.42u l=1u
X3741 a_7262_15242# sg13cmos5l_buf_1_0.X a_7160_15242# VSS.t3202 sg13_lv_nmos ad=0.1406p pd=1.12u as=0.1406p ps=1.12u w=0.74u l=0.13u
X3742 VDD a_26638_15423# sg13cmos5l_o21ai_1_2.B1 VDD sg13_lv_pmos ad=0.2254p pd=1.53u as=0.4256p ps=3u w=1.12u l=0.13u
X3743 VDD a_6682_13690# a_6401_13912# VDD sg13_lv_pmos ad=0.1523p pd=1.38u as=0.34p ps=2.68u w=1u l=0.5u
X3744 VSS.t2732 VDD VSS.t2732 VSS.t198 sg13_lv_nmos ad=0.1428p pd=1.52u as=0 ps=0 w=0.42u l=1u
X3745 VSS.t614 VDD VSS.t614 VSS.t615 sg13_lv_nmos ad=79.8f pd=0.8u as=0 ps=0 w=0.42u l=1u
X3746 VDD VSS.t1026 VDD VDD sg13_lv_pmos ad=0.19p pd=1.38u as=0 ps=0 w=1u l=1u
X3747 VDD sg13cmos5l_inv_1_0.A sg13cmos5l_inv_1_0.Y VDD sg13_lv_pmos ad=0.3808p pd=2.92u as=0.3808p ps=2.92u w=1.12u l=0.13u
X3748 VSS.t366 VDD VSS.t366 VSS.t368 sg13_lv_nmos ad=79.8f pd=0.8u as=0 ps=0 w=0.42u l=1u
X3749 VSS.t426 VDD VSS.t427 VSS.t11 sg13_lv_nmos ad=79.8f pd=0.8u as=0 ps=0 w=0.42u l=1u
X3750 VDD VSS.t682 VDD VDD sg13_lv_pmos ad=0.19p pd=1.38u as=0 ps=0 w=1u l=1u
X3751 VDD VSS.t1652 VDD VDD sg13_lv_pmos ad=0.19p pd=1.38u as=0 ps=0 w=1u l=1u
X3752 VSS.t570 VDD VSS.t571 VSS.t676 sg13_lv_nmos ad=0.1428p pd=1.52u as=0 ps=0 w=0.42u l=1u
X3753 VDD VSS.t2006 VDD VDD sg13_lv_pmos ad=0.34p pd=2.68u as=0 ps=0 w=1u l=1u
X3754 VDD VSS.t209 VDD VDD sg13_lv_pmos ad=0.34p pd=2.68u as=0 ps=0 w=1u l=1u
X3755 VDD VSS.t1295 VDD VDD sg13_lv_pmos ad=0.19p pd=1.38u as=0 ps=0 w=1u l=1u
X3756 VDD a_14261_15238# sg13cmos5l_or3_1_1.B VDD sg13_lv_pmos ad=0.3808p pd=2.92u as=0.2128p ps=1.5u w=1.12u l=0.13u
X3757 a_22738_14922# sg13cmos5l_dfrbpq_1_6.RESET_B VSS.t89 VSS.t4 sg13_lv_nmos ad=37.8f pd=0.6u as=79.8f ps=0.8u w=0.42u l=0.13u
X3758 VSS.t623 VDD VSS.t623 VSS.t624 sg13_lv_nmos ad=79.8f pd=0.8u as=0 ps=0 w=0.42u l=1u
X3759 VDD a_4175_15311# a_4432_15454# VDD sg13_lv_pmos ad=2.8961p pd=18.25u as=79.8f ps=0.8u w=0.42u l=0.13u
X3760 VSS.t1328 VDD VSS.t1327 VSS.t1154 sg13_lv_nmos ad=0.1428p pd=1.52u as=0 ps=0 w=0.42u l=1u
X3761 VSS.t1409 VDD VSS.t1277 VSS.t1154 sg13_lv_nmos ad=79.8f pd=0.8u as=0 ps=0 w=0.42u l=1u
X3762 VDD VSS.t2271 VDD VDD sg13_lv_pmos ad=0.19p pd=1.38u as=0 ps=0 w=1u l=1u
X3763 VSS.t2454 VDD VSS.t2453 VSS.t2452 sg13_lv_nmos ad=0.1428p pd=1.52u as=0 ps=0 w=0.42u l=1u
X3764 a_26565_13701# sg13cmos5l_buf_8_2.X VDD VDD sg13_lv_pmos ad=0.4088p pd=2.97u as=2.3367p ps=15.135u w=1.12u l=0.13u
X3765 VSS.t924 VDD VSS.t926 VSS.t925 sg13_lv_nmos ad=79.8f pd=0.8u as=0 ps=0 w=0.42u l=1u
X3766 VDD VSS.t1519 VDD VDD sg13_lv_pmos ad=0.34p pd=2.68u as=0 ps=0 w=1u l=1u
X3767 sg13cmos5l_buf_8_2.X a_19323_13726# VSS.t138 VSS.t3251 sg13_lv_nmos ad=0.1406p pd=1.12u as=0.1406p ps=1.12u w=0.74u l=0.13u
X3768 VDD VSS.t993 VDD VDD sg13_lv_pmos ad=0.34p pd=2.68u as=0 ps=0 w=1u l=1u
X3769 VSS.t2747 VDD VSS.t2749 VSS.t198 sg13_lv_nmos ad=79.8f pd=0.8u as=0 ps=0 w=0.42u l=1u
X3770 VDD VSS.t269 VDD VDD sg13_lv_pmos ad=0.34p pd=2.68u as=0 ps=0 w=1u l=1u
X3771 sg13cmos5l_or3_1_1.B a_14261_15238# VSS.t111 VSS.t204 sg13_lv_nmos ad=0.1406p pd=1.12u as=0.3293p ps=1.63u w=0.74u l=0.13u
X3772 VSS.t1877 VDD VSS.t1879 VSS.t1878 sg13_lv_nmos ad=79.8f pd=0.8u as=0 ps=0 w=0.42u l=1u
X3773 VSS.t408 VDD VSS.t407 VSS.t11 sg13_lv_nmos ad=0.1428p pd=1.52u as=0 ps=0 w=0.42u l=1u
X3774 VSS.t819 VDD VSS.t821 VSS.t820 sg13_lv_nmos ad=79.8f pd=0.8u as=0 ps=0 w=0.42u l=1u
X3775 VDD VSS.t1559 VDD VDD sg13_lv_pmos ad=0.34p pd=2.68u as=0 ps=0 w=1u l=1u
X3776 VDD VSS.t545 VDD VDD sg13_lv_pmos ad=0.34p pd=2.68u as=0 ps=0 w=1u l=1u
X3777 VSS.t1590 VDD VSS.t1592 VSS.t1591 sg13_lv_nmos ad=79.8f pd=0.8u as=0 ps=0 w=0.42u l=1u
X3778 VSS.t2714 VDD VSS.t2715 VSS.t198 sg13_lv_nmos ad=79.8f pd=0.8u as=0 ps=0 w=0.42u l=1u
X3779 VSS.t1475 VDD VSS.t1474 VSS.t1473 sg13_lv_nmos ad=0.1428p pd=1.52u as=0 ps=0 w=0.42u l=1u
X3780 a_12524_15960# sg13cmos5l_dlygate4sd3_1_8.A VDD VDD sg13_lv_pmos ad=0.2856p pd=2.36u as=0.2114p ps=1.54u w=0.84u l=0.13u
X3781 VDD VSS.t1244 VDD VDD sg13_lv_pmos ad=0.19p pd=1.38u as=0 ps=0 w=1u l=1u
X3782 VSS.t2067 VDD VSS.t2069 VSS.t2068 sg13_lv_nmos ad=79.8f pd=0.8u as=0 ps=0 w=0.42u l=1u
X3783 a_17529_14037# a_16587_13844# a_17327_13799# VDD sg13_lv_pmos ad=93.45f pd=0.865u as=0.2048p ps=1.63u w=0.42u l=0.13u
X3784 VDD VSS.t1214 VDD VDD sg13_lv_pmos ad=0.34p pd=2.68u as=0 ps=0 w=1u l=1u
X3785 VDD VSS.t2715 VDD VDD sg13_lv_pmos ad=0.34p pd=2.68u as=0 ps=0 w=1u l=1u
X3786 VSS.t2284 VDD VSS.t2283 VSS.t2282 sg13_lv_nmos ad=0.1428p pd=1.52u as=0 ps=0 w=0.42u l=1u
X3787 VDD VSS.t1991 VDD VDD sg13_lv_pmos ad=0.34p pd=2.68u as=0 ps=0 w=1u l=1u
X3788 VSS.t355 VDD VSS.t351 VSS.t354 sg13_lv_nmos ad=0.1428p pd=1.52u as=0 ps=0 w=0.42u l=1u
X3789 VDD VSS.t576 VDD VDD sg13_lv_pmos ad=0.19p pd=1.38u as=0 ps=0 w=1u l=1u
X3790 VSS.t2731 VDD VSS.t2730 VSS.t198 sg13_lv_nmos ad=0.1428p pd=1.52u as=0 ps=0 w=0.42u l=1u
X3791 VSS.t56 a_10703_15311# a_11370_15532# VSS.t3242 sg13_lv_nmos ad=0.1406p pd=1.12u as=0.2516p ps=2.16u w=0.74u l=0.13u
X3792 a_18789_15277# a_18789_15277# VSS.t11 VSS.t18 sg13_lv_nmos ad=0.111p pd=1.34u as=4.11262p ps=27.15u w=0.3u l=0.13u
X3793 VSS.t605 VDD VSS.t602 VSS.t604 sg13_lv_nmos ad=0.1428p pd=1.52u as=0 ps=0 w=0.42u l=1u
X3794 VDD VSS.t1909 VDD VDD sg13_lv_pmos ad=0.19p pd=1.38u as=0 ps=0 w=1u l=1u
X3795 VSS.t1952 VDD VSS.t1954 VSS.t1953 sg13_lv_nmos ad=79.8f pd=0.8u as=0 ps=0 w=0.42u l=1u
X3796 VSS.t411 VDD VSS.t412 VSS.t11 sg13_lv_nmos ad=79.8f pd=0.8u as=0 ps=0 w=0.42u l=1u
X3797 VSS.t1258 VDD VSS.t1257 VSS.t1154 sg13_lv_nmos ad=0.1428p pd=1.52u as=0 ps=0 w=0.42u l=1u
X3798 VDD VSS.t1674 VDD VDD sg13_lv_pmos ad=0.34p pd=2.68u as=0 ps=0 w=1u l=1u
X3799 a_6346_14452# a_6789_14495# a_6086_14922# VSS.t60 sg13_lv_nmos ad=79.8f pd=0.8u as=0.1296p ps=1.52u w=0.42u l=0.13u
X3800 VDD VSS.t2256 VDD VDD sg13_lv_pmos ad=0.19p pd=1.38u as=0 ps=0 w=1u l=1u
X3801 VSS.t2474 VDD VSS.t2473 VSS.t2472 sg13_lv_nmos ad=0.1428p pd=1.52u as=0 ps=0 w=0.42u l=1u
X3802 VSS.t2294 VDD VSS.t2296 VSS.t2295 sg13_lv_nmos ad=79.8f pd=0.8u as=0 ps=0 w=0.42u l=1u
X3803 VDD VSS.t2094 VDD VDD sg13_lv_pmos ad=0.19p pd=1.38u as=0 ps=0 w=1u l=1u
X3804 VDD VSS.t2046 VDD VDD sg13_lv_pmos ad=0.34p pd=2.68u as=0 ps=0 w=1u l=1u
X3805 VSS.t1862 VDD VSS.t1864 VSS.t1863 sg13_lv_nmos ad=79.8f pd=0.8u as=0 ps=0 w=0.42u l=1u
X3806 VDD VSS.t3164 VDD VDD sg13_lv_pmos ad=0.19p pd=1.38u as=0 ps=0 w=1u l=1u
X3807 VDD VSS.t2675 VDD VDD sg13_lv_pmos ad=0.34p pd=2.68u as=0 ps=0 w=1u l=1u
X3808 VSS.t2725 VDD VSS.t2724 VSS.t198 sg13_lv_nmos ad=0.1428p pd=1.52u as=0 ps=0 w=0.42u l=1u
X3809 VSS.t501 VDD VSS.t501 VSS.t500 sg13_lv_nmos ad=0.1428p pd=1.52u as=0 ps=0 w=0.42u l=1u
X3810 VDD VSS.t883 VDD VDD sg13_lv_pmos ad=0.34p pd=2.68u as=0 ps=0 w=1u l=1u
X3811 VSS.t704 VDD VSS.t703 VSS.t702 sg13_lv_nmos ad=0.1428p pd=1.52u as=0 ps=0 w=0.42u l=1u
X3812 VSS.t2102 VDD VSS.t2104 VSS.t2103 sg13_lv_nmos ad=79.8f pd=0.8u as=0 ps=0 w=0.42u l=1u
X3813 VSS.t420 VDD VSS.t421 VSS.t11 sg13_lv_nmos ad=79.8f pd=0.8u as=0 ps=0 w=0.42u l=1u
X3814 VDD VSS.t1504 VDD VDD sg13_lv_pmos ad=0.34p pd=2.68u as=0 ps=0 w=1u l=1u
X3815 VDD VSS.t2413 VDD VDD sg13_lv_pmos ad=0.34p pd=2.68u as=0 ps=0 w=1u l=1u
X3816 VDD a_17126_15238# a_17238_15302# VDD sg13_lv_pmos ad=0.2254p pd=1.53u as=0.34p ps=2.68u w=1u l=0.5u
X3817 sg13cmos5l_dlygate4sd3_1_3.A a_4842_15532# VDD VDD sg13_lv_pmos ad=0.3808p pd=2.92u as=0.2128p ps=1.5u w=1.12u l=0.13u
X3818 VSS.t1605 VDD VSS.t1604 VSS.t1603 sg13_lv_nmos ad=0.1428p pd=1.52u as=0 ps=0 w=0.42u l=1u
X3819 VDD VSS.t2361 VDD VDD sg13_lv_pmos ad=0.19p pd=1.38u as=0 ps=0 w=1u l=1u
X3820 VSS.t2022 VDD VSS.t2021 VSS.t2020 sg13_lv_nmos ad=0.1428p pd=1.52u as=0 ps=0 w=0.42u l=1u
X3821 VSS.t2723 VDD VSS.t2721 VSS.t198 sg13_lv_nmos ad=0.1428p pd=1.52u as=0 ps=0 w=0.42u l=1u
X3822 VSS.t894 VDD VSS.t896 VSS.t895 sg13_lv_nmos ad=79.8f pd=0.8u as=0 ps=0 w=0.42u l=1u
X3823 VSS.t924 VDD VSS.t926 VSS.t925 sg13_lv_nmos ad=79.8f pd=0.8u as=0 ps=0 w=0.42u l=1u
X3824 VDD VSS.t1210 VDD VDD sg13_lv_pmos ad=0.34p pd=2.68u as=0 ps=0 w=1u l=1u
X3825 VDD VSS.t187 VDD VDD sg13_lv_pmos ad=0.34p pd=2.68u as=0 ps=0 w=1u l=1u
X3826 a_7631_14845# a_6789_14495# a_6372_14488# VDD sg13_lv_pmos ad=0.2048p pd=1.63u as=0.34p ps=2.68u w=1u l=0.13u
X3827 VDD VSS.t2079 VDD VDD sg13_lv_pmos ad=0.19p pd=1.38u as=0 ps=0 w=1u l=1u
X3828 sg13cmos5l_buf_8_2.X a_19323_13726# VSS.t698 VSS.t3257 sg13_lv_nmos ad=0.1406p pd=1.12u as=0.1406p ps=1.12u w=0.74u l=0.13u
X3829 VDD VSS.t1854 VDD VDD sg13_lv_pmos ad=0.19p pd=1.38u as=0 ps=0 w=1u l=1u
X3830 VDD VSS.t2641 VDD VDD sg13_lv_pmos ad=0.19p pd=1.38u as=0 ps=0 w=1u l=1u
X3831 VDD VSS.t2694 VDD VDD sg13_lv_pmos ad=0.19p pd=1.38u as=0 ps=0 w=1u l=1u
X3832 VSS.t1897 VDD VSS.t1899 VSS.t1898 sg13_lv_nmos ad=79.8f pd=0.8u as=0 ps=0 w=0.42u l=1u
X3833 VSS.t1535 VDD VSS.t1534 VSS.t1533 sg13_lv_nmos ad=0.1428p pd=1.52u as=0 ps=0 w=0.42u l=1u
X3834 VSS.t3052 VDD VSS.t3051 VSS.t3050 sg13_lv_nmos ad=0.1428p pd=1.52u as=0 ps=0 w=0.42u l=1u
X3835 VSS.t2269 VDD VSS.t2268 VSS.t2267 sg13_lv_nmos ad=0.1428p pd=1.52u as=0 ps=0 w=0.42u l=1u
X3836 VSS.t2439 VDD VSS.t2441 VSS.t2440 sg13_lv_nmos ad=79.8f pd=0.8u as=0 ps=0 w=0.42u l=1u
X3837 VDD VSS.t21 VDD VDD sg13_lv_pmos ad=0.34p pd=2.68u as=0 ps=0 w=1u l=1u
X3838 VDD VSS.t1248 VDD VDD sg13_lv_pmos ad=0.19p pd=1.38u as=0 ps=0 w=1u l=1u
X3839 VSS.t2344 VDD VSS.t2343 VSS.t2342 sg13_lv_nmos ad=0.1428p pd=1.52u as=0 ps=0 w=0.42u l=1u
X3840 VSS.t2705 VDD VSS.t2706 VSS.t198 sg13_lv_nmos ad=79.8f pd=0.8u as=0 ps=0 w=0.42u l=1u
X3841 VDD VSS.t2446 VDD VDD sg13_lv_pmos ad=0.19p pd=1.38u as=0 ps=0 w=1u l=1u
X3842 VSS.t236 a_21166_16263# sg13cmos5l_dfrbpq_1_6.D VSS.t235 sg13_lv_nmos ad=0.1426p pd=1.16u as=0.2516p ps=2.16u w=0.74u l=0.13u
X3843 VSS.t1196 VDD VSS.t1197 VSS.t1154 sg13_lv_nmos ad=79.8f pd=0.8u as=0 ps=0 w=0.42u l=1u
X3844 counter_value_o[3] a_16552_15996# VDD VDD sg13_lv_pmos ad=0.42p pd=2.99u as=0.2114p ps=1.54u w=1.12u l=0.13u
X3845 a_25786_15960# sg13cmos5l_o21ai_1_3.Y VSS.t155 VSS.t224 sg13_lv_nmos ad=0.1428p pd=1.52u as=79.8f ps=0.8u w=0.42u l=0.13u
X3846 VDD VSS.t599 VDD VDD sg13_lv_pmos ad=0.19p pd=1.38u as=0 ps=0 w=1u l=1u
X3847 VSS.t2052 VDD VSS.t2054 VSS.t2053 sg13_lv_nmos ad=79.8f pd=0.8u as=0 ps=0 w=0.42u l=1u
X3848 VDD sg13cmos5l_o21ai_1_2.B1 sg13cmos5l_o21ai_1_2.Y VDD sg13_lv_pmos ad=0.3808p pd=2.92u as=0.2128p ps=1.5u w=1.12u l=0.15u
X3849 VDD VSS.t1206 VDD VDD sg13_lv_pmos ad=0.34p pd=2.68u as=0 ps=0 w=1u l=1u
X3850 VDD VSS.t2706 VDD VDD sg13_lv_pmos ad=0.34p pd=2.68u as=0 ps=0 w=1u l=1u
X3851 VSS.t2007 VDD VSS.t2006 VSS.t2005 sg13_lv_nmos ad=0.1428p pd=1.52u as=0 ps=0 w=0.42u l=1u
X3852 VSS.t2647 VDD VSS.t2648 VSS.t198 sg13_lv_nmos ad=79.8f pd=0.8u as=0 ps=0 w=0.42u l=1u
X3853 VDD a_18202_15202# a_17921_15424# VDD sg13_lv_pmos ad=0.1523p pd=1.38u as=0.34p ps=2.68u w=1u l=0.5u
X3854 VSS.t1285 VDD VSS.t1284 VSS.t1154 sg13_lv_nmos ad=0.1428p pd=1.52u as=0 ps=0 w=0.42u l=1u
X3855 VDD VSS.t2071 VDD VDD sg13_lv_pmos ad=0.34p pd=2.68u as=0 ps=0 w=1u l=1u
X3856 VSS.t314 VDD VSS.t316 VSS.t315 sg13_lv_nmos ad=79.8f pd=0.8u as=0 ps=0 w=0.42u l=1u
X3857 VDD VSS.t1262 VDD VDD sg13_lv_pmos ad=0.34p pd=2.68u as=0 ps=0 w=1u l=1u
X3858 VDD VSS.t2759 VDD VDD sg13_lv_pmos ad=0.34p pd=2.68u as=0 ps=0 w=1u l=1u
X3859 VSS.t2459 VDD VSS.t2458 VSS.t2457 sg13_lv_nmos ad=0.1428p pd=1.52u as=0 ps=0 w=0.42u l=1u
X3860 VDD VSS.t1524 VDD VDD sg13_lv_pmos ad=0.34p pd=2.68u as=0 ps=0 w=1u l=1u
X3861 VDD VSS.t2241 VDD VDD sg13_lv_pmos ad=0.19p pd=1.38u as=0 ps=0 w=1u l=1u
X3862 VSS.t2750 VDD VSS.t2752 VSS.t198 sg13_lv_nmos ad=79.8f pd=0.8u as=0 ps=0 w=0.42u l=1u
X3863 VDD VSS.t2031 VDD VDD sg13_lv_pmos ad=0.34p pd=2.68u as=0 ps=0 w=1u l=1u
X3864 VSS.t1847 VDD VSS.t1849 VSS.t1848 sg13_lv_nmos ad=79.8f pd=0.8u as=0 ps=0 w=0.42u l=1u
X3865 VDD VSS.t791 VDD VDD sg13_lv_pmos ad=0.19p pd=1.38u as=0 ps=0 w=1u l=1u
X3866 VDD VSS.t1529 VDD VDD sg13_lv_pmos ad=0.34p pd=2.68u as=0 ps=0 w=1u l=1u
X3867 VDD VSS.t3149 VDD VDD sg13_lv_pmos ad=0.19p pd=1.38u as=0 ps=0 w=1u l=1u
X3868 VDD VSS.t2668 VDD VDD sg13_lv_pmos ad=0.34p pd=2.68u as=0 ps=0 w=1u l=1u
X3869 VSS.t879 VDD VSS.t878 VSS.t877 sg13_lv_nmos ad=0.1428p pd=1.52u as=0 ps=0 w=0.42u l=1u
X3870 a_26148_14040# a_26667_13844# a_27407_13799# VSS.t69 sg13_lv_nmos ad=0.3473p pd=2.71u as=0.12665p ps=1.145u w=0.74u l=0.13u
X3871 VSS.t2769 VDD VSS.t2768 VSS.t198 sg13_lv_nmos ad=0.1428p pd=1.52u as=0 ps=0 w=0.42u l=1u
X3872 VDD VSS.t1489 VDD VDD sg13_lv_pmos ad=0.34p pd=2.68u as=0 ps=0 w=1u l=1u
X3873 VDD VSS.t2398 VDD VDD sg13_lv_pmos ad=0.34p pd=2.68u as=0 ps=0 w=1u l=1u
X3874 VSS.t2289 VDD VSS.t2288 VSS.t2287 sg13_lv_nmos ad=0.1428p pd=1.52u as=0 ps=0 w=0.42u l=1u
X3875 VSS.t894 VDD VSS.t896 VSS.t895 sg13_lv_nmos ad=79.8f pd=0.8u as=0 ps=0 w=0.42u l=1u
X3876 VDD VSS.t503 VDD VDD sg13_lv_pmos ad=0.19p pd=1.38u as=0 ps=0 w=1u l=1u
X3877 VDD VSS.t1914 VDD VDD sg13_lv_pmos ad=0.19p pd=1.38u as=0 ps=0 w=1u l=1u
X3878 VSS.t2714 VDD VSS.t2713 VSS.t198 sg13_lv_nmos ad=0.1428p pd=1.52u as=0 ps=0 w=0.42u l=1u
X3879 VSS.t1957 VDD VSS.t1959 VSS.t1958 sg13_lv_nmos ad=79.8f pd=0.8u as=0 ps=0 w=0.42u l=1u
X3880 VDD VSS.t806 VDD VDD sg13_lv_pmos ad=0.19p pd=1.38u as=0 ps=0 w=1u l=1u
X3881 VSS.t1229 VDD VSS.t1230 VSS.t1154 sg13_lv_nmos ad=79.8f pd=0.8u as=0 ps=0 w=0.42u l=1u
X3882 VDD VSS.t2233 VDD VDD sg13_lv_pmos ad=0.34p pd=2.68u as=0 ps=0 w=1u l=1u
X3883 VDD VSS.t59 VDD VDD sg13_lv_pmos ad=0.34p pd=2.68u as=0 ps=0 w=1u l=1u
X3884 VSS.t1193 VDD VSS.t1192 VSS.t1154 sg13_lv_nmos ad=0.1428p pd=1.52u as=0 ps=0 w=0.42u l=1u
X3885 VDD VSS.t2634 VDD VDD sg13_lv_pmos ad=0.19p pd=1.38u as=0 ps=0 w=1u l=1u
X3886 VDD VSS.t384 VDD VDD sg13_lv_pmos ad=0.34p pd=2.68u as=0 ps=0 w=1u l=1u
X3887 VSS.t1520 VDD VSS.t1519 VSS.t1518 sg13_lv_nmos ad=0.1428p pd=1.52u as=0 ps=0 w=0.42u l=1u
X3888 VSS.t3037 VDD VSS.t3036 VSS.t3035 sg13_lv_nmos ad=0.1428p pd=1.52u as=0 ps=0 w=0.42u l=1u
X3889 VSS.t2254 VDD VSS.t2253 VSS.t2252 sg13_lv_nmos ad=0.1428p pd=1.52u as=0 ps=0 w=0.42u l=1u
X3890 VSS.t1867 VDD VSS.t1869 VSS.t1868 sg13_lv_nmos ad=79.8f pd=0.8u as=0 ps=0 w=0.42u l=1u
X3891 VSS.t180 a_27407_13799# a_28074_14020# VSS.t195 sg13_lv_nmos ad=0.1406p pd=1.12u as=0.2516p ps=2.16u w=0.74u l=0.13u
X3892 VSS.t1156 VDD VSS.t1157 VSS.t1154 sg13_lv_nmos ad=79.8f pd=0.8u as=0 ps=0 w=0.42u l=1u
X3893 VSS.t351 VDD VSS.t351 VSS.t353 sg13_lv_nmos ad=79.8f pd=0.8u as=0 ps=0 w=0.42u l=1u
X3894 VSS.t184 sg13cmos5l_dlygate4sd3_1_8.X a_7829_15238# VSS.t3191 sg13_lv_nmos ad=0.1898p pd=1.36u as=0.2516p ps=2.16u w=0.74u l=0.13u
X3895 VDD VSS.t1238 VDD VDD sg13_lv_pmos ad=0.19p pd=1.38u as=0 ps=0 w=1u l=1u
X3896 VDD VSS.t2736 VDD VDD sg13_lv_pmos ad=0.19p pd=1.38u as=0 ps=0 w=1u l=1u
X3897 VDD VSS.t629 VDD VDD sg13_lv_pmos ad=0.34p pd=2.68u as=0 ps=0 w=1u l=1u
X3898 VDD VSS.t1474 VDD VDD sg13_lv_pmos ad=0.34p pd=2.68u as=0 ps=0 w=1u l=1u
X3899 VSS.t2660 VDD VSS.t2661 VSS.t198 sg13_lv_nmos ad=79.8f pd=0.8u as=0 ps=0 w=0.42u l=1u
X3900 VDD VSS.t2383 VDD VDD sg13_lv_pmos ad=0.34p pd=2.68u as=0 ps=0 w=1u l=1u
X3901 VSS.t2444 VDD VSS.t2443 VSS.t2442 sg13_lv_nmos ad=0.1428p pd=1.52u as=0 ps=0 w=0.42u l=1u
X3902 VDD VSS.t406 VDD VDD sg13_lv_pmos ad=0.19p pd=1.38u as=0 ps=0 w=1u l=1u
X3903 VSS.t2274 VDD VSS.t2273 VSS.t2272 sg13_lv_nmos ad=0.1428p pd=1.52u as=0 ps=0 w=0.42u l=1u
X3904 VSS.t909 VDD VSS.t908 VSS.t907 sg13_lv_nmos ad=0.1428p pd=1.52u as=0 ps=0 w=0.42u l=1u
X3905 VDD VSS.t1894 VDD VDD sg13_lv_pmos ad=0.19p pd=1.38u as=0 ps=0 w=1u l=1u
X3906 VSS.t1610 VDD VSS.t1609 VSS.t1608 sg13_lv_nmos ad=0.1428p pd=1.52u as=0 ps=0 w=0.42u l=1u
X3907 VSS.t1992 VDD VSS.t1991 VSS.t1990 sg13_lv_nmos ad=0.1428p pd=1.52u as=0 ps=0 w=0.42u l=1u
X3908 VDD VSS.t961 VDD VDD sg13_lv_pmos ad=0.19p pd=1.38u as=0 ps=0 w=1u l=1u
X3909 VSS.t1211 VDD VSS.t1210 VSS.t1154 sg13_lv_nmos ad=0.1428p pd=1.52u as=0 ps=0 w=0.42u l=1u
X3910 VSS.t2726 VDD VSS.t2725 VSS.t198 sg13_lv_nmos ad=0.1428p pd=1.52u as=0 ps=0 w=0.42u l=1u
X3911 VDD VSS.t2301 VDD VDD sg13_lv_pmos ad=0.19p pd=1.38u as=0 ps=0 w=1u l=1u
X3912 VSS.t541 VDD VSS.t543 VSS.t542 sg13_lv_nmos ad=79.8f pd=0.8u as=0 ps=0 w=0.42u l=1u
X3913 VDD VSS.t373 VDD VDD sg13_lv_pmos ad=0.34p pd=2.68u as=0 ps=0 w=1u l=1u
X3914 VDD VSS.t1254 VDD VDD sg13_lv_pmos ad=0.34p pd=2.68u as=0 ps=0 w=1u l=1u
X3915 VDD VSS.t2056 VDD VDD sg13_lv_pmos ad=0.34p pd=2.68u as=0 ps=0 w=1u l=1u
X3916 VDD VSS.t2426 VDD VDD sg13_lv_pmos ad=0.19p pd=1.38u as=0 ps=0 w=1u l=1u
X3917 VDD VSS.t2084 VDD VDD sg13_lv_pmos ad=0.19p pd=1.38u as=0 ps=0 w=1u l=1u
X3918 VSS.t1907 VDD VSS.t1909 VSS.t1908 sg13_lv_nmos ad=79.8f pd=0.8u as=0 ps=0 w=0.42u l=1u
X3919 VDD VSS.t286 VDD VDD sg13_lv_pmos ad=0.34p pd=2.68u as=0 ps=0 w=1u l=1u
X3920 sg13cmos5l_and2_1_2.X a_8685_14832# VSS.t1 VSS.t228 sg13_lv_nmos ad=0.2516p pd=2.16u as=0.1331p ps=1.12u w=0.74u l=0.13u
X3921 VDD VSS.t1859 VDD VDD sg13_lv_pmos ad=0.19p pd=1.38u as=0 ps=0 w=1u l=1u
X3922 VDD VSS.t2697 VDD VDD sg13_lv_pmos ad=0.19p pd=1.38u as=0 ps=0 w=1u l=1u
X3923 VSS.t626 VDD VSS.t626 VSS.t627 sg13_lv_nmos ad=79.8f pd=0.8u as=0 ps=0 w=0.42u l=1u
X3924 VSS.t1540 VDD VSS.t1539 VSS.t1538 sg13_lv_nmos ad=0.1428p pd=1.52u as=0 ps=0 w=0.42u l=1u
X3925 VSS.t2742 VDD VSS.t2743 VSS.t198 sg13_lv_nmos ad=79.8f pd=0.8u as=0 ps=0 w=0.42u l=1u
X3926 VDD VSS.t2626 VDD VDD sg13_lv_pmos ad=0.19p pd=1.38u as=0 ps=0 w=1u l=1u
X3927 VSS.t2239 VDD VSS.t2238 VSS.t2237 sg13_lv_nmos ad=0.1428p pd=1.52u as=0 ps=0 w=0.42u l=1u
X3928 sg13cmos5l_a21oi_1_3.Y sg13cmos5l_a21oi_1_3.A1 a_25203_13320# VSS.t126 sg13_lv_nmos ad=0.1406p pd=1.12u as=0.1406p ps=1.12u w=0.74u l=0.13u
X3929 VSS.t879 VDD VSS.t878 VSS.t877 sg13_lv_nmos ad=0.1428p pd=1.52u as=0 ps=0 w=0.42u l=1u
X3930 VSS.t1247 VDD VSS.t1248 VSS.t1154 sg13_lv_nmos ad=79.8f pd=0.8u as=0 ps=0 w=0.42u l=1u
X3931 VSS.t3 VDD VSS.t3 VSS.t378 sg13_lv_nmos ad=79.8f pd=0.8u as=0 ps=0 w=0.42u l=1u
X3932 VSS.t438 VDD VSS.t439 VSS.t11 sg13_lv_nmos ad=79.8f pd=0.8u as=0 ps=0 w=0.42u l=1u
X3933 VDD VSS.t135 VDD VDD sg13_lv_pmos ad=0.19p pd=1.38u as=0 ps=0 w=1u l=1u
X3934 VDD VSS.t836 VDD VDD sg13_lv_pmos ad=0.19p pd=1.38u as=0 ps=0 w=1u l=1u
X3935 VDD VSS.t1514 VDD VDD sg13_lv_pmos ad=0.34p pd=2.68u as=0 ps=0 w=1u l=1u
X3936 a_18202_15202# sg13cmos5l_dfrbpq_1_2.Q VDD VDD sg13_lv_pmos ad=0.1428p pd=1.52u as=0.1523p ps=1.38u w=0.42u l=0.13u
X3937 sg13cmos5l_buf_8_2.A a_15579_14854# VSS.t21 VSS.t3243 sg13_lv_nmos ad=0.1406p pd=1.12u as=0.1406p ps=1.12u w=0.74u l=0.13u
X3938 VSS.t573 VDD VSS.t87 VSS.t691 sg13_lv_nmos ad=0.1428p pd=1.52u as=0 ps=0 w=0.42u l=1u
X3939 VSS.t2314 VDD VSS.t2313 VSS.t2312 sg13_lv_nmos ad=0.1428p pd=1.52u as=0 ps=0 w=0.42u l=1u
X3940 VSS.t2670 VDD VSS.t2671 VSS.t198 sg13_lv_nmos ad=79.8f pd=0.8u as=0 ps=0 w=0.42u l=1u
X3941 VDD VSS.t274 VDD VDD sg13_lv_pmos ad=0.34p pd=2.68u as=0 ps=0 w=1u l=1u
X3942 VSS.t7 sg13cmos5l_or3_1_1.B a_16168_15996# VSS.t3184 sg13_lv_nmos ad=0.14875p pd=1.16u as=0.187p ps=1.78u w=0.55u l=0.13u
X3943 a_23736_14464# sg13cmos5l_or3_1_2.B VDD VDD sg13_lv_pmos ad=0.2128p pd=1.5u as=0.3808p ps=2.92u w=1.12u l=0.15u
X3944 VDD VSS.t596 VDD VDD sg13_lv_pmos ad=0.34p pd=2.68u as=0 ps=0 w=1u l=1u
X3945 VDD VSS.t1722 VDD VDD sg13_lv_pmos ad=0.19p pd=1.38u as=0 ps=0 w=1u l=1u
X3946 VDD VSS.t3004 VDD VDD sg13_lv_pmos ad=0.19p pd=1.38u as=0 ps=0 w=1u l=1u
X3947 VSS.t2741 VDD VSS.t2742 VSS.t198 sg13_lv_nmos ad=79.8f pd=0.8u as=0 ps=0 w=0.42u l=1u
X3948 VDD VSS.t503 VDD VDD sg13_lv_pmos ad=0.19p pd=1.38u as=0 ps=0 w=1u l=1u
X3949 VDD VSS.t928 VDD VDD sg13_lv_pmos ad=0.34p pd=2.68u as=0 ps=0 w=1u l=1u
X3950 a_24935_14020# sg13cmos5l_or3_1_1.C a_24841_13726# VDD sg13_lv_pmos ad=0.19p pd=1.38u as=0.34p ps=2.68u w=1u l=0.13u
X3951 VSS.t501 VDD VSS.t501 VSS.t500 sg13_lv_nmos ad=0.1428p pd=1.52u as=0 ps=0 w=0.42u l=1u
X3952 VSS.t2650 VDD VSS.t2651 VSS.t198 sg13_lv_nmos ad=79.8f pd=0.8u as=0 ps=0 w=0.42u l=1u
X3953 VDD VSS.t2076 VDD VDD sg13_lv_pmos ad=0.34p pd=2.68u as=0 ps=0 w=1u l=1u
X3954 VDD VSS.t1245 VDD VDD sg13_lv_pmos ad=0.34p pd=2.68u as=0 ps=0 w=1u l=1u
X3955 VDD VSS.t2742 VDD VDD sg13_lv_pmos ad=0.34p pd=2.68u as=0 ps=0 w=1u l=1u
X3956 VSS.t3022 VDD VSS.t3024 VSS.t3023 sg13_lv_nmos ad=79.8f pd=0.8u as=0 ps=0 w=0.42u l=1u
X3957 VDD VSS.t338 VDD VDD sg13_lv_pmos ad=0.19p pd=1.38u as=0 ps=0 w=1u l=1u
X3958 a_2890_15457# a_3333_15213# a_2630_15234# VSS.t254 sg13_lv_nmos ad=79.8f pd=0.8u as=0.1296p ps=1.52u w=0.42u l=0.13u
X3959 VDD VSS.t424 VDD VDD sg13_lv_pmos ad=0.19p pd=1.38u as=0 ps=0 w=1u l=1u
X3960 a_22030_15423# a_22145_15424# VSS.t201 VSS.t200 sg13_lv_nmos ad=0.1428p pd=1.52u as=0.1426p ps=1.16u w=0.42u l=0.5u
X3961 VDD VSS.t306 VDD VDD sg13_lv_pmos ad=0.19p pd=1.38u as=0 ps=0 w=1u l=1u
X3962 VSS.t635 VDD VSS.t761 VSS.t760 sg13_lv_nmos ad=0.1428p pd=1.52u as=0 ps=0 w=0.42u l=1u
X3963 VDD VSS.t2246 VDD VDD sg13_lv_pmos ad=0.19p pd=1.38u as=0 ps=0 w=1u l=1u
X3964 VDD VSS.t991 VDD VDD sg13_lv_pmos ad=0.19p pd=1.38u as=0 ps=0 w=1u l=1u
X3965 VDD VSS.t2036 VDD VDD sg13_lv_pmos ad=0.34p pd=2.68u as=0 ps=0 w=1u l=1u
X3966 VSS.t420 VDD VSS.t419 VSS.t11 sg13_lv_nmos ad=0.1428p pd=1.52u as=0 ps=0 w=0.42u l=1u
X3967 VSS.t580 VDD VSS.t580 VSS.t581 sg13_lv_nmos ad=0.1428p pd=1.52u as=0 ps=0 w=0.42u l=1u
X3968 VSS.t1852 VDD VSS.t1854 VSS.t1853 sg13_lv_nmos ad=79.8f pd=0.8u as=0 ps=0 w=0.42u l=1u
X3969 VSS.t596 VDD VSS.t599 VSS.t735 sg13_lv_nmos ad=79.8f pd=0.8u as=0 ps=0 w=0.42u l=1u
X3970 VDD VSS.t1534 VDD VDD sg13_lv_pmos ad=0.34p pd=2.68u as=0 ps=0 w=1u l=1u
X3971 VDD VSS.t3154 VDD VDD sg13_lv_pmos ad=0.19p pd=1.38u as=0 ps=0 w=1u l=1u
X3972 VSS.t2648 VDD VSS.t2649 VSS.t198 sg13_lv_nmos ad=79.8f pd=0.8u as=0 ps=0 w=0.42u l=1u
X3973 VSS.t336 VDD VSS.t101 VSS.t335 sg13_lv_nmos ad=0.1428p pd=1.52u as=0 ps=0 w=0.42u l=1u
X3974 a_21477_14495# sg13cmos5l_buf_8_2.X VDD VDD sg13_lv_pmos ad=0.4088p pd=2.97u as=2.3367p ps=15.135u w=1.12u l=0.13u
X3975 VDD VSS.t468 VDD VDD sg13_lv_pmos ad=0.34p pd=2.68u as=0 ps=0 w=1u l=1u
X3976 VDD VSS.t1871 VDD VDD sg13_lv_pmos ad=0.34p pd=2.68u as=0 ps=0 w=1u l=1u
X3977 VDD VSS.t2703 VDD VDD sg13_lv_pmos ad=0.34p pd=2.68u as=0 ps=0 w=1u l=1u
X3978 VSS.t909 VDD VSS.t908 VSS.t907 sg13_lv_nmos ad=0.1428p pd=1.52u as=0 ps=0 w=0.42u l=1u
X3979 VSS.t2750 VDD VSS.t2871 VSS.t198 sg13_lv_nmos ad=0.1428p pd=1.52u as=0 ps=0 w=0.42u l=1u
X3980 VDD VSS.t583 VDD VDD sg13_lv_pmos ad=0.19p pd=1.38u as=0 ps=0 w=1u l=1u
X3981 VDD VSS.t891 VDD VDD sg13_lv_pmos ad=0.19p pd=1.38u as=0 ps=0 w=1u l=1u
X3982 VSS.t580 VDD VSS.t578 VSS.t706 sg13_lv_nmos ad=0.1428p pd=1.52u as=0 ps=0 w=0.42u l=1u
X3983 VSS.t2259 VDD VSS.t2258 VSS.t2257 sg13_lv_nmos ad=0.1428p pd=1.52u as=0 ps=0 w=0.42u l=1u
X3984 VSS.t1269 VDD VSS.t1269 VSS.t1154 sg13_lv_nmos ad=0.1428p pd=1.52u as=0 ps=0 w=0.42u l=1u
X3985 VDD VSS.t1286 VDD VDD sg13_lv_pmos ad=0.19p pd=1.38u as=0 ps=0 w=1u l=1u
X3986 VSS.t1595 VDD VSS.t1594 VSS.t1593 sg13_lv_nmos ad=0.1428p pd=1.52u as=0 ps=0 w=0.42u l=1u
X3987 VSS.t2642 VDD VSS.t2643 VSS.t198 sg13_lv_nmos ad=79.8f pd=0.8u as=0 ps=0 w=0.42u l=1u
X3988 VSS.t2717 VDD VSS.t2715 VSS.t198 sg13_lv_nmos ad=0.1428p pd=1.52u as=0 ps=0 w=0.42u l=1u
X3989 VDD VSS.t2463 VDD VDD sg13_lv_pmos ad=0.34p pd=2.68u as=0 ps=0 w=1u l=1u
X3990 VSS.t1962 VDD VSS.t1964 VSS.t1963 sg13_lv_nmos ad=79.8f pd=0.8u as=0 ps=0 w=0.42u l=1u
X3991 VDD VSS.t2656 VDD VDD sg13_lv_pmos ad=0.19p pd=1.38u as=0 ps=0 w=1u l=1u
X3992 VSS.t2299 VDD VSS.t2298 VSS.t2297 sg13_lv_nmos ad=0.1428p pd=1.52u as=0 ps=0 w=0.42u l=1u
X3993 a_6682_13690# sg13cmos5l_dlygate4sd3_1_0.A VDD VDD sg13_lv_pmos ad=0.1428p pd=1.52u as=0.1523p ps=1.38u w=0.42u l=0.13u
X3994 VDD VSS.t614 VDD VDD sg13_lv_pmos ad=0.34p pd=2.68u as=0 ps=0 w=1u l=1u
X3995 VDD VSS.t828 VDD VDD sg13_lv_pmos ad=0.34p pd=2.68u as=0 ps=0 w=1u l=1u
X3996 VDD VSS.t2949 VDD VDD sg13_lv_pmos ad=0.19p pd=1.38u as=0 ps=0 w=1u l=1u
X3997 VSS.t1313 VDD VSS.t1312 VSS.t1154 sg13_lv_nmos ad=0.1428p pd=1.52u as=0 ps=0 w=0.42u l=1u
X3998 VDD VSS.t2411 VDD VDD sg13_lv_pmos ad=0.19p pd=1.38u as=0 ps=0 w=1u l=1u
X3999 VDD VSS.t2069 VDD VDD sg13_lv_pmos ad=0.19p pd=1.38u as=0 ps=0 w=1u l=1u
X4000 VSS.t2072 VDD VSS.t2071 VSS.t2070 sg13_lv_nmos ad=0.1428p pd=1.52u as=0 ps=0 w=0.42u l=1u
X4001 VDD VSS.t766 VDD VDD sg13_lv_pmos ad=0.19p pd=1.38u as=0 ps=0 w=1u l=1u
X4002 VDD VSS.t132 VDD VDD sg13_lv_pmos ad=0.34p pd=2.68u as=0 ps=0 w=1u l=1u
X4003 VSS.t23 VDD VSS.t23 VSS.t716 sg13_lv_nmos ad=0.1428p pd=1.52u as=0 ps=0 w=0.42u l=1u
X4004 VDD VSS.t1844 VDD VDD sg13_lv_pmos ad=0.19p pd=1.38u as=0 ps=0 w=1u l=1u
X4005 VDD VSS.t2363 VDD VDD sg13_lv_pmos ad=0.34p pd=2.68u as=0 ps=0 w=1u l=1u
X4006 VSS.t1525 VDD VSS.t1524 VSS.t1523 sg13_lv_nmos ad=0.1428p pd=1.52u as=0 ps=0 w=0.42u l=1u
X4007 VSS.t227 VDD VSS.t355 VSS.t359 sg13_lv_nmos ad=0.1428p pd=1.52u as=0 ps=0 w=0.42u l=1u
X4008 VDD VSS.t548 VDD VDD sg13_lv_pmos ad=0.19p pd=1.38u as=0 ps=0 w=1u l=1u
X4009 VDD VSS.t394 VDD VDD sg13_lv_pmos ad=0.34p pd=2.68u as=0 ps=0 w=1u l=1u
X4010 VSS.t455 VDD VSS.t56 VSS.t456 sg13_lv_nmos ad=79.8f pd=0.8u as=0 ps=0 w=0.42u l=1u
X4011 VDD VSS.t881 VDD VDD sg13_lv_pmos ad=0.19p pd=1.38u as=0 ps=0 w=1u l=1u
X4012 VDD VSS.t1939 VDD VDD sg13_lv_pmos ad=0.19p pd=1.38u as=0 ps=0 w=1u l=1u
X4013 VDD VSS.t1178 VDD VDD sg13_lv_pmos ad=0.34p pd=2.68u as=0 ps=0 w=1u l=1u
X4014 VDD a_7631_14845# a_7888_14726# VDD sg13_lv_pmos ad=2.42015p pd=15.68u as=79.8f ps=0.8u w=0.42u l=0.13u
X4015 VSS.t614 VDD VSS.t617 VSS.t747 sg13_lv_nmos ad=79.8f pd=0.8u as=0 ps=0 w=0.42u l=1u
X4016 VSS.t2763 VDD VSS.t2762 VSS.t198 sg13_lv_nmos ad=0.1428p pd=1.52u as=0 ps=0 w=0.42u l=1u
X4017 VSS.t2662 VDD VSS.t2663 VSS.t198 sg13_lv_nmos ad=79.8f pd=0.8u as=0 ps=0 w=0.42u l=1u
X4018 VDD VSS.t1652 VDD VDD sg13_lv_pmos ad=0.19p pd=1.38u as=0 ps=0 w=1u l=1u
X4019 sg13cmos5l_dlygate4sd3_1_1.A a_8298_14484# VDD VDD sg13_lv_pmos ad=0.3808p pd=2.92u as=0.2128p ps=1.5u w=1.12u l=0.13u
X4020 VDD VSS.t1707 VDD VDD sg13_lv_pmos ad=0.19p pd=1.38u as=0 ps=0 w=1u l=1u
X4021 VDD VSS.t2306 VDD VDD sg13_lv_pmos ad=0.19p pd=1.38u as=0 ps=0 w=1u l=1u
X4022 a_17710_16263# a_17825_16262# VSS.t83 VSS.t116 sg13_lv_nmos ad=0.1428p pd=1.52u as=0.1426p ps=1.16u w=0.42u l=0.5u
X4023 VDD VSS.t2431 VDD VDD sg13_lv_pmos ad=0.19p pd=1.38u as=0 ps=0 w=1u l=1u
X4024 VDD VSS.t2089 VDD VDD sg13_lv_pmos ad=0.19p pd=1.38u as=0 ps=0 w=1u l=1u
X4025 VSS.t1912 VDD VSS.t1914 VSS.t1913 sg13_lv_nmos ad=79.8f pd=0.8u as=0 ps=0 w=0.42u l=1u
X4026 VSS.t789 VDD VSS.t791 VSS.t790 sg13_lv_nmos ad=79.8f pd=0.8u as=0 ps=0 w=0.42u l=1u
X4027 VDD VSS.t2629 VDD VDD sg13_lv_pmos ad=0.19p pd=1.38u as=0 ps=0 w=1u l=1u
X4028 VSS.t2244 VDD VSS.t2243 VSS.t2242 sg13_lv_nmos ad=0.1428p pd=1.52u as=0 ps=0 w=0.42u l=1u
X4029 VSS.t155 a_25390_16263# sg13cmos5l_a21oi_1_2.A1 VSS.t181 sg13_lv_nmos ad=0.1426p pd=1.16u as=0.2516p ps=2.16u w=0.74u l=0.13u
X4030 a_24310_15230# sg13cmos5l_or3_1_1.C VSS.t65 VSS.t64 sg13_lv_nmos ad=0.1406p pd=1.12u as=0.1406p ps=1.12u w=0.74u l=0.15u
X4031 VDD VSS.t848 VDD VDD sg13_lv_pmos ad=0.34p pd=2.68u as=0 ps=0 w=1u l=1u
X4032 VSS.t3027 VDD VSS.t3026 VSS.t3025 sg13_lv_nmos ad=0.1428p pd=1.52u as=0 ps=0 w=0.42u l=1u
X4033 VSS.t2414 VDD VSS.t2416 VSS.t2415 sg13_lv_nmos ad=79.8f pd=0.8u as=0 ps=0 w=0.42u l=1u
X4034 sg13cmos5l_dlygate4sd3_1_8.A a_11370_15532# VSS.t56 VSS.t55 sg13_lv_nmos ad=0.2516p pd=2.16u as=0.1406p ps=1.12u w=0.74u l=0.13u
X4035 VDD VSS.t1519 VDD VDD sg13_lv_pmos ad=0.34p pd=2.68u as=0 ps=0 w=1u l=1u
X4036 VSS.t2641 VDD VSS.t2642 VSS.t198 sg13_lv_nmos ad=79.8f pd=0.8u as=0 ps=0 w=0.42u l=1u
X4037 sg13cmos5l_or3_1_1.B a_14261_15238# VDD VDD sg13_lv_pmos ad=0.2128p pd=1.5u as=0.203p ps=1.5u w=1.12u l=0.13u
X4038 VSS.t187 sg13cmos5l_buf_1_0.X a_2646_14842# VSS.t3203 sg13_lv_nmos ad=0.15245p pd=1.17u as=88.8f ps=0.98u w=0.74u l=0.13u
X4039 a_6660_14909# a_6891_14495# a_6346_14452# VSS.t60 sg13_lv_nmos ad=0.2373p pd=1.97u as=79.8f ps=0.8u w=0.42u l=0.13u
X4040 VDD VSS.t602 VDD VDD sg13_lv_pmos ad=0.19p pd=1.38u as=0 ps=0 w=1u l=1u
X4041 VSS.t1208 VDD VSS.t1209 VSS.t1154 sg13_lv_nmos ad=79.8f pd=0.8u as=0 ps=0 w=0.42u l=1u
X4042 VSS.t2319 VDD VSS.t2318 VSS.t2317 sg13_lv_nmos ad=0.1428p pd=1.52u as=0 ps=0 w=0.42u l=1u
X4043 VSS.t72 a_26565_13701# a_26667_13844# VSS.t71 sg13_lv_nmos ad=15.38618p pd=0.10091m as=0.2516p ps=2.16u w=0.74u l=0.13u
X4044 VSS.t599 VDD VSS.t596 VSS.t598 sg13_lv_nmos ad=0.1428p pd=1.52u as=0 ps=0 w=0.42u l=1u
X4045 VSS.t1580 VDD VSS.t1582 VSS.t1581 sg13_lv_nmos ad=79.8f pd=0.8u as=0 ps=0 w=0.42u l=1u
X4046 VDD VSS.t1856 VDD VDD sg13_lv_pmos ad=0.34p pd=2.68u as=0 ps=0 w=1u l=1u
X4047 sg13cmos5l_and2_1_1.X a_5613_14832# VSS.t11 VSS.t3169 sg13_lv_nmos ad=0.2516p pd=2.16u as=0.1331p ps=1.12u w=0.74u l=0.13u
X4048 VDD VSS.t586 VDD VDD sg13_lv_pmos ad=0.19p pd=1.38u as=0 ps=0 w=1u l=1u
X4049 VDD VSS.t2695 VDD VDD sg13_lv_pmos ad=0.34p pd=2.68u as=0 ps=0 w=1u l=1u
X4050 VSS.t135 sg13cmos5l_buf_8_2.A a_19323_13726# VSS.t134 sg13_lv_nmos ad=0.1406p pd=1.12u as=0.2553p ps=2.17u w=0.74u l=0.13u
X4051 VSS.t884 VDD VSS.t883 VSS.t882 sg13_lv_nmos ad=0.1428p pd=1.52u as=0 ps=0 w=0.42u l=1u
X4052 VDD VSS.t3009 VDD VDD sg13_lv_pmos ad=0.19p pd=1.38u as=0 ps=0 w=1u l=1u
X4053 VSS.t2743 VDD VSS.t2744 VSS.t198 sg13_lv_nmos ad=79.8f pd=0.8u as=0 ps=0 w=0.42u l=1u
X4054 VDD VSS.t1884 VDD VDD sg13_lv_pmos ad=0.19p pd=1.38u as=0 ps=0 w=1u l=1u
X4055 VSS.t1213 VDD VSS.t1214 VSS.t1154 sg13_lv_nmos ad=79.8f pd=0.8u as=0 ps=0 w=0.42u l=1u
X4056 VSS.t804 VDD VSS.t806 VSS.t805 sg13_lv_nmos ad=79.8f pd=0.8u as=0 ps=0 w=0.42u l=1u
X4057 a_25390_16263# a_25505_16262# VSS.t155 VSS.t166 sg13_lv_nmos ad=0.1428p pd=1.52u as=0.1426p ps=1.16u w=0.42u l=0.5u
X4058 VSS.t2635 VDD VSS.t2636 VSS.t198 sg13_lv_nmos ad=79.8f pd=0.8u as=0 ps=0 w=0.42u l=1u
X4059 VDD VSS.t2448 VDD VDD sg13_lv_pmos ad=0.34p pd=2.68u as=0 ps=0 w=1u l=1u
X4060 VSS.t1947 VDD VSS.t1949 VSS.t1948 sg13_lv_nmos ad=79.8f pd=0.8u as=0 ps=0 w=0.42u l=1u
X4061 VDD VSS.t1248 VDD VDD sg13_lv_pmos ad=0.34p pd=2.68u as=0 ps=0 w=1u l=1u
X4062 VDD VSS.t2744 VDD VDD sg13_lv_pmos ad=0.34p pd=2.68u as=0 ps=0 w=1u l=1u
X4063 VDD a_19323_13726# sg13cmos5l_buf_8_2.X VDD sg13_lv_pmos ad=0.2128p pd=1.5u as=0.2128p ps=1.5u w=1.12u l=0.13u
X4064 VDD VSS.t2251 VDD VDD sg13_lv_pmos ad=0.19p pd=1.38u as=0 ps=0 w=1u l=1u
X4065 VDD VSS.t811 VDD VDD sg13_lv_pmos ad=0.19p pd=1.38u as=0 ps=0 w=1u l=1u
X4066 VDD VSS.t2348 VDD VDD sg13_lv_pmos ad=0.34p pd=2.68u as=0 ps=0 w=1u l=1u
X4067 VDD clock_i a_15579_14854# VDD sg13_lv_pmos ad=0.2128p pd=1.5u as=0.2128p ps=1.5u w=1.12u l=0.13u
X4068 VDD VSS.t548 VDD VDD sg13_lv_pmos ad=0.19p pd=1.38u as=0 ps=0 w=1u l=1u
X4069 VSS.t2434 VDD VSS.t2436 VSS.t2435 sg13_lv_nmos ad=79.8f pd=0.8u as=0 ps=0 w=0.42u l=1u
X4070 VSS.t1857 VDD VSS.t1859 VSS.t1858 sg13_lv_nmos ad=79.8f pd=0.8u as=0 ps=0 w=0.42u l=1u
X4071 a_7822_13911# a_7937_13912# VSS.t209 VSS.t216 sg13_lv_nmos ad=0.1428p pd=1.52u as=0.1426p ps=1.16u w=0.42u l=0.5u
X4072 VSS.t541 VDD VSS.t543 VSS.t542 sg13_lv_nmos ad=79.8f pd=0.8u as=0 ps=0 w=0.42u l=1u
X4073 VSS.t2634 VDD VSS.t2635 VSS.t198 sg13_lv_nmos ad=79.8f pd=0.8u as=0 ps=0 w=0.42u l=1u
X4074 VDD VSS.t1317 VDD VDD sg13_lv_pmos ad=0.19p pd=1.38u as=0 ps=0 w=1u l=1u
X4075 VDD VSS.t2101 VDD VDD sg13_lv_pmos ad=0.34p pd=2.68u as=0 ps=0 w=1u l=1u
X4076 VDD VSS.t1924 VDD VDD sg13_lv_pmos ad=0.19p pd=1.38u as=0 ps=0 w=1u l=1u
X4077 a_6286_13911# a_6401_13912# VSS.t44 VSS.t3217 sg13_lv_nmos ad=0.1428p pd=1.52u as=0.1426p ps=1.16u w=0.42u l=0.5u
X4078 VSS.t3 VDD VSS.t3 VSS.t380 sg13_lv_nmos ad=0.1428p pd=1.52u as=0 ps=0 w=0.42u l=1u
X4079 sg13cmos5l_nand3_1_0.Y sg13cmos5l_buf_1_0.X a_6680_15242# VSS.t3201 sg13_lv_nmos ad=0.2516p pd=2.16u as=0.1406p ps=1.12u w=0.74u l=0.13u
X4080 VDD VSS.t1876 VDD VDD sg13_lv_pmos ad=0.34p pd=2.68u as=0 ps=0 w=1u l=1u
X4081 VDD VSS.t2707 VDD VDD sg13_lv_pmos ad=0.34p pd=2.68u as=0 ps=0 w=1u l=1u
X4082 VSS.t1159 VDD VSS.t1160 VSS.t1154 sg13_lv_nmos ad=79.8f pd=0.8u as=0 ps=0 w=0.42u l=1u
X4083 VSS.t2754 VDD VSS.t2753 VSS.t198 sg13_lv_nmos ad=0.1428p pd=1.52u as=0 ps=0 w=0.42u l=1u
X4084 VDD VSS.t2635 VDD VDD sg13_lv_pmos ad=0.34p pd=2.68u as=0 ps=0 w=1u l=1u
X4085 VDD VSS.t2049 VDD VDD sg13_lv_pmos ad=0.19p pd=1.38u as=0 ps=0 w=1u l=1u
X4086 VDD a_2540_15960# counter_value_o[0] VDD sg13_lv_pmos ad=0.2114p pd=1.54u as=0.42p ps=2.99u w=1.12u l=0.13u
X4087 VSS.t959 VDD VSS.t961 VSS.t960 sg13_lv_nmos ad=79.8f pd=0.8u as=0 ps=0 w=0.42u l=1u
X4088 VSS.t2887 VDD VSS.t2889 VSS.t2888 sg13_lv_nmos ad=79.8f pd=0.8u as=0 ps=0 w=0.42u l=1u
X4089 sg13cmos5l_dlygate4sd3_1_1.A a_8298_14484# VSS.t39 VSS.t38 sg13_lv_nmos ad=0.2516p pd=2.16u as=0.1406p ps=1.12u w=0.74u l=0.13u
X4090 VDD VSS.t1028 VDD VDD sg13_lv_pmos ad=0.34p pd=2.68u as=0 ps=0 w=1u l=1u
X4091 VSS.t1720 VDD VSS.t1722 VSS.t1721 sg13_lv_nmos ad=79.8f pd=0.8u as=0 ps=0 w=0.42u l=1u
X4092 VSS.t417 VDD VSS.t418 VSS.t11 sg13_lv_nmos ad=79.8f pd=0.8u as=0 ps=0 w=0.42u l=1u
X4093 VDD VSS.t635 VDD VDD sg13_lv_pmos ad=0.19p pd=1.38u as=0 ps=0 w=1u l=1u
X4094 VSS.t2720 VDD VSS.t2719 VSS.t198 sg13_lv_nmos ad=0.1428p pd=1.52u as=0 ps=0 w=0.42u l=1u
X4095 VDD VSS.t2468 VDD VDD sg13_lv_pmos ad=0.34p pd=2.68u as=0 ps=0 w=1u l=1u
X4096 VSS.t1932 VDD VSS.t1934 VSS.t1933 sg13_lv_nmos ad=79.8f pd=0.8u as=0 ps=0 w=0.42u l=1u
X4097 VSS.t629 VDD VSS.t629 VSS.t756 sg13_lv_nmos ad=0.1428p pd=1.52u as=0 ps=0 w=0.42u l=1u
X4098 VSS.t132 VDD VSS.t132 VSS.t391 sg13_lv_nmos ad=0.1428p pd=1.52u as=0 ps=0 w=0.42u l=1u
X4099 VDD VSS.t684 VDD VDD sg13_lv_pmos ad=0.34p pd=2.68u as=0 ps=0 w=1u l=1u
X4100 VDD VSS.t2074 VDD VDD sg13_lv_pmos ad=0.19p pd=1.38u as=0 ps=0 w=1u l=1u
X4101 VSS.t2077 VDD VSS.t2076 VSS.t2075 sg13_lv_nmos ad=0.1428p pd=1.52u as=0 ps=0 w=0.42u l=1u
X4102 sg13cmos5l_o21ai_1_2.Y sg13cmos5l_o21ai_1_2.B1 a_23638_14862# VSS.t4 sg13_lv_nmos ad=0.2516p pd=2.16u as=0.1406p ps=1.12u w=0.74u l=0.15u
X4103 VSS.t789 VDD VSS.t791 VSS.t790 sg13_lv_nmos ad=79.8f pd=0.8u as=0 ps=0 w=0.42u l=1u
X4104 VDD VSS.t778 VDD VDD sg13_lv_pmos ad=0.34p pd=2.68u as=0 ps=0 w=1u l=1u
X4105 VDD VSS.t1562 VDD VDD sg13_lv_pmos ad=0.19p pd=1.38u as=0 ps=0 w=1u l=1u
X4106 VSS.t283 VDD VSS.t283 VSS.t282 sg13_lv_nmos ad=0.1428p pd=1.52u as=0 ps=0 w=0.42u l=1u
X4107 VSS.t546 VDD VSS.t548 VSS.t547 sg13_lv_nmos ad=79.8f pd=0.8u as=0 ps=0 w=0.42u l=1u
X4108 VDD VSS.t3 VDD VDD sg13_lv_pmos ad=0.34p pd=2.68u as=0 ps=0 w=1u l=1u
X4109 VSS.t1168 VDD VSS.t1169 VSS.t1154 sg13_lv_nmos ad=79.8f pd=0.8u as=0 ps=0 w=0.42u l=1u
X4110 VSS.t2229 VDD VSS.t2228 VSS.t2227 sg13_lv_nmos ad=0.1428p pd=1.52u as=0 ps=0 w=0.42u l=1u
X4111 VSS.t1842 VDD VSS.t1844 VSS.t1843 sg13_lv_nmos ad=79.8f pd=0.8u as=0 ps=0 w=0.42u l=1u
X4112 VDD VSS.t1297 VDD VDD sg13_lv_pmos ad=0.34p pd=2.68u as=0 ps=0 w=1u l=1u
X4113 VDD VSS.t1168 VDD VDD sg13_lv_pmos ad=0.19p pd=1.38u as=0 ps=0 w=1u l=1u
X4114 VSS.t626 VDD VSS.t623 VSS.t625 sg13_lv_nmos ad=0.1428p pd=1.52u as=0 ps=0 w=0.42u l=1u
X4115 VSS.t1590 VDD VSS.t1589 VSS.t1588 sg13_lv_nmos ad=0.1428p pd=1.52u as=0 ps=0 w=0.42u l=1u
X4116 VSS.t3107 VDD VSS.t3106 VSS.t3105 sg13_lv_nmos ad=0.1428p pd=1.52u as=0 ps=0 w=0.42u l=1u
X4117 VSS.t2304 VDD VSS.t2303 VSS.t2302 sg13_lv_nmos ad=0.1428p pd=1.52u as=0 ps=0 w=0.42u l=1u
X4118 a_1965_14832# sg13cmos5l_buf_1_10.X VDD VDD sg13_lv_pmos ad=0.1596p pd=1.22u as=0.2856p ps=2.36u w=0.84u l=0.13u
X4119 VSS.t884 VDD VSS.t883 VSS.t882 sg13_lv_nmos ad=0.1428p pd=1.52u as=0 ps=0 w=0.42u l=1u
X4120 VDD VSS.t2263 VDD VDD sg13_lv_pmos ad=0.34p pd=2.68u as=0 ps=0 w=1u l=1u
X4121 a_25094_15238# a_24824_15238# VSS.t103 VSS.t64 sg13_lv_nmos ad=0.1428p pd=1.52u as=79.8f ps=0.8u w=0.42u l=0.5u
X4122 VSS.t2665 VDD VSS.t2666 VSS.t198 sg13_lv_nmos ad=79.8f pd=0.8u as=0 ps=0 w=0.42u l=1u
X4123 VSS.t929 VDD VSS.t928 VSS.t927 sg13_lv_nmos ad=0.1428p pd=1.52u as=0 ps=0 w=0.42u l=1u
X4124 VSS.t804 VDD VSS.t806 VSS.t805 sg13_lv_nmos ad=79.8f pd=0.8u as=0 ps=0 w=0.42u l=1u
X4125 VSS.t1240 VDD VSS.t1241 VSS.t1154 sg13_lv_nmos ad=79.8f pd=0.8u as=0 ps=0 w=0.42u l=1u
X4126 VDD VSS.t1712 VDD VDD sg13_lv_pmos ad=0.19p pd=1.38u as=0 ps=0 w=1u l=1u
X4127 VDD VSS.t2994 VDD VDD sg13_lv_pmos ad=0.19p pd=1.38u as=0 ps=0 w=1u l=1u
X4128 VSS.t2736 VDD VSS.t2737 VSS.t198 sg13_lv_nmos ad=79.8f pd=0.8u as=0 ps=0 w=0.42u l=1u
X4129 VDD VSS.t1869 VDD VDD sg13_lv_pmos ad=0.19p pd=1.38u as=0 ps=0 w=1u l=1u
X4130 VSS.t1872 VDD VSS.t1871 VSS.t1870 sg13_lv_nmos ad=0.1428p pd=1.52u as=0 ps=0 w=0.42u l=1u
X4131 VSS.t1585 VDD VSS.t1584 VSS.t1583 sg13_lv_nmos ad=0.1428p pd=1.52u as=0 ps=0 w=0.42u l=1u
X4132 VDD sg13cmos5l_dfrbpq_1_2.RESET_B a_15782_13722# VDD sg13_lv_pmos ad=0.36237p pd=2.605u as=79.8f ps=0.8u w=0.42u l=0.13u
X4133 VSS.t67 sg13cmos5l_or3_1_1.A a_24841_13726# VSS.t3171 sg13_lv_nmos ad=0.13395p pd=1.12u as=0.198p ps=1.27u w=0.55u l=0.13u
X4134 VSS.t2711 VDD VSS.t2709 VSS.t198 sg13_lv_nmos ad=0.1428p pd=1.52u as=0 ps=0 w=0.42u l=1u
X4135 VSS.t2112 VDD VSS.t2111 VSS.t2110 sg13_lv_nmos ad=0.1428p pd=1.52u as=0 ps=0 w=0.42u l=1u
X4136 VDD VSS.t1239 VDD VDD sg13_lv_pmos ad=0.34p pd=2.68u as=0 ps=0 w=1u l=1u
X4137 VDD VSS.t2737 VDD VDD sg13_lv_pmos ad=0.34p pd=2.68u as=0 ps=0 w=1u l=1u
X4138 VDD VSS.t2401 VDD VDD sg13_lv_pmos ad=0.19p pd=1.38u as=0 ps=0 w=1u l=1u
X4139 VDD sg13cmos5l_a21oi_1_3.A2 a_25109_12972# VDD sg13_lv_pmos ad=0.2128p pd=1.5u as=0.3808p ps=2.92u w=1.12u l=0.13u
X4140 VSS.t989 VDD VSS.t991 VSS.t990 sg13_lv_nmos ad=79.8f pd=0.8u as=0 ps=0 w=0.42u l=1u
X4141 VDD VSS.t2059 VDD VDD sg13_lv_pmos ad=0.19p pd=1.38u as=0 ps=0 w=1u l=1u
X4142 a_18021_14495# sg13cmos5l_buf_8_2.X VDD VDD sg13_lv_pmos ad=0.4088p pd=2.97u as=2.3367p ps=15.135u w=1.12u l=0.13u
X4143 VSS.t1259 VDD VSS.t1260 VSS.t1154 sg13_lv_nmos ad=79.8f pd=0.8u as=0 ps=0 w=0.42u l=1u
X4144 VDD VSS.t2236 VDD VDD sg13_lv_pmos ad=0.19p pd=1.38u as=0 ps=0 w=1u l=1u
X4145 VDD VSS.t856 VDD VDD sg13_lv_pmos ad=0.19p pd=1.38u as=0 ps=0 w=1u l=1u
X4146 VSS.t2652 VDD VSS.t2652 VSS.t198 sg13_lv_nmos ad=0.1428p pd=1.52u as=0 ps=0 w=0.42u l=1u
X4147 VSS.t2419 VDD VSS.t2421 VSS.t2420 sg13_lv_nmos ad=79.8f pd=0.8u as=0 ps=0 w=0.42u l=1u
X4148 VDD VSS.t1524 VDD VDD sg13_lv_pmos ad=0.34p pd=2.68u as=0 ps=0 w=1u l=1u
X4149 VDD a_17710_16263# sg13cmos5l_a21oi_1_0.A1 VDD sg13_lv_pmos ad=0.2254p pd=1.53u as=0.4256p ps=3u w=1.12u l=0.13u
X4150 a_10703_15311# a_9861_15213# a_9444_15552# VDD sg13_lv_pmos ad=0.2048p pd=1.63u as=0.34p ps=2.68u w=1u l=0.13u
X4151 VDD VSS.t1507 VDD VDD sg13_lv_pmos ad=0.19p pd=1.38u as=0 ps=0 w=1u l=1u
X4152 VSS.t2626 VDD VSS.t2627 VSS.t198 sg13_lv_nmos ad=79.8f pd=0.8u as=0 ps=0 w=0.42u l=1u
X4153 VDD VSS.t311 VDD VDD sg13_lv_pmos ad=0.19p pd=1.38u as=0 ps=0 w=1u l=1u
X4154 VDD a_15671_15315# a_15671_15549# VDD sg13_lv_pmos ad=2.8961p pd=18.25u as=0.2442p ps=2.06u w=0.66u l=0.13u
X4155 VDD VSS.t241 VDD VDD sg13_lv_pmos ad=0.34p pd=2.68u as=0 ps=0 w=1u l=1u
X4156 VSS.t2324 VDD VSS.t2323 VSS.t2322 sg13_lv_nmos ad=0.1428p pd=1.52u as=0 ps=0 w=0.42u l=1u
X4157 VDD VSS.t2086 VDD VDD sg13_lv_pmos ad=0.34p pd=2.68u as=0 ps=0 w=1u l=1u
X4158 a_16068_14040# a_16042_13945# VSS.t49 VSS.t48 sg13_lv_nmos ad=0.2516p pd=2.16u as=0.1626p ps=1.415u w=0.74u l=0.13u
X4159 VDD VSS.t1231 VDD VDD sg13_lv_pmos ad=0.34p pd=2.68u as=0 ps=0 w=1u l=1u
X4160 VDD VSS.t1861 VDD VDD sg13_lv_pmos ad=0.34p pd=2.68u as=0 ps=0 w=1u l=1u
X4161 VSS.t959 VDD VSS.t961 VSS.t960 sg13_lv_nmos ad=79.8f pd=0.8u as=0 ps=0 w=0.42u l=1u
X4162 VDD VSS.t948 VDD VDD sg13_lv_pmos ad=0.34p pd=2.68u as=0 ps=0 w=1u l=1u
X4163 VDD VSS.t2627 VDD VDD sg13_lv_pmos ad=0.34p pd=2.68u as=0 ps=0 w=1u l=1u
X4164 VDD VSS.t2697 VDD VDD sg13_lv_pmos ad=0.34p pd=2.68u as=0 ps=0 w=1u l=1u
X4165 a_10960_15454# a_10703_15311# a_11122_15234# VSS.t3241 sg13_lv_nmos ad=0.1428p pd=1.52u as=37.8f ps=0.6u w=0.42u l=0.13u
X4166 VDD VSS.t3014 VDD VDD sg13_lv_pmos ad=0.19p pd=1.38u as=0 ps=0 w=1u l=1u
X4167 VDD VSS.t1889 VDD VDD sg13_lv_pmos ad=0.19p pd=1.38u as=0 ps=0 w=1u l=1u
X4168 VSS.t1705 VDD VSS.t1707 VSS.t1706 sg13_lv_nmos ad=79.8f pd=0.8u as=0 ps=0 w=0.42u l=1u
X4169 VDD VSS.t436 VDD VDD sg13_lv_pmos ad=0.19p pd=1.38u as=0 ps=0 w=1u l=1u
X4170 VSS.t2097 VDD VSS.t2096 VSS.t2095 sg13_lv_nmos ad=0.1428p pd=1.52u as=0 ps=0 w=0.42u l=1u
X4171 VDD VSS.t2051 VDD VDD sg13_lv_pmos ad=0.34p pd=2.68u as=0 ps=0 w=1u l=1u
X4172 VDD VSS.t1158 VDD VDD sg13_lv_pmos ad=0.34p pd=2.68u as=0 ps=0 w=1u l=1u
X4173 VDD sg13cmos5l_or3_1_1.A sg13cmos5l_o21ai_1_3.Y VDD sg13_lv_pmos ad=0.3808p pd=2.92u as=0.2128p ps=1.5u w=1.12u l=0.15u
X4174 VDD VSS.t1011 VDD VDD sg13_lv_pmos ad=0.19p pd=1.38u as=0 ps=0 w=1u l=1u
X4175 VSS.t1406 VDD VSS.t1274 VSS.t1154 sg13_lv_nmos ad=79.8f pd=0.8u as=0 ps=0 w=0.42u l=1u
X4176 VSS.t13 sg13cmos5l_dfrbpq_1_3.RESET_B a_17412_14922# VSS.t3213 sg13_lv_nmos ad=0.1626p pd=1.415u as=60.89999f ps=0.71u w=0.42u l=0.13u
X4177 VSS.t1575 VDD VSS.t1577 VSS.t1576 sg13_lv_nmos ad=79.8f pd=0.8u as=0 ps=0 w=0.42u l=1u
X4178 VDD VSS.t2353 VDD VDD sg13_lv_pmos ad=0.34p pd=2.68u as=0 ps=0 w=1u l=1u
X4179 a_21251_13690# sg13cmos5l_or3_1_2.C a_21549_14020# VDD sg13_lv_pmos ad=0.34p pd=2.68u as=0.19p ps=1.38u w=1u l=0.13u
X4180 VSS.t227 a_32492_15960# counter_value_o[6] VSS.t226 sg13_lv_nmos ad=0.14875p pd=1.16u as=0.2886p ps=2.26u w=0.74u l=0.13u
X4181 VSS.t879 VDD VSS.t881 VSS.t880 sg13_lv_nmos ad=79.8f pd=0.8u as=0 ps=0 w=0.42u l=1u
X4182 VSS.t1445 VDD VSS.t1447 VSS.t1446 sg13_lv_nmos ad=79.8f pd=0.8u as=0 ps=0 w=0.42u l=1u
X4183 VSS.t2636 VDD VSS.t2637 VSS.t198 sg13_lv_nmos ad=79.8f pd=0.8u as=0 ps=0 w=0.42u l=1u
X4184 a_21070_15423# a_21185_15424# VSS.t172 VSS.t3210 sg13_lv_nmos ad=0.1428p pd=1.52u as=0.1426p ps=1.16u w=0.42u l=0.5u
X4185 VDD VSS.t384 VDD VDD sg13_lv_pmos ad=0.34p pd=2.68u as=0 ps=0 w=1u l=1u
X4186 VDD VSS.t726 VDD VDD sg13_lv_pmos ad=0.19p pd=1.38u as=0 ps=0 w=1u l=1u
X4187 VDD VSS.t1929 VDD VDD sg13_lv_pmos ad=0.19p pd=1.38u as=0 ps=0 w=1u l=1u
X4188 sg13cmos5l_and2_1_2.B a_8694_15302# VDD VDD sg13_lv_pmos ad=0.4256p pd=3u as=0.2254p ps=1.53u w=1.12u l=0.13u
X4189 VSS.t929 VDD VSS.t928 VSS.t927 sg13_lv_nmos ad=0.1428p pd=1.52u as=0 ps=0 w=0.42u l=1u
X4190 VDD VSS.t1159 VDD VDD sg13_lv_pmos ad=0.19p pd=1.38u as=0 ps=0 w=1u l=1u
X4191 VDD VSS.t2248 VDD VDD sg13_lv_pmos ad=0.34p pd=2.68u as=0 ps=0 w=1u l=1u
X4192 a_7923_15532# sg13cmos5l_dlygate4sd3_1_8.X VDD VDD sg13_lv_pmos ad=0.1428p pd=1.375u as=0.2891p ps=1.695u w=1.12u l=0.13u
X4193 VDD VSS.t1846 VDD VDD sg13_lv_pmos ad=0.34p pd=2.68u as=0 ps=0 w=1u l=1u
X4194 VSS.t2757 VDD VSS.t2756 VSS.t198 sg13_lv_nmos ad=0.1428p pd=1.52u as=0 ps=0 w=0.42u l=1u
X4195 VDD VSS.t2637 VDD VDD sg13_lv_pmos ad=0.34p pd=2.68u as=0 ps=0 w=1u l=1u
X4196 VDD VSS.t2731 VDD VDD sg13_lv_pmos ad=0.19p pd=1.38u as=0 ps=0 w=1u l=1u
X4197 VDD sg13cmos5l_o21ai_1_2.B1 a_24365_14508# VDD sg13_lv_pmos ad=0.3822p pd=1.84u as=0.1575p ps=1.315u w=1u l=0.13u
X4198 VSS.t23 sg13cmos5l_a21oi_1_3.B1 sg13cmos5l_a21oi_1_3.Y VSS.t22 sg13_lv_nmos ad=0.2516p pd=2.16u as=0.1406p ps=1.12u w=0.74u l=0.13u
X4199 VDD VSS.t3156 VDD VDD sg13_lv_pmos ad=0.34p pd=2.68u as=0 ps=0 w=1u l=1u
X4200 a_27502_15423# a_27617_15424# VDD VDD sg13_lv_pmos ad=0.34p pd=2.68u as=0.2254p ps=1.53u w=1u l=0.5u
X4201 VDD VSS.t416 VDD VDD sg13_lv_pmos ad=0.34p pd=2.68u as=0 ps=0 w=1u l=1u
X4202 VSS.t83 sg13cmos5l_or3_1_2.B a_16969_16020# VSS.t3292 sg13_lv_nmos ad=0.1045p pd=0.93u as=0.187p ps=1.78u w=0.55u l=0.13u
X4203 VDD VSS.t406 VDD VDD sg13_lv_pmos ad=0.19p pd=1.38u as=0 ps=0 w=1u l=1u
X4204 VDD VSS.t72 VDD VDD sg13_lv_pmos ad=0.19p pd=1.38u as=0 ps=0 w=1u l=1u
X4205 VDD VSS.t626 VDD VDD sg13_lv_pmos ad=0.34p pd=2.68u as=0 ps=0 w=1u l=1u
X4206 VSS.t2702 VDD VSS.t2701 VSS.t198 sg13_lv_nmos ad=0.1428p pd=1.52u as=0 ps=0 w=0.42u l=1u
X4207 VSS.t989 VDD VSS.t991 VSS.t990 sg13_lv_nmos ad=79.8f pd=0.8u as=0 ps=0 w=0.42u l=1u
X4208 VDD VSS.t1249 VDD VDD sg13_lv_pmos ad=0.34p pd=2.68u as=0 ps=0 w=1u l=1u
X4209 a_32492_15960# sg13cmos5l_dfrbpq_1_7.Q VSS.t227 VSS.t3229 sg13_lv_nmos ad=0.187p pd=1.78u as=0.14875p ps=1.16u w=0.55u l=0.13u
X4210 VDD a_27034_15202# a_26753_15424# VDD sg13_lv_pmos ad=0.1523p pd=1.38u as=0.34p ps=2.68u w=1u l=0.5u
X4211 VDD VSS.t786 VDD VDD sg13_lv_pmos ad=0.19p pd=1.38u as=0 ps=0 w=1u l=1u
X4212 VDD VSS.t978 VDD VDD sg13_lv_pmos ad=0.34p pd=2.68u as=0 ps=0 w=1u l=1u
X4213 VSS.t3207 sg13cmos5l_or3_1_2.B a_23638_14862# VSS.t4 sg13_lv_nmos ad=0.1406p pd=1.12u as=0.2516p ps=2.16u w=0.74u l=0.15u
X4214 VSS.t1665 VDD VSS.t1664 VSS.t1663 sg13_lv_nmos ad=0.1428p pd=1.52u as=0 ps=0 w=0.42u l=1u
X4215 VDD VSS.t2386 VDD VDD sg13_lv_pmos ad=0.19p pd=1.38u as=0 ps=0 w=1u l=1u
X4216 VSS.t180 VDD VSS.t180 VSS.t730 sg13_lv_nmos ad=0.1428p pd=1.52u as=0 ps=0 w=0.42u l=1u
X4217 VDD VSS.t1567 VDD VDD sg13_lv_pmos ad=0.19p pd=1.38u as=0 ps=0 w=1u l=1u
X4218 VSS.t2656 VDD VSS.t2657 VSS.t198 sg13_lv_nmos ad=79.8f pd=0.8u as=0 ps=0 w=0.42u l=1u
X4219 VDD VSS.t1901 VDD VDD sg13_lv_pmos ad=0.34p pd=2.68u as=0 ps=0 w=1u l=1u
X4220 VSS.t263 VDD VSS.t265 VSS.t264 sg13_lv_nmos ad=79.8f pd=0.8u as=0 ps=0 w=0.42u l=1u
X4221 VSS.t849 VDD VSS.t848 VSS.t847 sg13_lv_nmos ad=0.1428p pd=1.52u as=0 ps=0 w=0.42u l=1u
X4222 VDD a_10960_15454# a_10905_15549# VDD sg13_lv_pmos ad=2.8961p pd=18.25u as=93.45f ps=0.865u w=0.42u l=0.13u
X4223 VDD VSS.t901 VDD VDD sg13_lv_pmos ad=0.19p pd=1.38u as=0 ps=0 w=1u l=1u
X4224 VSS.t2645 VDD VSS.t2644 VSS.t198 sg13_lv_nmos ad=0.1428p pd=1.52u as=0 ps=0 w=0.42u l=1u
X4225 VDD VSS.t2691 VDD VDD sg13_lv_pmos ad=0.19p pd=1.38u as=0 ps=0 w=1u l=1u
X4226 VSS.t1967 VDD VSS.t1966 VSS.t1965 sg13_lv_nmos ad=0.1428p pd=1.52u as=0 ps=0 w=0.42u l=1u
X4227 VSS.t299 VDD VSS.t301 VSS.t300 sg13_lv_nmos ad=79.8f pd=0.8u as=0 ps=0 w=0.42u l=1u
X4228 VSS.t394 VDD VSS.t394 VSS.t465 sg13_lv_nmos ad=79.8f pd=0.8u as=0 ps=0 w=0.42u l=1u
X4229 VDD VSS.t1189 VDD VDD sg13_lv_pmos ad=0.34p pd=2.68u as=0 ps=0 w=1u l=1u
X4230 VSS.t2309 VDD VSS.t2308 VSS.t2307 sg13_lv_nmos ad=0.1428p pd=1.52u as=0 ps=0 w=0.42u l=1u
X4231 a_2540_15960# sg13cmos5l_dlygate4sd3_1_3.A VSS.t267 VSS.t3235 sg13_lv_nmos ad=0.187p pd=1.78u as=0.14875p ps=1.16u w=0.55u l=0.13u
X4232 VSS.t626 VDD VSS.t629 VSS.t755 sg13_lv_nmos ad=79.8f pd=0.8u as=0 ps=0 w=0.42u l=1u
X4233 VDD VSS.t2268 VDD VDD sg13_lv_pmos ad=0.34p pd=2.68u as=0 ps=0 w=1u l=1u
X4234 VSS.t2499 VDD VSS.t2501 VSS.t2500 sg13_lv_nmos ad=79.8f pd=0.8u as=0 ps=0 w=0.42u l=1u
X4235 VSS.t2811 VDD VSS.t2668 VSS.t198 sg13_lv_nmos ad=79.8f pd=0.8u as=0 ps=0 w=0.42u l=1u
X4236 VDD VSS.t2441 VDD VDD sg13_lv_pmos ad=0.19p pd=1.38u as=0 ps=0 w=1u l=1u
X4237 VDD VSS.t605 VDD VDD sg13_lv_pmos ad=0.19p pd=1.38u as=0 ps=0 w=1u l=1u
X4238 VDD VSS.t776 VDD VDD sg13_lv_pmos ad=0.19p pd=1.38u as=0 ps=0 w=1u l=1u
X4239 VSS.t1211 VDD VSS.t1212 VSS.t1154 sg13_lv_nmos ad=79.8f pd=0.8u as=0 ps=0 w=0.42u l=1u
X4240 VDD VSS.t2999 VDD VDD sg13_lv_pmos ad=0.19p pd=1.38u as=0 ps=0 w=1u l=1u
X4241 VDD VSS.t1874 VDD VDD sg13_lv_pmos ad=0.19p pd=1.38u as=0 ps=0 w=1u l=1u
X4242 VSS.t1877 VDD VSS.t1876 VSS.t1875 sg13_lv_nmos ad=0.1428p pd=1.52u as=0 ps=0 w=0.42u l=1u
X4243 VSS.t402 VDD VSS.t403 VSS.t11 sg13_lv_nmos ad=79.8f pd=0.8u as=0 ps=0 w=0.42u l=1u
X4244 VSS.t2047 VDD VSS.t2049 VSS.t2048 sg13_lv_nmos ad=79.8f pd=0.8u as=0 ps=0 w=0.42u l=1u
X4245 VDD VSS.t941 VDD VDD sg13_lv_pmos ad=0.19p pd=1.38u as=0 ps=0 w=1u l=1u
X4246 VDD VSS.t1722 VDD VDD sg13_lv_pmos ad=0.19p pd=1.38u as=0 ps=0 w=1u l=1u
X4247 VDD VSS.t590 VDD VDD sg13_lv_pmos ad=0.19p pd=1.38u as=0 ps=0 w=1u l=1u
X4248 VDD VSS.t1242 VDD VDD sg13_lv_pmos ad=0.34p pd=2.68u as=0 ps=0 w=1u l=1u
X4249 VDD VSS.t2739 VDD VDD sg13_lv_pmos ad=0.34p pd=2.68u as=0 ps=0 w=1u l=1u
X4250 VDD VSS.t2406 VDD VDD sg13_lv_pmos ad=0.19p pd=1.38u as=0 ps=0 w=1u l=1u
X4251 VSS.t809 VDD VSS.t811 VSS.t810 sg13_lv_nmos ad=79.8f pd=0.8u as=0 ps=0 w=0.42u l=1u
X4252 VDD a_27500_15960# counter_value_o[5] VDD sg13_lv_pmos ad=0.2114p pd=1.54u as=0.42p ps=2.99u w=1.12u l=0.13u
X4253 VSS.t879 VDD VSS.t881 VSS.t880 sg13_lv_nmos ad=79.8f pd=0.8u as=0 ps=0 w=0.42u l=1u
X4254 VSS.t2907 VDD VSS.t2906 VSS.t2905 sg13_lv_nmos ad=0.1428p pd=1.52u as=0 ps=0 w=0.42u l=1u
X4255 VDD VSS.t424 VDD VDD sg13_lv_pmos ad=0.19p pd=1.38u as=0 ps=0 w=1u l=1u
X4256 a_26436_13735# a_26667_13844# a_26122_13945# VSS.t68 sg13_lv_nmos ad=0.2373p pd=1.97u as=79.8f ps=0.8u w=0.42u l=0.13u
X4257 a_26374_13735# sg13cmos5l_dfrbpq_1_5.RESET_B VSS.t145 VSS.t148 sg13_lv_nmos ad=37.8f pd=0.6u as=0.1701p ps=1.65u w=0.42u l=0.13u
X4258 VDD VSS.t868 VDD VDD sg13_lv_pmos ad=0.34p pd=2.68u as=0 ps=0 w=1u l=1u
X4259 VSS.t1560 VDD VSS.t1562 VSS.t1561 sg13_lv_nmos ad=79.8f pd=0.8u as=0 ps=0 w=0.42u l=1u
X4260 VSS.t1220 VDD VSS.t1220 VSS.t1154 sg13_lv_nmos ad=79.8f pd=0.8u as=0 ps=0 w=0.42u l=1u
X4261 VSS.t291 VDD VSS.t291 VSS.t296 sg13_lv_nmos ad=79.8f pd=0.8u as=0 ps=0 w=0.42u l=1u
X4262 VSS.t49 sg13cmos5l_dfrbpq_1_2.RESET_B a_15876_13722# VSS.t248 sg13_lv_nmos ad=0.1626p pd=1.415u as=60.89999f ps=0.71u w=0.42u l=0.13u
X4263 VSS.t608 VDD VSS.t608 VSS.t742 sg13_lv_nmos ad=0.1428p pd=1.52u as=0 ps=0 w=0.42u l=1u
X4264 VDD VSS.t614 VDD VDD sg13_lv_pmos ad=0.19p pd=1.38u as=0 ps=0 w=1u l=1u
X4265 VSS.t2629 VDD VSS.t2630 VSS.t198 sg13_lv_nmos ad=79.8f pd=0.8u as=0 ps=0 w=0.42u l=1u
X4266 VSS.t11 a_27472_14726# a_27121_14845# VSS.t11 sg13_lv_nmos ad=79.8f pd=0.8u as=0.1428p ps=1.52u w=0.42u l=0.13u
X4267 VDD VSS.t2433 VDD VDD sg13_lv_pmos ad=0.34p pd=2.68u as=0 ps=0 w=1u l=1u
X4268 VDD VSS.t2091 VDD VDD sg13_lv_pmos ad=0.34p pd=2.68u as=0 ps=0 w=1u l=1u
X4269 VSS.t2484 VDD VSS.t2486 VSS.t2485 sg13_lv_nmos ad=79.8f pd=0.8u as=0 ps=0 w=0.42u l=1u
X4270 a_8582_15238# a_8312_15238# VSS.t39 VSS.t3198 sg13_lv_nmos ad=0.1428p pd=1.52u as=79.8f ps=0.8u w=0.42u l=0.5u
X4271 sg13cmos5l_buf_8_2.X a_19323_13726# VDD VDD sg13_lv_pmos ad=0.2128p pd=1.5u as=0.2128p ps=1.5u w=1.12u l=0.13u
X4272 VSS.t546 VDD VSS.t548 VSS.t547 sg13_lv_nmos ad=79.8f pd=0.8u as=0 ps=0 w=0.42u l=1u
X4273 VSS.t1184 VDD VSS.t1183 VSS.t1154 sg13_lv_nmos ad=0.1428p pd=1.52u as=0 ps=0 w=0.42u l=1u
X4274 VSS.t1225 VDD VSS.t1226 VSS.t1154 sg13_lv_nmos ad=79.8f pd=0.8u as=0 ps=0 w=0.42u l=1u
X4275 VDD VSS.t2630 VDD VDD sg13_lv_pmos ad=0.34p pd=2.68u as=0 ps=0 w=1u l=1u
X4276 a_15870_15486# a_15671_15549# VSS.t11 VSS.t158 sg13_lv_nmos ad=0.27427p pd=2.28u as=4.11262p ps=27.15u w=0.795u l=0.13u
X4277 VDD VSS.t2984 VDD VDD sg13_lv_pmos ad=0.19p pd=1.38u as=0 ps=0 w=1u l=1u
X4278 VDD VSS.t72 VDD VDD sg13_lv_pmos ad=0.19p pd=1.38u as=0 ps=0 w=1u l=1u
X4279 VDD VSS.t1320 VDD VDD sg13_lv_pmos ad=0.19p pd=1.38u as=0 ps=0 w=1u l=1u
X4280 a_27472_14726# a_27215_14845# a_27634_14922# VSS.t11 sg13_lv_nmos ad=0.1428p pd=1.52u as=37.8f ps=0.6u w=0.42u l=0.13u
X4281 VSS.t1710 VDD VSS.t1712 VSS.t1711 sg13_lv_nmos ad=79.8f pd=0.8u as=0 ps=0 w=0.42u l=1u
X4282 a_12010_15202# sg13cmos5l_buf_8_2.A VSS.t35 VSS.t130 sg13_lv_nmos ad=0.1406p pd=1.12u as=0.1406p ps=1.12u w=0.74u l=0.13u
X4283 VSS.t779 VDD VSS.t778 VSS.t777 sg13_lv_nmos ad=0.1428p pd=1.52u as=0 ps=0 w=0.42u l=1u
X4284 VSS.t2675 VDD VSS.t2674 VSS.t198 sg13_lv_nmos ad=0.1428p pd=1.52u as=0 ps=0 w=0.42u l=1u
X4285 VSS.t849 VDD VSS.t848 VSS.t847 sg13_lv_nmos ad=0.1428p pd=1.52u as=0 ps=0 w=0.42u l=1u
X4286 VDD VSS.t1552 VDD VDD sg13_lv_pmos ad=0.19p pd=1.38u as=0 ps=0 w=1u l=1u
X4287 VSS.t2746 VDD VSS.t2745 VSS.t198 sg13_lv_nmos ad=0.1428p pd=1.52u as=0 ps=0 w=0.42u l=1u
X4288 VDD VSS.t1886 VDD VDD sg13_lv_pmos ad=0.34p pd=2.68u as=0 ps=0 w=1u l=1u
X4289 VSS.t2017 VDD VSS.t2019 VSS.t2018 sg13_lv_nmos ad=79.8f pd=0.8u as=0 ps=0 w=0.42u l=1u
X4290 a_26122_13945# a_26565_13701# a_26505_14113# VDD sg13_lv_pmos ad=79.8f pd=0.8u as=63f ps=0.72u w=0.42u l=0.13u
X4291 VDD VSS.t946 VDD VDD sg13_lv_pmos ad=0.19p pd=1.38u as=0 ps=0 w=1u l=1u
X4292 VSS.t1202 VDD VSS.t1201 VSS.t1154 sg13_lv_nmos ad=0.1428p pd=1.52u as=0 ps=0 w=0.42u l=1u
X4293 VDD VSS.t2418 VDD VDD sg13_lv_pmos ad=0.34p pd=2.68u as=0 ps=0 w=1u l=1u
X4294 VSS.t1505 VDD VSS.t1507 VSS.t1506 sg13_lv_nmos ad=79.8f pd=0.8u as=0 ps=0 w=0.42u l=1u
X4295 VSS.t1207 VDD VSS.t1206 VSS.t1154 sg13_lv_nmos ad=0.1428p pd=1.52u as=0 ps=0 w=0.42u l=1u
X4296 VDD VSS.t2253 VDD VDD sg13_lv_pmos ad=0.34p pd=2.68u as=0 ps=0 w=1u l=1u
X4297 VDD VSS.t1851 VDD VDD sg13_lv_pmos ad=0.34p pd=2.68u as=0 ps=0 w=1u l=1u
X4298 VDD VSS.t2691 VDD VDD sg13_lv_pmos ad=0.34p pd=2.68u as=0 ps=0 w=1u l=1u
X4299 VDD sg13cmos5l_dfrbpq_1_0.RESET_B a_2890_15457# VDD sg13_lv_pmos ad=0.1563p pd=1.22u as=0.147p ps=1.54u w=0.42u l=0.13u
X4300 a_21251_13690# sg13cmos5l_or3_1_2.A VSS.t703 VSS.t3267 sg13_lv_nmos ad=0.198p pd=1.27u as=0.13395p ps=1.12u w=0.55u l=0.13u
X4301 VSS.t1238 VDD VSS.t1239 VSS.t1154 sg13_lv_nmos ad=79.8f pd=0.8u as=0 ps=0 w=0.42u l=1u
X4302 VDD VSS.t1235 VDD VDD sg13_lv_pmos ad=0.19p pd=1.38u as=0 ps=0 w=1u l=1u
X4303 VDD VSS.t2733 VDD VDD sg13_lv_pmos ad=0.19p pd=1.38u as=0 ps=0 w=1u l=1u
X4304 VDD VSS.t2024 VDD VDD sg13_lv_pmos ad=0.19p pd=1.38u as=0 ps=0 w=1u l=1u
X4305 VSS.t1 sg13cmos5l_tiehi_1.L_HI a_9252_15234# VSS.t92 sg13_lv_nmos ad=0.1626p pd=1.415u as=60.89999f ps=0.71u w=0.42u l=0.13u
X4306 a_16068_14040# a_16042_13945# VDD VDD sg13_lv_pmos ad=0.34p pd=2.68u as=0.36237p ps=2.605u w=1u l=0.13u
X4307 VSS.t629 VDD VSS.t626 VSS.t628 sg13_lv_nmos ad=0.1428p pd=1.52u as=0 ps=0 w=0.42u l=1u
X4308 VDD VSS.t3161 VDD VDD sg13_lv_pmos ad=0.34p pd=2.68u as=0 ps=0 w=1u l=1u
X4309 VSS.t2439 VDD VSS.t2438 VSS.t2437 sg13_lv_nmos ad=0.1428p pd=1.52u as=0 ps=0 w=0.42u l=1u
X4310 VSS.t1862 VDD VSS.t1861 VSS.t1860 sg13_lv_nmos ad=0.1428p pd=1.52u as=0 ps=0 w=0.42u l=1u
X4311 VDD VSS.t2443 VDD VDD sg13_lv_pmos ad=0.34p pd=2.68u as=0 ps=0 w=1u l=1u
X4312 VSS.t934 VDD VSS.t933 VSS.t932 sg13_lv_nmos ad=0.1428p pd=1.52u as=0 ps=0 w=0.42u l=1u
X4313 VDD VSS.t1707 VDD VDD sg13_lv_pmos ad=0.19p pd=1.38u as=0 ps=0 w=1u l=1u
X4314 VSS.t809 VDD VSS.t811 VSS.t810 sg13_lv_nmos ad=79.8f pd=0.8u as=0 ps=0 w=0.42u l=1u
X4315 VSS.t1243 VDD VSS.t1244 VSS.t1154 sg13_lv_nmos ad=79.8f pd=0.8u as=0 ps=0 w=0.42u l=1u
X4316 sg13cmos5l_dfrbpq_1_2.CLK a_12010_15202# VSS.t30 VSS.t31 sg13_lv_nmos ad=0.1406p pd=1.12u as=0.1406p ps=1.12u w=0.74u l=0.13u
X4317 VSS.t2504 VDD VSS.t2506 VSS.t2505 sg13_lv_nmos ad=79.8f pd=0.8u as=0 ps=0 w=0.42u l=1u
X4318 VDD VSS.t2391 VDD VDD sg13_lv_pmos ad=0.19p pd=1.38u as=0 ps=0 w=1u l=1u
X4319 VSS.t2052 VDD VSS.t2051 VSS.t2050 sg13_lv_nmos ad=0.1428p pd=1.52u as=0 ps=0 w=0.42u l=1u
X4320 VDD VSS.t1572 VDD VDD sg13_lv_pmos ad=0.19p pd=1.38u as=0 ps=0 w=1u l=1u
X4321 VSS.t2658 VDD VSS.t2659 VSS.t198 sg13_lv_nmos ad=79.8f pd=0.8u as=0 ps=0 w=0.42u l=1u
X4322 VDD VSS.t913 VDD VDD sg13_lv_pmos ad=0.34p pd=2.68u as=0 ps=0 w=1u l=1u
X4323 VSS.t2892 VDD VSS.t2891 VSS.t2890 sg13_lv_nmos ad=0.1428p pd=1.52u as=0 ps=0 w=0.42u l=1u
X4324 VSS.t2647 VDD VSS.t2647 VSS.t198 sg13_lv_nmos ad=0.1428p pd=1.52u as=0 ps=0 w=0.42u l=1u
X4325 VDD VSS.t2659 VDD VDD sg13_lv_pmos ad=0.34p pd=2.68u as=0 ps=0 w=1u l=1u
X4326 VSS.t1937 VDD VSS.t1936 VSS.t1935 sg13_lv_nmos ad=0.1428p pd=1.52u as=0 ps=0 w=0.42u l=1u
X4327 VDD VSS.t415 VDD VDD sg13_lv_pmos ad=0.19p pd=1.38u as=0 ps=0 w=1u l=1u
X4328 VSS.t59 VDD VSS.t351 VSS.t350 sg13_lv_nmos ad=79.8f pd=0.8u as=0 ps=0 w=0.42u l=1u
X4329 VDD VSS.t861 VDD VDD sg13_lv_pmos ad=0.19p pd=1.38u as=0 ps=0 w=1u l=1u
X4330 a_25930_14452# a_26373_14495# a_26313_14531# VDD sg13_lv_pmos ad=79.8f pd=0.8u as=63f ps=0.72u w=0.42u l=0.13u
X4331 sg13cmos5l_buf_8_2.X a_19323_13726# VDD VDD sg13_lv_pmos ad=0.2128p pd=1.5u as=0.2128p ps=1.5u w=1.12u l=0.13u
X4332 VSS.t949 VDD VSS.t948 VSS.t947 sg13_lv_nmos ad=0.1428p pd=1.52u as=0 ps=0 w=0.42u l=1u
X4333 VDD VSS.t2238 VDD VDD sg13_lv_pmos ad=0.34p pd=2.68u as=0 ps=0 w=1u l=1u
X4334 VSS.t1252 VDD VSS.t1253 VSS.t1154 sg13_lv_nmos ad=79.8f pd=0.8u as=0 ps=0 w=0.42u l=1u
X4335 VSS.t2469 VDD VSS.t2471 VSS.t2470 sg13_lv_nmos ad=79.8f pd=0.8u as=0 ps=0 w=0.42u l=1u
X4336 a_21348_14909# a_21060_14488# a_21286_14909# VSS.t139 sg13_lv_nmos ad=0.1428p pd=1.52u as=37.8f ps=0.6u w=0.42u l=0.13u
X4337 VSS.t411 VDD VSS.t410 VSS.t11 sg13_lv_nmos ad=0.1428p pd=1.52u as=0 ps=0 w=0.42u l=1u
X4338 VSS.t1465 VDD VSS.t1464 VSS.t1463 sg13_lv_nmos ad=0.1428p pd=1.52u as=0 ps=0 w=0.42u l=1u
X4339 VDD VSS.t2969 VDD VDD sg13_lv_pmos ad=0.19p pd=1.38u as=0 ps=0 w=1u l=1u
X4340 VDD VSS.t3146 VDD VDD sg13_lv_pmos ad=0.34p pd=2.68u as=0 ps=0 w=1u l=1u
X4341 VSS.t2374 VDD VSS.t2373 VSS.t2372 sg13_lv_nmos ad=0.1428p pd=1.52u as=0 ps=0 w=0.42u l=1u
X4342 VSS.t1847 VDD VSS.t1846 VSS.t1845 sg13_lv_nmos ad=0.1428p pd=1.52u as=0 ps=0 w=0.42u l=1u
X4343 VSS.t779 VDD VSS.t778 VSS.t777 sg13_lv_nmos ad=0.1428p pd=1.52u as=0 ps=0 w=0.42u l=1u
X4344 VDD VSS.t1234 VDD VDD sg13_lv_pmos ad=0.34p pd=2.68u as=0 ps=0 w=1u l=1u
X4345 a_17057_14832# sg13cmos5l_a21oi_1_0.A1 sg13cmos5l_a21oi_1_0.Y VSS.t113 sg13_lv_nmos ad=0.1406p pd=1.12u as=0.1406p ps=1.12u w=0.74u l=0.13u
X4346 VSS.t44 a_6682_13690# a_6401_13912# VSS.t3220 sg13_lv_nmos ad=79.8f pd=0.8u as=0.1428p ps=1.52u w=0.42u l=0.5u
X4347 VSS.t521 VDD VSS.t520 VSS.t519 sg13_lv_nmos ad=0.1428p pd=1.52u as=0 ps=0 w=0.42u l=1u
X4348 VSS.t1009 VDD VSS.t1011 VSS.t1010 sg13_lv_nmos ad=79.8f pd=0.8u as=0 ps=0 w=0.42u l=1u
X4349 VDD VSS.t1188 VDD VDD sg13_lv_pmos ad=0.19p pd=1.38u as=0 ps=0 w=1u l=1u
X4350 VSS.t2811 VDD VSS.t2667 VSS.t198 sg13_lv_nmos ad=0.1428p pd=1.52u as=0 ps=0 w=0.42u l=1u
R0 VSS.t60 VSS.n755 2.277e+06
R1 VSS.t3218 VSS.n767 1.34743e+06
R2 VSS.n945 VSS.t198 4108.7
R3 VSS.n945 VSS.n453 4108.7
R4 VSS.n453 VSS.n510 4108.7
R5 VSS.n510 VSS.t1154 4108.7
R6 VSS.t1154 VSS.n599 4108.7
R7 VSS.n599 VSS.n154 4108.7
R8 VSS.n154 VSS.n719 4108.7
R9 VSS.t2890 VSS.n126 182.042
R10 VSS.t2893 VSS.n126 183.806
R11 VSS.t2898 VSS.n126 183.804
R12 VSS.n126 VSS.t2928 183.806
R13 VSS.n126 VSS.t2943 183.806
R14 VSS.n126 VSS.t2948 183.805
R15 VSS.n126 VSS.t2968 183.806
R16 VSS.n126 VSS.t2973 183.805
R17 VSS.n126 VSS.t2978 183.806
R18 VSS.t2988 VSS.n126 183.806
R19 VSS.t2998 VSS.n126 183.805
R20 VSS.t3018 VSS.n126 183.805
R21 VSS.t3028 VSS.n126 183.805
R22 VSS.t3043 VSS.n126 183.806
R23 VSS.t3048 VSS.n126 183.806
R24 VSS.t3058 VSS.n126 183.806
R25 VSS.t3093 VSS.n126 183.805
R26 VSS.t3113 VSS.n126 183.806
R27 VSS.t3128 VSS.n126 183.806
R28 VSS.t3138 VSS.n126 183.805
R29 VSS.n126 VSS.t3143 183.805
R30 VSS.t3148 VSS.n126 183.805
R31 VSS.t3158 VSS.n126 183.805
R32 VSS.t198 VSS.n126 4435.04
R33 VSS.t159 VSS.t197 612.602
R34 VSS.t2245 VSS.n77 109.992
R35 VSS.t2255 VSS.n77 109.993
R36 VSS.t2260 VSS.n77 109.992
R37 VSS.t2280 VSS.n77 109.992
R38 VSS.t2295 VSS.n77 109.993
R39 VSS.t2310 VSS.n77 109.992
R40 VSS.t2330 VSS.n77 109.992
R41 VSS.t2350 VSS.n77 109.993
R42 VSS.t2355 VSS.n77 109.992
R43 VSS.t2370 VSS.n77 109.993
R44 VSS.t2375 VSS.n77 109.992
R45 VSS.n77 VSS.t2400 109.992
R46 VSS.n77 VSS.t2450 109.992
R47 VSS.n77 VSS.t2470 109.993
R48 VSS.t2475 VSS.n77 109.992
R49 VSS.n77 VSS.t2500 109.992
R50 VSS.t1843 VSS.n76 109.992
R51 VSS.n76 VSS.t1855 109.001
R52 VSS.t1878 VSS.n76 109.992
R53 VSS.t1893 VSS.n76 109.993
R54 VSS.n76 VSS.t1900 108.999
R55 VSS.n76 VSS.t1925 109.001
R56 VSS.t1943 VSS.n76 109.992
R57 VSS.t1973 VSS.n76 109.992
R58 VSS.t1988 VSS.n76 109.993
R59 VSS.t2013 VSS.n76 109.993
R60 VSS.t2033 VSS.n76 109.993
R61 VSS.t2043 VSS.n76 109.992
R62 VSS.t2058 VSS.n76 109.992
R63 VSS.t2063 VSS.n76 109.993
R64 VSS.t2068 VSS.n76 109.992
R65 VSS.t2088 VSS.n76 109.992
R66 VSS.t2108 VSS.n76 109.992
R67 VSS.t1461 VSS.n75 109.992
R68 VSS.t1476 VSS.n75 109.992
R69 VSS.t1506 VSS.n75 109.992
R70 VSS.n75 VSS.t1533 108.999
R71 VSS.n75 VSS.t1571 109.992
R72 VSS.t1576 VSS.n75 109.992
R73 VSS.t1596 VSS.n75 109.992
R74 VSS.n75 VSS.t1641 109.992
R75 VSS.t1646 VSS.n75 109.993
R76 VSS.n75 VSS.t1651 109.992
R77 VSS.t1666 VSS.n75 109.993
R78 VSS.t1696 VSS.n75 109.992
R79 VSS.n74 VSS.t772 108.999
R80 VSS.t780 VSS.n74 109.992
R81 VSS.t790 VSS.n74 109.993
R82 VSS.t795 VSS.n74 109.992
R83 VSS.t825 VSS.n74 109.992
R84 VSS.n74 VSS.t842 109.001
R85 VSS.t865 VSS.n74 109.992
R86 VSS.t875 VSS.n74 109.992
R87 VSS.t880 VSS.n74 109.993
R88 VSS.t885 VSS.n74 109.992
R89 VSS.t900 VSS.n74 109.992
R90 VSS.t910 VSS.n74 109.993
R91 VSS.t935 VSS.n74 109.992
R92 VSS.t945 VSS.n74 109.993
R93 VSS.t950 VSS.n74 109.992
R94 VSS.t955 VSS.n74 109.993
R95 VSS.t960 VSS.n74 109.992
R96 VSS.t985 VSS.n74 109.992
R97 VSS.t1005 VSS.n74 109.992
R98 VSS.t1025 VSS.n74 109.96
R99 VSS.t69 VSS.n141 26.1545
R100 VSS.n166 VSS.t72 8.48859
R101 VSS.n153 VSS.t72 15.2046
R102 VSS.t522 VSS.t72 109.986
R103 VSS.t527 VSS.t72 109.992
R104 VSS.t532 VSS.t72 109.992
R105 VSS.t72 VSS.t567 109.998
R106 VSS.n155 VSS.t55 60.3116
R107 VSS.t386 VSS.t11 109.986
R108 VSS.n91 VSS.t3201 424.017
R109 VSS.n111 VSS.t72 0.356769
R110 VSS.n6 VSS.t22 418.56
R111 VSS.t72 VSS.t720 237.142
R112 VSS.n140 VSS.t238 66.199
R113 VSS.n77 VSS.n945 427.5
R114 VSS.n76 VSS.n453 427.5
R115 VSS.n75 VSS.n510 427.5
R116 VSS.n74 VSS.n599 427.5
R117 VSS.t600 VSS.n235 242.846
R118 VSS.t621 VSS.n262 242.846
R119 VSS.t3188 VSS.n148 420.111
R120 VSS.t705 VSS.n173 242.846
R121 VSS.t707 VSS.n269 242.846
R122 VSS.t709 VSS.n234 242.846
R123 VSS.t711 VSS.n268 242.846
R124 VSS.n232 VSS.t653 242.846
R125 VSS.t11 VSS.n719 427.5
R126 VSS.t3202 VSS.n745 408.31
R127 VSS.n803 VSS.t3254 407.144
R128 VSS.n939 VSS.t31 407.144
R129 VSS.t40 VSS.n890 407.144
R130 VSS.t3246 VSS.n882 407.144
R131 VSS.t2885 VSS.n126 181.874
R132 VSS.t2895 VSS.n126 182.042
R133 VSS.n126 VSS.t2905 182.042
R134 VSS.t2910 VSS.n126 182.042
R135 VSS.t2920 VSS.n126 182.042
R136 VSS.t2930 VSS.n126 182.042
R137 VSS.t2950 VSS.n126 182.042
R138 VSS.t2960 VSS.n126 182.042
R139 VSS.n126 VSS.t2990 182.042
R140 VSS.n126 VSS.t3000 182.042
R141 VSS.n126 VSS.t3010 182.042
R142 VSS.n126 VSS.t3020 182.042
R143 VSS.n126 VSS.t3035 182.042
R144 VSS.n126 VSS.t3065 182.042
R145 VSS.n126 VSS.t3070 182.042
R146 VSS.n126 VSS.t3080 182.042
R147 VSS.n126 VSS.t3095 182.042
R148 VSS.n126 VSS.t3115 182.042
R149 VSS.t3150 VSS.n126 182.042
R150 VSS.n794 VSS.t97 402.858
R151 VSS.t53 VSS.n270 249.002
R152 VSS.t218 VSS.n256 119.835
R153 VSS.t73 VSS.n141 75.2357
R154 VSS.n929 VSS.t54 398.572
R155 VSS.t115 VSS.n765 398.572
R156 VSS.t110 VSS.t204 398.572
R157 VSS.n89 VSS.t3234 398.228
R158 VSS.t151 VSS.n85 397.132
R159 VSS.n878 VSS.t3168 397.132
R160 VSS.n814 VSS.t126 394.286
R161 VSS.n126 VSS.t2888 183.806
R162 VSS.n759 VSS.t96 391.118
R163 VSS.n927 VSS.t3253 390
R164 VSS.t32 VSS.n778 390
R165 VSS.t3169 VSS.n158 36.5344
R166 VSS.t3265 VSS.n99 386.526
R167 VSS.n808 VSS.t3267 385.714
R168 VSS.n737 VSS.t3278 385.714
R169 VSS.n86 VSS.t3191 385.334
R170 VSS.t3261 VSS.n875 384.274
R171 VSS.t43 VSS.n787 381.43
R172 VSS.n940 VSS.t29 381.43
R173 VSS.t185 VSS.n738 381.43
R174 VSS.n87 VSS.t3236 381.036
R175 VSS.t183 VSS.n91 381.036
R176 VSS.t3192 VSS.n789 377.144
R177 VSS.t205 VSS.n773 377.144
R178 VSS.n884 VSS.t3290 377.144
R179 VSS.t71 VSS.n132 43.6455
R180 VSS.t3283 VSS.n99 376.724
R181 VSS.t3176 VSS.n802 368.572
R182 VSS.t66 VSS.n815 368.572
R183 VSS.n816 VSS.t231 368.572
R184 VSS.n792 VSS.t99 368.572
R185 VSS.t3270 VSS.n881 368.572
R186 VSS.t62 VSS.n92 368.142
R187 VSS.n93 VSS.t3194 368.142
R188 VSS.n780 VSS.t33 364.286
R189 VSS.n886 VSS.t3244 364.286
R190 VSS.n943 VSS.t255 361.033
R191 VSS.t61 VSS.n746 361.033
R192 VSS.t118 VSS.n736 360
R193 VSS.n805 VSS.t3256 355.714
R194 VSS.n941 VSS.t28 355.714
R195 VSS.t20 VSS.n892 355.714
R196 VSS.t3248 VSS.n880 355.714
R197 VSS.t73 VSS.n820 351.43
R198 VSS.t179 VSS.n825 351.43
R199 VSS.t3197 VSS.n797 351.43
R200 VSS.n790 VSS.t165 351.43
R201 VSS.n155 VSS.t3242 99.148
R202 VSS.t206 VSS.n772 351.43
R203 VSS.n885 VSS.t14 351.43
R204 VSS.t109 VSS.n94 350.95
R205 VSS.n762 VSS.t234 348.139
R206 VSS.t153 VSS.n798 347.144
R207 VSS.n770 VSS.t128 347.144
R208 VSS.n816 VSS.t3185 342.858
R209 VSS.t46 VSS.n89 342.354
R210 VSS.t141 VSS.n93 342.354
R211 VSS.n146 VSS.t86 65.92
R212 VSS.t3285 VSS.n741 339.543
R213 VSS.n801 VSS.t3251 338.572
R214 VSS.n157 VSS.t3276 67.9
R215 VSS.t208 VSS.n785 338.572
R216 VSS.n887 VSS.t3243 338.572
R217 VSS.t3211 VSS.n898 337.046
R218 VSS.t108 VSS.n756 335.245
R219 VSS.t2913 VSS.n126 183.806
R220 VSS.t2963 VSS.n126 183.806
R221 VSS.t2993 VSS.n126 183.806
R222 VSS.t3003 VSS.n126 183.806
R223 VSS.t3008 VSS.n126 183.806
R224 VSS.t3033 VSS.n126 183.806
R225 VSS.t3063 VSS.n126 183.806
R226 VSS.t3073 VSS.n126 183.806
R227 VSS.t3088 VSS.n126 183.806
R228 VSS.t3103 VSS.n126 183.806
R229 VSS.t3133 VSS.n126 183.806
R230 VSS.t3163 VSS.n126 183.806
R231 VSS.t3222 VSS.t51 330.947
R232 VSS.n806 VSS.t3257 330
R233 VSS.t3277 VSS.n891 330
R234 VSS.t144 VSS.n140 167.082
R235 VSS.n933 VSS.t48 329.168
R236 VSS.t173 VSS.n865 329.168
R237 VSS.t217 VSS.n864 329.168
R238 VSS.t12 VSS.n150 83.7485
R239 VSS.n740 VSS.t3219 329.168
R240 VSS.t3200 VSS.t177 326.649
R241 VSS.t195 VSS.n824 325.714
R242 VSS.n866 VSS.t207 325.714
R243 VSS.t11 VSS.t127 321.486
R244 VSS.n159 VSS.t114 77.4642
R245 VSS.n4 VSS.t161 319.99
R246 VSS.t3250 VSS.n878 319.99
R247 VSS.t120 VSS.n83 319.99
R248 VSS.n126 VSS.t3160 182.042
R249 VSS.t3155 VSS.n126 182.042
R250 VSS.t3153 VSS.n126 183.806
R251 VSS.t3145 VSS.n126 182.042
R252 VSS.n126 VSS.t3140 182.042
R253 VSS.t3135 VSS.n126 182.042
R254 VSS.n126 VSS.t3130 182.042
R255 VSS.t3125 VSS.n126 182.042
R256 VSS.t3120 VSS.n126 182.042
R257 VSS.n126 VSS.t3118 183.806
R258 VSS.t3110 VSS.n126 182.042
R259 VSS.t3105 VSS.n126 182.042
R260 VSS.t3100 VSS.n126 182.042
R261 VSS.n126 VSS.t3098 183.805
R262 VSS.t3090 VSS.n126 182.042
R263 VSS.t3085 VSS.n126 182.042
R264 VSS.n126 VSS.t3083 183.806
R265 VSS.t3075 VSS.n126 182.042
R266 VSS.n126 VSS.t3068 183.805
R267 VSS.t3060 VSS.n126 182.042
R268 VSS.t3055 VSS.n126 182.042
R269 VSS.t3050 VSS.n126 182.042
R270 VSS.t3045 VSS.n126 182.042
R271 VSS.t3040 VSS.n126 182.042
R272 VSS.n126 VSS.t3038 183.805
R273 VSS.t3030 VSS.n126 182.042
R274 VSS.t3025 VSS.n126 182.042
R275 VSS.n126 VSS.t3023 183.806
R276 VSS.t3015 VSS.n126 182.042
R277 VSS.n126 VSS.t3013 183.805
R278 VSS.t3005 VSS.n126 182.042
R279 VSS.t2995 VSS.n126 182.042
R280 VSS.t2985 VSS.n126 182.042
R281 VSS.t2980 VSS.n126 182.042
R282 VSS.n126 VSS.t2975 182.042
R283 VSS.n126 VSS.t2970 182.042
R284 VSS.n126 VSS.t2965 182.042
R285 VSS.n126 VSS.t2955 182.042
R286 VSS.t2953 VSS.n126 183.806
R287 VSS.n126 VSS.t2945 182.042
R288 VSS.n126 VSS.t2940 182.042
R289 VSS.n126 VSS.t2935 182.042
R290 VSS.t2933 VSS.n126 183.805
R291 VSS.n126 VSS.t2925 182.042
R292 VSS.t2923 VSS.n126 183.806
R293 VSS.n126 VSS.t2915 182.042
R294 VSS.t2908 VSS.n126 183.805
R295 VSS.t2900 VSS.n126 182.042
R296 VSS.n761 VSS.t3178 313.755
R297 VSS.n767 VSS.t38 313.755
R298 VSS.t137 VSS.n800 312.858
R299 VSS.n793 VSS.t3193 312.858
R300 VSS.n781 VSS.t130 312.858
R301 VSS.n888 VSS.t3239 312.858
R302 VSS.t3293 VSS.n879 312.858
R303 VSS.t725 VSS.n819 305.159
R304 VSS.n755 VSS.n751 305.159
R305 VSS.n152 VSS.t3266 312.969
R306 VSS.t10 VSS.n898 292.264
R307 VSS.n897 VSS.t200 292.264
R308 VSS.n752 VSS.t90 292.264
R309 VSS.t3217 VSS.n157 304.37
R310 VSS.t216 VSS.n785 291.43
R311 VSS.n92 VSS.t3180 290.779
R312 VSS.t131 VSS.n776 287.144
R313 VSS.n739 VSS.t3203 287.144
R314 VSS.n901 VSS.t41 283.334
R315 VSS.t3210 VSS.n864 283.334
R316 VSS.n873 VSS.t259 283.334
R317 VSS.t253 VSS.t18 279.37
R318 VSS.t256 VSS.t36 279.37
R319 VSS.t134 VSS.n143 93.6797
R320 VSS.n819 VSS.t77 275.072
R321 VSS.n897 VSS.t79 275.072
R322 VSS.t76 VSS.n867 275.072
R323 VSS.n751 VSS.t3182 275.072
R324 VSS.n94 VSS.t3198 273.587
R325 VSS.n3 VSS.t251 272.846
R326 VSS.t3232 VSS.t45 266.476
R327 VSS.n757 VSS.t3175 266.476
R328 VSS.t160 VSS.t212 266.476
R329 VSS.t210 VSS.t140 266.476
R330 VSS.t194 VSS.t146 265.714
R331 VSS.n889 VSS.t63 265.714
R332 VSS.n782 VSS.t133 261.43
R333 VSS.n890 VSS.t3237 261.43
R334 VSS.n925 VSS.t70 258.334
R335 VSS.t249 VSS.t3215 258.334
R336 VSS.t3195 VSS.n930 258.334
R337 VSS.n900 VSS.t229 258.334
R338 VSS.t215 VSS.t139 258.334
R339 VSS.t50 VSS.n871 258.334
R340 VSS.t218 VSS.t3231 258.334
R341 VSS.n125 VSS.t78 288.68
R342 VSS.n943 VSS.t449 257.88
R343 VSS.n791 VSS.t3220 257.144
R344 VSS.n768 VSS.t3199 257.144
R345 VSS.t176 VSS.n876 257.144
R346 VSS.t211 VSS.n748 253.583
R347 VSS.t504 VSS.t72 109.001
R348 VSS.t509 VSS.t72 108.999
R349 VSS.t72 VSS.t511 108.999
R350 VSS.n15 VSS.t592 251.417
R351 VSS.n20 VSS.t595 251.417
R352 VSS.n23 VSS.t598 251.417
R353 VSS.n19 VSS.t601 251.417
R354 VSS.n16 VSS.t604 251.417
R355 VSS.n33 VSS.t607 251.417
R356 VSS.n30 VSS.t610 251.417
R357 VSS.n34 VSS.t613 251.417
R358 VSS.n37 VSS.t616 251.417
R359 VSS.n42 VSS.t619 251.417
R360 VSS.n45 VSS.t622 251.417
R361 VSS.n41 VSS.t625 251.417
R362 VSS.n38 VSS.t628 251.417
R363 VSS.n29 VSS.t631 251.417
R364 VSS.n27 VSS.t634 251.417
R365 VSS.n10 VSS.t706 251.417
R366 VSS.n13 VSS.t708 251.417
R367 VSS.n9 VSS.t710 251.417
R368 VSS.t712 VSS.n7 251.417
R369 VSS.t72 VSS.n154 427.5
R370 VSS.n1 VSS.t652 251.417
R371 VSS.n96 VSS.t391 251.417
R372 VSS.n98 VSS.t464 251.417
R373 VSS.n934 VSS.t248 250.952
R374 VSS.n874 VSS.t3213 250.952
R375 VSS.t3230 VSS.n734 250.952
R376 VSS.n870 VSS.t117 250
R377 VSS.t122 VSS.n102 249.002
R378 VSS.n82 VSS.t104 249.002
R379 VSS.t60 VSS.n88 243.5
R380 VSS.t72 VSS.t516 109.993
R381 VSS.t72 VSS.t699 243.47
R382 VSS.n14 VSS.t731 242.846
R383 VSS.n21 VSS.t733 242.846
R384 VSS.n22 VSS.t735 242.846
R385 VSS.n18 VSS.t737 242.846
R386 VSS.n17 VSS.t739 242.846
R387 VSS.n32 VSS.t741 242.846
R388 VSS.n31 VSS.t743 242.846
R389 VSS.n35 VSS.t745 242.846
R390 VSS.n36 VSS.t747 242.846
R391 VSS.n43 VSS.t749 242.846
R392 VSS.n44 VSS.t751 242.846
R393 VSS.n40 VSS.t753 242.846
R394 VSS.n39 VSS.t755 242.846
R395 VSS.n28 VSS.t757 242.846
R396 VSS.n11 VSS.t579 242.846
R397 VSS.n12 VSS.t582 242.846
R398 VSS.n8 VSS.t585 242.846
R399 VSS.n2 VSS.t518 242.846
R400 VSS.n97 VSS.t463 242.846
R401 VSS.n98 VSS.t392 242.846
R402 VSS.n139 VSS.t11 9.30614
R403 VSS.n83 VSS.t389 242.846
R404 VSS.t106 VSS.t0 240.689
R405 VSS.n132 VSS.t722 238.357
R406 VSS.n754 VSS.t451 236.391
R407 VSS.n77 VSS.t2227 108.722
R408 VSS.n77 VSS.t2232 109.001
R409 VSS.n77 VSS.t2237 108.999
R410 VSS.n77 VSS.t2262 108.999
R411 VSS.n77 VSS.t2282 108.999
R412 VSS.n77 VSS.t2287 109.001
R413 VSS.n77 VSS.t2302 108.999
R414 VSS.n77 VSS.t2312 108.999
R415 VSS.n77 VSS.t2332 108.999
R416 VSS.n77 VSS.t2342 108.999
R417 VSS.n77 VSS.t2357 108.999
R418 VSS.n77 VSS.t2377 108.999
R419 VSS.n77 VSS.t2382 108.999
R420 VSS.n77 VSS.t2402 108.999
R421 VSS.t2407 VSS.n77 109.001
R422 VSS.n77 VSS.t2422 108.999
R423 VSS.t2427 VSS.n77 109.001
R424 VSS.n77 VSS.t2432 108.999
R425 VSS.n77 VSS.t2442 108.999
R426 VSS.n77 VSS.t2452 108.999
R427 VSS.n77 VSS.t2462 108.999
R428 VSS.t2477 VSS.n77 108.999
R429 VSS.n77 VSS.t2482 109.001
R430 VSS.n77 VSS.t2492 108.999
R431 VSS.n77 VSS.t2502 108.999
R432 VSS.n76 VSS.t1845 108.999
R433 VSS.n76 VSS.t1895 109.001
R434 VSS.n76 VSS.t1920 108.999
R435 VSS.n76 VSS.t1945 108.999
R436 VSS.n76 VSS.t1955 108.999
R437 VSS.n76 VSS.t1960 109.001
R438 VSS.n76 VSS.t1965 108.999
R439 VSS.n76 VSS.t1980 108.999
R440 VSS.n76 VSS.t1990 109.001
R441 VSS.n76 VSS.t1995 108.999
R442 VSS.n76 VSS.t2015 108.999
R443 VSS.n76 VSS.t2020 109.001
R444 VSS.n76 VSS.t2035 108.999
R445 VSS.t2090 VSS.n76 108.999
R446 VSS.t2110 VSS.n76 108.999
R447 VSS.n75 VSS.t1443 108.722
R448 VSS.n75 VSS.t1448 109.001
R449 VSS.n75 VSS.t1453 108.999
R450 VSS.n75 VSS.t1468 108.999
R451 VSS.n75 VSS.t1478 108.999
R452 VSS.n75 VSS.t1508 108.999
R453 VSS.t1548 VSS.n75 108.999
R454 VSS.n75 VSS.t1553 108.999
R455 VSS.t1578 VSS.n75 108.999
R456 VSS.t1598 VSS.n75 108.999
R457 VSS.n75 VSS.t1603 108.999
R458 VSS.t1618 VSS.n75 108.999
R459 VSS.n75 VSS.t1623 108.999
R460 VSS.t1628 VSS.n75 109.001
R461 VSS.n75 VSS.t1633 108.999
R462 VSS.t1668 VSS.n75 108.999
R463 VSS.t1688 VSS.n75 108.999
R464 VSS.t1698 VSS.n75 109.001
R465 VSS.n75 VSS.t1703 109.05
R466 VSS.t1708 VSS.n75 108.999
R467 VSS.t1718 VSS.n75 108.999
R468 VSS.n74 VSS.t817 108.999
R469 VSS.n74 VSS.t827 108.999
R470 VSS.n74 VSS.t832 109.001
R471 VSS.n74 VSS.t837 108.999
R472 VSS.n74 VSS.t857 108.999
R473 VSS.n74 VSS.t867 108.999
R474 VSS.n74 VSS.t887 108.999
R475 VSS.n74 VSS.t902 108.999
R476 VSS.n74 VSS.t912 108.999
R477 VSS.n74 VSS.t927 108.999
R478 VSS.n74 VSS.t937 108.999
R479 VSS.n74 VSS.t962 108.999
R480 VSS.n74 VSS.t977 108.999
R481 VSS.n74 VSS.t997 108.999
R482 VSS.t1007 VSS.n74 108.999
R483 VSS.t1017 VSS.n74 108.999
R484 VSS.t1027 VSS.n74 108.999
R485 VSS.n74 VSS.t1032 109.001
R486 VSS.t1037 VSS.n74 108.999
R487 VSS.n267 VSS.t730 251.417
R488 VSS.n185 VSS.t732 251.417
R489 VSS.n266 VSS.t734 251.417
R490 VSS.n235 VSS.t736 251.417
R491 VSS.n265 VSS.t738 251.417
R492 VSS.n168 VSS.t740 251.417
R493 VSS.n264 VSS.t742 251.417
R494 VSS.n236 VSS.t744 251.417
R495 VSS.n263 VSS.t746 251.417
R496 VSS.n184 VSS.t748 251.417
R497 VSS.n262 VSS.t750 251.417
R498 VSS.n237 VSS.t752 251.417
R499 VSS.n261 VSS.t754 251.417
R500 VSS.n174 VSS.t756 251.417
R501 VSS.n260 VSS.t758 251.417
R502 VSS.n928 VSS.t687 235.714
R503 VSS.t691 VSS.n146 238.992
R504 VSS.n145 VSS.t692 106.677
R505 VSS.n143 VSS.t695 241.448
R506 VSS.n808 VSS.t702 235.714
R507 VSS.n173 VSS.t577 251.417
R508 VSS.n269 VSS.t581 251.417
R509 VSS.n234 VSS.t584 251.417
R510 VSS.n268 VSS.t587 251.417
R511 VSS.n817 VSS.t716 235.714
R512 VSS.n794 VSS.t517 235.714
R513 VSS.n795 VSS.t654 235.714
R514 VSS.t72 VSS.t534 109.001
R515 VSS.t554 VSS.t72 109.001
R516 VSS.t559 VSS.t72 109.001
R517 VSS.n156 VSS.t11 0.369499
R518 VSS.n938 VSS.t460 235.714
R519 VSS.n782 VSS.t462 235.714
R520 VSS.t11 VSS.t383 108.722
R521 VSS.t11 VSS.t388 252.065
R522 VSS.n896 VSS.t174 233.333
R523 VSS.t8 VSS.n870 233.333
R524 VSS.n84 VSS.t3204 232.335
R525 VSS.n932 VSS.t679 229.167
R526 VSS.n142 VSS.t452 102.749
R527 VSS.n76 VSS.t1838 109.986
R528 VSS.n76 VSS.t1853 109.992
R529 VSS.n76 VSS.t1868 109.992
R530 VSS.n76 VSS.t1913 109.993
R531 VSS.n75 VSS.t1486 109.992
R532 VSS.n75 VSS.t1501 109.993
R533 VSS.n75 VSS.t1516 109.993
R534 VSS.n75 VSS.t1526 109.993
R535 VSS.n75 VSS.t1531 109.992
R536 VSS.n74 VSS.t770 109.992
R537 VSS.n74 VSS.t810 109.992
R538 VSS.n824 VSS.t729 227.143
R539 VSS.n185 VSS.t594 242.846
R540 VSS.n266 VSS.t597 242.846
R541 VSS.n265 VSS.t603 242.846
R542 VSS.n168 VSS.t606 242.846
R543 VSS.n264 VSS.t609 242.846
R544 VSS.n236 VSS.t612 242.846
R545 VSS.n263 VSS.t615 242.846
R546 VSS.n184 VSS.t618 242.846
R547 VSS.n237 VSS.t624 242.846
R548 VSS.n261 VSS.t627 242.846
R549 VSS.n174 VSS.t630 242.846
R550 VSS.n260 VSS.t633 242.846
R551 VSS.n153 VSS.t655 228.291
R552 VSS.t461 VSS.n777 227.143
R553 VSS.t258 VSS.t80 225
R554 VSS.t72 VSS.t651 111.022
R555 VSS.t72 VSS.n157 3.41028
R556 VSS.n149 VSS.t72 3.67123
R557 VSS.t390 VSS.n88 222.011
R558 VSS.t591 VSS.n6 221.417
R559 VSS.n95 VSS.t393 221.417
R560 VSS.t395 VSS.n893 221.417
R561 VSS.n931 VSS.t681 220.833
R562 VSS.t3281 VSS.t245 212.5
R563 VSS.n142 VSS.t390 214.988
R564 VSS.t697 VSS.t3255 205.714
R565 VSS.n149 VSS.t575 107.358
R566 VSS.n166 VSS.t715 102.707
R567 VSS.n817 VSS.t591 205.714
R568 VSS.t569 VSS.n151 15.0018
R569 VSS.t393 VSS.n139 212.761
R570 VSS.t466 VSS.n866 205.714
R571 VSS.n259 VSS.t466 221.417
R572 VSS.n259 VSS.t395 221.417
R573 VSS.n142 VSS.t11 7.66894
R574 VSS.t694 VSS.t72 109.981
R575 VSS.t2230 VSS.n77 109.986
R576 VSS.t2275 VSS.n77 109.993
R577 VSS.t2285 VSS.n77 109.993
R578 VSS.t2315 VSS.n77 109.993
R579 VSS.n77 VSS.t2320 109.992
R580 VSS.t2325 VSS.n77 109.993
R581 VSS.t2345 VSS.n77 109.993
R582 VSS.t2385 VSS.n77 109.993
R583 VSS.t2395 VSS.n77 109.993
R584 VSS.t2405 VSS.n77 109.993
R585 VSS.t2415 VSS.n77 109.993
R586 VSS.t2425 VSS.n77 109.993
R587 VSS.t2435 VSS.n77 109.993
R588 VSS.t2480 VSS.n77 109.993
R589 VSS.t2505 VSS.n77 109.993
R590 VSS.t1863 VSS.n76 109.993
R591 VSS.t1873 VSS.n76 109.993
R592 VSS.t1883 VSS.n76 109.993
R593 VSS.t1903 VSS.n76 109.993
R594 VSS.t1933 VSS.n76 109.993
R595 VSS.t1938 VSS.n76 109.993
R596 VSS.t1958 VSS.n76 109.993
R597 VSS.t1983 VSS.n76 109.993
R598 VSS.t1998 VSS.n76 109.993
R599 VSS.t2018 VSS.n76 109.993
R600 VSS.t2048 VSS.n76 109.993
R601 VSS.t2053 VSS.n76 109.993
R602 VSS.n76 VSS.t2073 109.993
R603 VSS.t2078 VSS.n76 109.993
R604 VSS.t2093 VSS.n76 109.993
R605 VSS.t2103 VSS.n76 109.993
R606 VSS.t2113 VSS.n76 109.993
R607 VSS.t1446 VSS.n75 109.986
R608 VSS.t1491 VSS.n75 109.993
R609 VSS.t1511 VSS.n75 109.993
R610 VSS.t1536 VSS.n75 109.993
R611 VSS.t1546 VSS.n75 109.993
R612 VSS.t1566 VSS.n75 109.993
R613 VSS.t1586 VSS.n75 109.993
R614 VSS.t1606 VSS.n75 109.993
R615 VSS.t1616 VSS.n75 109.993
R616 VSS.t1636 VSS.n75 109.993
R617 VSS.t1656 VSS.n75 109.993
R618 VSS.t1681 VSS.n75 109.993
R619 VSS.t1721 VSS.n75 109.993
R620 VSS.t765 VSS.n74 109.986
R621 VSS.t775 VSS.n74 109.993
R622 VSS.t800 VSS.n74 109.993
R623 VSS.t805 VSS.n74 109.993
R624 VSS.t820 VSS.n74 109.993
R625 VSS.t850 VSS.n74 109.993
R626 VSS.n74 VSS.t855 109.992
R627 VSS.t860 VSS.n74 109.993
R628 VSS.t870 VSS.n74 109.993
R629 VSS.t895 VSS.n74 109.993
R630 VSS.t905 VSS.n74 109.993
R631 VSS.t925 VSS.n74 109.993
R632 VSS.t940 VSS.n74 109.993
R633 VSS.t965 VSS.n74 109.993
R634 VSS.t970 VSS.n74 109.993
R635 VSS.t990 VSS.n74 109.993
R636 VSS.t1020 VSS.n74 109.993
R637 VSS.t1030 VSS.n74 109.993
R638 VSS.t1040 VSS.n74 109.993
R639 VSS.t72 VSS.n144 86.7544
R640 VSS.t701 VSS.n148 102.457
R641 VSS.t502 VSS.t72 109.986
R642 VSS.t507 VSS.t72 109.993
R643 VSS.t677 VSS.n152 102.457
R644 VSS.t456 VSS.t11 200.613
R645 VSS.t729 VSS.n823 199.989
R646 VSS.t594 VSS.n14 199.989
R647 VSS.t597 VSS.n21 199.989
R648 VSS.t600 VSS.n22 199.989
R649 VSS.t603 VSS.n18 199.989
R650 VSS.t606 VSS.n17 199.989
R651 VSS.t609 VSS.n32 199.989
R652 VSS.t612 VSS.n31 199.989
R653 VSS.t615 VSS.n35 199.989
R654 VSS.t618 VSS.n36 199.989
R655 VSS.t621 VSS.n43 199.989
R656 VSS.t624 VSS.n44 199.989
R657 VSS.t627 VSS.n40 199.989
R658 VSS.t630 VSS.n39 199.989
R659 VSS.t633 VSS.n28 199.989
R660 VSS.t636 VSS.n111 109.579
R661 VSS.t705 VSS.n24 199.989
R662 VSS.t707 VSS.n11 199.989
R663 VSS.t709 VSS.n12 199.989
R664 VSS.t711 VSS.n8 199.989
R665 VSS.t714 VSS.t72 109.644
R666 VSS.n2 VSS.t653 199.989
R667 VSS.t392 VSS.n97 199.989
R668 VSS.t91 VSS.t47 193.411
R669 VSS.n77 VSS.t2497 109.001
R670 VSS.n77 VSS.t2495 109.993
R671 VSS.n77 VSS.t2487 109.05
R672 VSS.n77 VSS.t2485 109.992
R673 VSS.t2472 VSS.n77 109.001
R674 VSS.n77 VSS.t2467 108.999
R675 VSS.n77 VSS.t2465 109.993
R676 VSS.n77 VSS.t2457 109.001
R677 VSS.n77 VSS.t2455 109.993
R678 VSS.n77 VSS.t2447 109.001
R679 VSS.n77 VSS.t2445 109.993
R680 VSS.n77 VSS.t2437 109.001
R681 VSS.t2430 VSS.n77 109.992
R682 VSS.n77 VSS.t2417 109.001
R683 VSS.t2412 VSS.n77 108.999
R684 VSS.t2410 VSS.n77 109.992
R685 VSS.n77 VSS.t2397 109.001
R686 VSS.t2392 VSS.n77 108.999
R687 VSS.t2387 VSS.n77 109.001
R688 VSS.n77 VSS.t2380 109.993
R689 VSS.t2372 VSS.n77 109.001
R690 VSS.t2367 VSS.n77 108.999
R691 VSS.t2362 VSS.n77 109.001
R692 VSS.n77 VSS.t2360 109.993
R693 VSS.t2352 VSS.n77 109.001
R694 VSS.t2347 VSS.n77 108.999
R695 VSS.t2337 VSS.n77 109.001
R696 VSS.n77 VSS.t2335 109.993
R697 VSS.t2327 VSS.n77 109.001
R698 VSS.t2322 VSS.n77 108.999
R699 VSS.t2307 VSS.n77 109.001
R700 VSS.n77 VSS.t2305 109.993
R701 VSS.t2297 VSS.n77 109.001
R702 VSS.t2292 VSS.n77 108.999
R703 VSS.n77 VSS.t2290 109.992
R704 VSS.t2277 VSS.n77 109.001
R705 VSS.t2272 VSS.n77 108.999
R706 VSS.t2267 VSS.n77 109.001
R707 VSS.n77 VSS.t2265 109.993
R708 VSS.t2257 VSS.n77 109.001
R709 VSS.t2252 VSS.n77 108.999
R710 VSS.t2247 VSS.n77 109.001
R711 VSS.t2242 VSS.n77 109.001
R712 VSS.n77 VSS.t2240 109.993
R713 VSS.n77 VSS.t2235 109.992
R714 VSS.t2317 VSS.n77 109.001
R715 VSS.t2105 VSS.n76 109.001
R716 VSS.n76 VSS.t2100 108.999
R717 VSS.t2095 VSS.n76 109.05
R718 VSS.t2085 VSS.n76 109.001
R719 VSS.n76 VSS.t2080 109.001
R720 VSS.t2075 VSS.n76 108.999
R721 VSS.t2070 VSS.n76 108.999
R722 VSS.t2065 VSS.n76 109.001
R723 VSS.t2060 VSS.n76 108.999
R724 VSS.t2055 VSS.n76 109.001
R725 VSS.t2050 VSS.n76 108.999
R726 VSS.t2045 VSS.n76 108.999
R727 VSS.t2040 VSS.n76 109.001
R728 VSS.n76 VSS.t2038 109.993
R729 VSS.t2030 VSS.n76 108.999
R730 VSS.t2025 VSS.n76 109.001
R731 VSS.n76 VSS.t2023 109.992
R732 VSS.t2010 VSS.n76 108.999
R733 VSS.t2005 VSS.n76 109.001
R734 VSS.t2000 VSS.n76 109.001
R735 VSS.n76 VSS.t1993 109.992
R736 VSS.t1985 VSS.n76 108.999
R737 VSS.t1975 VSS.n76 109.001
R738 VSS.t1970 VSS.n76 109.001
R739 VSS.n76 VSS.t1968 109.993
R740 VSS.n76 VSS.t1963 109.992
R741 VSS.t1950 VSS.n76 109.001
R742 VSS.n76 VSS.t1948 109.993
R743 VSS.t1940 VSS.n76 109.001
R744 VSS.t1935 VSS.n76 108.999
R745 VSS.t1930 VSS.n76 108.999
R746 VSS.n76 VSS.t1923 109.993
R747 VSS.t1915 VSS.n76 109.001
R748 VSS.t1910 VSS.n76 108.999
R749 VSS.t1905 VSS.n76 109.001
R750 VSS.n76 VSS.t1898 109.992
R751 VSS.t1890 VSS.n76 108.999
R752 VSS.t1885 VSS.n76 109.001
R753 VSS.t1880 VSS.n76 108.999
R754 VSS.t1875 VSS.n76 109.001
R755 VSS.t1870 VSS.n76 108.999
R756 VSS.t1865 VSS.n76 109.001
R757 VSS.t1860 VSS.n76 108.999
R758 VSS.n76 VSS.t1858 109.992
R759 VSS.t1850 VSS.n76 109.001
R760 VSS.n76 VSS.t1848 109.993
R761 VSS.t1840 VSS.n76 109.001
R762 VSS.t1835 VSS.n76 108.722
R763 VSS.n76 VSS.t1928 109.992
R764 VSS.t1713 VSS.n75 109.001
R765 VSS.t1711 VSS.n75 109.993
R766 VSS.n75 VSS.t1706 109.96
R767 VSS.t1701 VSS.n75 109.992
R768 VSS.t1693 VSS.n75 109.001
R769 VSS.t1691 VSS.n75 109.993
R770 VSS.t1683 VSS.n75 109.001
R771 VSS.n75 VSS.t1678 108.999
R772 VSS.t1673 VSS.n75 109.001
R773 VSS.t1671 VSS.n75 109.993
R774 VSS.t1663 VSS.n75 108.999
R775 VSS.n75 VSS.t1658 109.001
R776 VSS.t1653 VSS.n75 108.999
R777 VSS.n75 VSS.t1648 109.001
R778 VSS.t1643 VSS.n75 108.999
R779 VSS.n75 VSS.t1638 109.001
R780 VSS.t1631 VSS.n75 109.992
R781 VSS.n75 VSS.t1626 109.993
R782 VSS.t1621 VSS.n75 109.993
R783 VSS.t1613 VSS.n75 108.999
R784 VSS.n75 VSS.t1608 109.001
R785 VSS.t1601 VSS.n75 109.993
R786 VSS.t1593 VSS.n75 109.001
R787 VSS.n75 VSS.t1588 109.001
R788 VSS.t1583 VSS.n75 108.999
R789 VSS.t1581 VSS.n75 109.993
R790 VSS.t1573 VSS.n75 109.001
R791 VSS.n75 VSS.t1568 109.001
R792 VSS.t1563 VSS.n75 108.999
R793 VSS.n75 VSS.t1558 109.001
R794 VSS.n75 VSS.t1556 109.993
R795 VSS.t1551 VSS.n75 109.993
R796 VSS.t1543 VSS.n75 108.999
R797 VSS.n75 VSS.t1538 109.001
R798 VSS.t1528 VSS.n75 109.001
R799 VSS.t1523 VSS.n75 108.999
R800 VSS.t1518 VSS.n75 109.001
R801 VSS.t1513 VSS.n75 108.999
R802 VSS.t1503 VSS.n75 109.001
R803 VSS.t1498 VSS.n75 108.999
R804 VSS.t1493 VSS.n75 109.001
R805 VSS.t1488 VSS.n75 108.999
R806 VSS.t1483 VSS.n75 109.001
R807 VSS.n75 VSS.t1481 109.993
R808 VSS.t1473 VSS.n75 109.001
R809 VSS.n75 VSS.t1471 109.993
R810 VSS.t1463 VSS.n75 109.001
R811 VSS.t1458 VSS.n75 109.001
R812 VSS.n75 VSS.t1456 109.993
R813 VSS.n75 VSS.t1451 109.992
R814 VSS.n74 VSS.t1035 109.992
R815 VSS.t1022 VSS.n74 109.05
R816 VSS.t1012 VSS.n74 109.001
R817 VSS.t1010 VSS.n74 109.993
R818 VSS.t1002 VSS.n74 109.001
R819 VSS.n74 VSS.t1000 109.993
R820 VSS.t992 VSS.n74 109.001
R821 VSS.t987 VSS.n74 108.999
R822 VSS.t982 VSS.n74 109.001
R823 VSS.n74 VSS.t980 109.993
R824 VSS.t972 VSS.n74 109.001
R825 VSS.t967 VSS.n74 108.999
R826 VSS.t957 VSS.n74 109.001
R827 VSS.t952 VSS.n74 108.999
R828 VSS.t947 VSS.n74 109.001
R829 VSS.t942 VSS.n74 108.999
R830 VSS.t932 VSS.n74 109.001
R831 VSS.n74 VSS.t930 109.993
R832 VSS.t922 VSS.n74 108.999
R833 VSS.t917 VSS.n74 109.001
R834 VSS.n74 VSS.t915 109.993
R835 VSS.t907 VSS.n74 108.999
R836 VSS.t897 VSS.n74 109.001
R837 VSS.t892 VSS.n74 108.999
R838 VSS.n74 VSS.t890 109.993
R839 VSS.t882 VSS.n74 109.001
R840 VSS.t877 VSS.n74 108.999
R841 VSS.t872 VSS.n74 109.001
R842 VSS.t862 VSS.n74 109.001
R843 VSS.t847 VSS.n74 108.999
R844 VSS.n74 VSS.t845 109.992
R845 VSS.n74 VSS.t840 109.993
R846 VSS.n74 VSS.t835 109.992
R847 VSS.n74 VSS.t830 109.993
R848 VSS.t822 VSS.n74 109.001
R849 VSS.t812 VSS.n74 109.001
R850 VSS.t807 VSS.n74 109.001
R851 VSS.t802 VSS.n74 108.999
R852 VSS.t797 VSS.n74 108.999
R853 VSS.t792 VSS.n74 109.001
R854 VSS.t787 VSS.n74 108.999
R855 VSS.t782 VSS.n74 109.001
R856 VSS.t777 VSS.n74 109.001
R857 VSS.t767 VSS.n74 109.001
R858 VSS.t762 VSS.n74 108.722
R859 VSS.t852 VSS.n74 109.001
R860 VSS.t72 VSS.n151 96.0268
R861 VSS.t72 VSS.t564 108.996
R862 VSS.t562 VSS.t72 109.992
R863 VSS.t549 VSS.t72 109.001
R864 VSS.t544 VSS.t72 109.001
R865 VSS.t539 VSS.t72 109.001
R866 VSS.t72 VSS.t537 109.992
R867 VSS.t529 VSS.t72 109.001
R868 VSS.t524 VSS.t72 109.001
R869 VSS.t519 VSS.t72 108.993
R870 VSS.n145 VSS.t572 105.683
R871 VSS.n149 VSS.t700 105.329
R872 VSS.t515 VSS.t72 108.999
R873 VSS.t72 VSS.t513 109.001
R874 VSS.t72 VSS.t512 109.993
R875 VSS.t510 VSS.t72 109.993
R876 VSS.t506 VSS.t72 108.999
R877 VSS.t505 VSS.t72 109.992
R878 VSS.t72 VSS.t500 108.722
R879 VSS.t557 VSS.t72 109.992
R880 VSS.t693 VSS.n144 22.241
R881 VSS.t718 VSS.t148 191.667
R882 VSS.t730 VSS.n15 191.417
R883 VSS.n20 VSS.t732 191.417
R884 VSS.n23 VSS.t734 191.417
R885 VSS.n19 VSS.t736 191.417
R886 VSS.n16 VSS.t738 191.417
R887 VSS.n33 VSS.t740 191.417
R888 VSS.n30 VSS.t742 191.417
R889 VSS.n34 VSS.t744 191.417
R890 VSS.n37 VSS.t746 191.417
R891 VSS.n42 VSS.t748 191.417
R892 VSS.n45 VSS.t750 191.417
R893 VSS.n41 VSS.t752 191.417
R894 VSS.n38 VSS.t754 191.417
R895 VSS.n29 VSS.t756 191.417
R896 VSS.n27 VSS.t758 191.417
R897 VSS.n25 VSS.t687 191.417
R898 VSS.n10 VSS.t577 191.417
R899 VSS.n13 VSS.t581 191.417
R900 VSS.n9 VSS.t584 191.417
R901 VSS.n7 VSS.t587 191.417
R902 VSS.t716 VSS.n4 191.417
R903 VSS.t517 VSS.n1 191.417
R904 VSS.t654 VSS.n3 191.417
R905 VSS.n156 VSS.t457 108.635
R906 VSS.t462 VSS.n96 191.417
R907 VSS.t464 VSS.n95 191.417
R908 VSS.n26 VSS.t679 186.502
R909 VSS.n756 VSS.t60 184.815
R910 VSS.n159 VSS.t92 188.911
R911 VSS.t731 VSS.n821 184.286
R912 VSS.t733 VSS.n826 184.286
R913 VSS.t735 VSS.n827 184.286
R914 VSS.t737 VSS.n828 184.286
R915 VSS.t739 VSS.n829 184.286
R916 VSS.t741 VSS.n830 184.286
R917 VSS.t743 VSS.n831 184.286
R918 VSS.t745 VSS.n832 184.286
R919 VSS.t747 VSS.n833 184.286
R920 VSS.t749 VSS.n918 184.286
R921 VSS.t751 VSS.n919 184.286
R922 VSS.t753 VSS.n920 184.286
R923 VSS.t755 VSS.n921 184.286
R924 VSS.t757 VSS.n922 184.286
R925 VSS.t759 VSS.n923 184.286
R926 VSS.t696 VSS.n799 184.286
R927 VSS.t579 VSS.n809 184.286
R928 VSS.t582 VSS.n810 184.286
R929 VSS.t585 VSS.n812 184.286
R930 VSS.n0 VSS.t589 100.822
R931 VSS.t717 VSS.n813 184.286
R932 VSS.t518 VSS.n786 184.286
R933 VSS.t655 VSS.n784 184.286
R934 VSS.t459 VSS.n771 184.286
R935 VSS.t463 VSS.n775 184.286
R936 VSS.n139 VSS.t465 100.871
R937 VSS.t3170 VSS.t57 184.286
R938 VSS.t389 VSS.n735 184.286
R939 VSS.t3204 VSS.n733 183.333
R940 VSS.t3252 VSS.t696 180
R941 VSS.t681 VSS.n796 179.167
R942 VSS.t722 VSS.n818 176.219
R943 VSS.n822 VSS.t727 175.714
R944 VSS.t592 VSS.n821 175.714
R945 VSS.t595 VSS.n826 175.714
R946 VSS.t598 VSS.n827 175.714
R947 VSS.t601 VSS.n828 175.714
R948 VSS.t604 VSS.n829 175.714
R949 VSS.t607 VSS.n830 175.714
R950 VSS.t610 VSS.n831 175.714
R951 VSS.t613 VSS.n832 175.714
R952 VSS.t616 VSS.n833 175.714
R953 VSS.t619 VSS.n918 175.714
R954 VSS.t622 VSS.n919 175.714
R955 VSS.t625 VSS.n920 175.714
R956 VSS.t628 VSS.n921 175.714
R957 VSS.t631 VSS.n922 175.714
R958 VSS.t634 VSS.n923 175.714
R959 VSS.n804 VSS.t697 175.714
R960 VSS.t706 VSS.n809 175.714
R961 VSS.t708 VSS.n810 175.714
R962 VSS.t710 VSS.n812 175.714
R963 VSS.n0 VSS.t712 182.764
R964 VSS.t652 VSS.n786 175.714
R965 VSS.n779 VSS.t460 175.714
R966 VSS.t391 VSS.n775 175.714
R967 VSS.t197 VSS.t3218 171.53
R968 VSS.t727 VSS.t182 171.429
R969 VSS.t85 VSS.t690 171.429
R970 VSS.t447 VSS.n732 170.833
R971 VSS.t68 VSS.n925 166.667
R972 VSS.n930 VSS.t53 166.667
R973 VSS.n900 VSS.t122 166.667
R974 VSS.t174 VSS.n863 166.667
R975 VSS.n871 VSS.t8 166.667
R976 VSS.t104 VSS.n732 166.667
R977 VSS.t117 VSS.n869 165.692
R978 VSS.t449 VSS.n82 165.669
R979 VSS.n758 VSS.t211 159.026
R980 VSS.t70 VSS.n924 157.335
R981 VSS.n100 VSS.t3282 157.335
R982 VSS.n753 VSS.t91 154.728
R983 VSS.t3198 VSS.n742 154.728
R984 VSS.t3220 VSS.n788 154.286
R985 VSS.t251 VSS.n784 154.286
R986 VSS.n933 VSS.t248 154.167
R987 VSS.t243 VSS.n901 154.167
R988 VSS.t213 VSS.n865 154.167
R989 VSS.t78 VSS.n104 153.243
R990 VSS.n868 VSS.t76 153.243
R991 VSS.n942 VSS.t3182 153.243
R992 VSS.n270 VSS.t683 165.669
R993 VSS.t171 VSS.n863 150
R994 VSS.t133 VSS.n776 150
R995 VSS.t3237 VSS.n889 150
R996 VSS.t454 VSS.t192 145.714
R997 VSS.t26 VSS.t459 145.714
R998 VSS.n931 VSS.t3195 141.667
R999 VSS.n872 VSS.t50 141.667
R1000 VSS.n256 VSS.t254 157.335
R1001 VSS.t3242 VSS.t456 141.429
R1002 VSS.t77 VSS.n818 137.536
R1003 VSS.t113 VSS.t176 137.143
R1004 VSS.n875 VSS.t3170 135.703
R1005 VSS.t136 VSS.n800 124.287
R1006 VSS.n781 VSS.t131 124.287
R1007 VSS.t3238 VSS.n888 124.287
R1008 VSS.n764 VSS.t106 120.344
R1009 VSS.n790 VSS.t3217 120.001
R1010 VSS.n795 VSS.t216 120.001
R1011 VSS.t3241 VSS.t454 120.001
R1012 VSS.n924 VSS.t170 119.835
R1013 VSS.n103 VSS.t233 119.835
R1014 VSS.t139 VSS.n100 119.835
R1015 VSS.n895 VSS.t3210 116.668
R1016 VSS.t259 VSS.n872 116.668
R1017 VSS.t451 VSS.t125 116.046
R1018 VSS.t3264 VSS.t691 115.715
R1019 VSS.t229 VSS.t3274 112.501
R1020 VSS.t34 VSS.t461 111.43
R1021 VSS.t3282 VSS.t171 108.334
R1022 VSS.n755 VSS.n750 107.451
R1023 VSS.t90 VSS.t105 107.451
R1024 VSS.t3180 VSS.t3189 107.451
R1025 VSS.n820 VSS.t725 107.144
R1026 VSS.n797 VSS.t683 107.144
R1027 VSS.t3258 VSS.n806 107.144
R1028 VSS.t702 VSS.t3294 107.144
R1029 VSS.t161 VSS.n813 107.144
R1030 VSS.t3266 VSS.n934 107.144
R1031 VSS.n768 VSS.t159 107.144
R1032 VSS.t24 VSS.n771 107.144
R1033 VSS.t57 VSS.n874 107.144
R1034 VSS.n738 VSS.t120 107.144
R1035 VSS.t221 VSS.n734 107.144
R1036 VSS.t3215 VSS.n796 104.168
R1037 VSS.t80 VSS.n873 104.168
R1038 VSS.t186 VSS.t3230 100.001
R1039 VSS.n801 VSS.t137 98.5719
R1040 VSS.n787 VSS.t3193 98.5719
R1041 VSS.t130 VSS.n777 98.5719
R1042 VSS.t3272 VSS.t3250 98.5719
R1043 VSS.t388 VSS.t107 98.5719
R1044 VSS.t3175 VSS.t81 94.5564
R1045 VSS.t127 VSS.t3233 94.5564
R1046 VSS.t690 VSS.t250 94.2862
R1047 VSS.t3199 VSS.t94 94.2862
R1048 VSS.n137 VSS.t75 0.121878
R1049 VSS.t3263 VSS.n134 16.9203
R1050 VSS.n753 VSS.t3232 90.2584
R1051 VSS.t146 VSS.n822 90.0005
R1052 VSS.t250 VSS.n798 90.0005
R1053 VSS.t192 VSS.n770 90.0005
R1054 VSS.n147 VSS.t264 26.1613
R1055 VSS.t75 VSS.n127 0.219019
R1056 VSS.n131 VSS.t75 0.121819
R1057 VSS.t320 VSS.n317 56.7064
R1058 VSS.t324 VSS.n135 26.2524
R1059 VSS.t329 VSS.n136 26.2524
R1060 VSS.n138 VSS.t337 26.1547
R1061 VSS.t75 VSS.n46 0.121827
R1062 VSS.t15 VSS.n378 89.7897
R1063 VSS.t3206 VSS.n101 88.7727
R1064 VSS.t177 VSS.n87 88.7727
R1065 VSS.t254 VSS.t447 87.5005
R1066 VSS.t95 VSS.n150 66.199
R1067 VSS.t11 VSS.t232 87.1423
R1068 VSS.n102 VSS.t3211 86.5025
R1069 VSS.n754 VSS.t46 85.9604
R1070 VSS.t3174 VSS.t160 85.9604
R1071 VSS.t3178 VSS.t225 85.9604
R1072 VSS.t3260 VSS.n853 85.7543
R1073 VSS.n58 VSS.t224 85.7543
R1074 VSS.n825 VSS.t195 85.7148
R1075 VSS.t207 VSS.n772 85.7148
R1076 VSS.t82 VSS.n857 83.6281
R1077 VSS.t3213 VSS.t12 83.3338
R1078 VSS.t154 VSS.n48 83.3336
R1079 VSS.t3257 VSS.n805 81.4291
R1080 VSS.n941 VSS.t26 81.4291
R1081 VSS.n892 VSS.t3277 81.4291
R1082 VSS.n880 VSS.t3249 81.4291
R1083 VSS.t47 VSS.t11 80.7982
R1084 VSS.n25 VSS.t153 79.9891
R1085 VSS.t128 VSS.n85 79.9891
R1086 VSS.n719 VSS.n255 3692.29
R1087 VSS.n110 VSS.t260 10.1739
R1088 VSS.n757 VSS.t108 77.3644
R1089 VSS.n764 VSS.t109 77.3644
R1090 VSS.t699 VSS.t3258 77.1434
R1091 VSS.t107 VSS.n736 77.1434
R1092 VSS.t125 VSS.t11 76.5012
R1093 VSS.t72 VSS.t3264 76.3274
R1094 VSS.n851 VSS.t203 74.234
R1095 VSS.n171 VSS.t3235 20.3759
R1096 VSS.t36 VSS.n750 73.0664
R1097 VSS.t3251 VSS.n799 72.8576
R1098 VSS.n232 VSS.t208 88.5605
R1099 VSS.n780 VSS.t34 72.8576
R1100 VSS.t3239 VSS.t158 72.8576
R1101 VSS.t3243 VSS.n886 72.8576
R1102 VSS.n861 VSS.t3223 72.8451
R1103 VSS.t3173 VSS.n61 72.8441
R1104 VSS.n55 VSS.t88 72.8441
R1105 VSS.n52 VSS.t3229 72.8441
R1106 VSS.n51 VSS.t240 72.8441
R1107 VSS.n860 VSS.t3262 72.6202
R1108 VSS.t168 VSS.n113 76.9095
R1109 VSS.t219 VSS.n847 72.6202
R1110 VSS.t220 VSS.n848 72.6202
R1111 VSS.t11 VSS.t3241 72.0417
R1112 VSS.n823 VSS.t194 71.4177
R1113 VSS.n893 VSS.t20 71.4177
R1114 VSS.t48 VSS.n932 70.8338
R1115 VSS.n894 VSS.t173 70.8338
R1116 VSS.n894 VSS.t217 70.8338
R1117 VSS.t3219 VSS.n733 70.8338
R1118 VSS.t149 VSS.n183 72.8451
R1119 VSS.t100 VSS.n187 72.8451
R1120 VSS.n862 VSS.t6 70.1995
R1121 VSS.t3223 VSS.n108 29.5338
R1122 VSS.t157 VSS.n112 13.9092
R1123 VSS.t230 VSS.t10 68.7684
R1124 VSS.t3294 VSS.n802 68.5719
R1125 VSS.t3185 VSS.n815 68.5719
R1126 VSS.n104 VSS.t230 67.2827
R1127 VSS.n101 VSS.t3283 67.2827
R1128 VSS.t51 VSS.n868 67.2827
R1129 VSS.t255 VSS.n942 67.2827
R1130 VSS.t144 VSS.t717 66.6672
R1131 VSS.t170 VSS.t718 66.6672
R1132 VSS.t4 VSS.t243 66.6672
R1133 VSS.t9 VSS.t213 66.6672
R1134 VSS.t3271 VSS.n860 64.5513
R1135 VSS.t79 VSS.t3206 64.4704
R1136 VSS.t234 VSS.n744 64.4704
R1137 VSS.n113 VSS.t75 10.0545
R1138 VSS.t182 VSS.t72 80.6121
R1139 VSS.n71 VSS.t74 63.9684
R1140 VSS.n57 VSS.t222 63.9684
R1141 VSS.t3259 VSS.n109 16.4142
R1142 VSS.t235 VSS.n163 16.4378
R1143 VSS.n850 VSS.t181 63.7444
R1144 VSS.n859 VSS.t3240 62.3556
R1145 VSS.n855 VSS.t237 62.3556
R1146 VSS.t3273 VSS.n49 62.3556
R1147 VSS.t3288 VSS.n134 33.1136
R1148 VSS.n752 VSS.t256 60.1724
R1149 VSS.t3194 VSS.n743 60.1724
R1150 VSS.t38 VSS.n742 60.1724
R1151 VSS.n267 VSS.t179 75.7034
R1152 VSS.n929 VSS.t3197 60.0005
R1153 VSS.t165 VSS.n789 60.0005
R1154 VSS.t94 VSS.n765 60.0005
R1155 VSS.n773 VSS.t206 60.0005
R1156 VSS.t11 VSS.t3186 51.2106
R1157 VSS.n70 VSS.t271 58.6622
R1158 VSS.n81 VSS.t75 0.22519
R1159 VSS.n69 VSS.t276 58.6622
R1160 VSS.t278 VSS.n78 26.1052
R1161 VSS.n73 VSS.t75 0.22519
R1162 VSS.n67 VSS.t288 58.6622
R1163 VSS.t290 VSS.n62 26.0021
R1164 VSS.n65 VSS.t293 58.6622
R1165 VSS.t295 VSS.n72 58.6622
R1166 VSS.n54 VSS.t352 26.1053
R1167 VSS.t354 VSS.n115 26.106
R1168 VSS.n53 VSS.t357 26.1053
R1169 VSS.n116 VSS.t75 0.12182
R1170 VSS.t75 VSS.n117 0.12186
R1171 VSS.t75 VSS.n118 0.121828
R1172 VSS.n122 VSS.t75 0.12182
R1173 VSS.t75 VSS.n121 0.121828
R1174 VSS.n123 VSS.t75 0.12182
R1175 VSS.n124 VSS.t377 26.1052
R1176 VSS.n24 VSS.t3176 58.5605
R1177 VSS.n71 VSS.t268 58.3211
R1178 VSS.t282 VSS.n61 58.3211
R1179 VSS.n55 VSS.t349 58.3211
R1180 VSS.n52 VSS.t364 58.3211
R1181 VSS.n51 VSS.t380 58.3211
R1182 VSS.n857 VSS.t3269 57.8078
R1183 VSS.n50 VSS.t381 26.1611
R1184 VSS.n70 VSS.t270 57.0465
R1185 VSS.n80 VSS.t75 0.219018
R1186 VSS.n69 VSS.t275 57.0465
R1187 VSS.n79 VSS.t75 0.219018
R1188 VSS.t75 VSS.n78 0.12186
R1189 VSS.t284 VSS.n68 26.1544
R1190 VSS.n67 VSS.t287 57.0465
R1191 VSS.t289 VSS.n66 26.1544
R1192 VSS.n65 VSS.t292 57.0465
R1193 VSS.t294 VSS.n72 57.0465
R1194 VSS.t75 VSS.n114 0.219018
R1195 VSS.t75 VSS.n115 0.12182
R1196 VSS.n116 VSS.t360 26.2515
R1197 VSS.t75 VSS.n119 0.219018
R1198 VSS.t368 VSS.n118 26.2522
R1199 VSS.n122 VSS.t371 26.2515
R1200 VSS.n123 VSS.t376 26.2515
R1201 VSS.n124 VSS.t75 0.12186
R1202 VSS.t45 VSS.n749 55.8744
R1203 VSS.t3179 VSS.t210 55.8744
R1204 VSS.t140 VSS.n743 55.8744
R1205 VSS.t3227 VSS.t141 55.8744
R1206 VSS.t72 VSS.t85 72.0407
R1207 VSS.t3256 VSS.n804 55.7148
R1208 VSS.t28 VSS.n940 55.7148
R1209 VSS.n881 VSS.t3248 55.7148
R1210 VSS.n109 VSS.t116 64.8343
R1211 VSS.n163 VSS.t3279 64.8293
R1212 VSS.n850 VSS.t166 54.8687
R1213 VSS.n740 VSS.t186 54.1672
R1214 VSS.n856 VSS.t3288 54.0618
R1215 VSS.t245 VSS.t11 53.8079
R1216 VSS.t11 VSS.t3212 53.8079
R1217 VSS.n26 VSS.t249 53.1692
R1218 VSS.t3231 VSS.n84 53.1692
R1219 VSS.t266 VSS.t75 26.5065
R1220 VSS.t281 VSS.t75 26.5067
R1221 VSS.t75 VSS.t379 26.5067
R1222 VSS.t348 VSS.n56 26.334
R1223 VSS.t75 VSS.t297 26.5067
R1224 VSS.t363 VSS.t75 26.5067
R1225 VSS.t3286 VSS.n56 64.1701
R1226 VSS.t81 VSS.n158 66.3233
R1227 VSS.n760 VSS.t61 51.5764
R1228 VSS.t3190 VSS.t62 51.5764
R1229 VSS.t0 VSS.n741 51.5764
R1230 VSS.t574 VSS.n144 23.2337
R1231 VSS.t695 VSS.t136 51.4291
R1232 VSS.n737 VSS.t118 51.4291
R1233 VSS.n147 VSS.t261 47.2101
R1234 VSS.t270 VSS.n60 48.6385
R1235 VSS.n80 VSS.t272 26.1544
R1236 VSS.t275 VSS.n81 48.8187
R1237 VSS.n79 VSS.t277 26.1544
R1238 VSS.t280 VSS.n78 26.2591
R1239 VSS.t282 VSS.n68 47.2102
R1240 VSS.t287 VSS.n73 48.8187
R1241 VSS.t288 VSS.n66 47.2102
R1242 VSS.t292 VSS.n62 48.8187
R1243 VSS.n64 VSS.t294 48.6385
R1244 VSS.n63 VSS.t295 47.2101
R1245 VSS.n127 VSS.t300 26.1547
R1246 VSS.t305 VSS.n59 26.2524
R1247 VSS.n131 VSS.t310 26.2517
R1248 VSS.n130 VSS.t315 26.2524
R1249 VSS.n133 VSS.t320 48.8187
R1250 VSS.t321 VSS.n135 26.1049
R1251 VSS.t326 VSS.n136 26.1049
R1252 VSS.n137 VSS.t334 26.2635
R1253 VSS.t335 VSS.n138 47.2102
R1254 VSS.t342 VSS.n46 26.2524
R1255 VSS.t347 VSS.n47 48.8187
R1256 VSS.t350 VSS.n114 26.1544
R1257 VSS.n54 VSS.t353 26.2522
R1258 VSS.t356 VSS.n115 26.2515
R1259 VSS.n53 VSS.t358 26.2522
R1260 VSS.n117 VSS.t362 26.2591
R1261 VSS.t365 VSS.n119 26.1544
R1262 VSS.t367 VSS.n118 26.1053
R1263 VSS.n121 VSS.t374 26.2522
R1264 VSS.n124 VSS.t378 26.2591
R1265 VSS.n50 VSS.t380 47.2101
R1266 VSS.n125 VSS.t84 37.8459
R1267 VSS.t3236 VSS.n747 47.2784
R1268 VSS.n759 VSS.t183 47.2784
R1269 VSS.t228 VSS.t3285 47.2784
R1270 VSS.n927 VSS.t3252 47.1434
R1271 VSS.t33 VSS.n778 47.1434
R1272 VSS.t3244 VSS.n885 47.1434
R1273 VSS.t268 VSS.n60 47.0238
R1274 VSS.n81 VSS.t273 26.0021
R1275 VSS.n73 VSS.t285 26.0021
R1276 VSS.t293 VSS.n64 47.0238
R1277 VSS.t317 VSS.n133 26.0017
R1278 VSS.n116 VSS.t359 26.106
R1279 VSS.n122 VSS.t369 26.106
R1280 VSS.n123 VSS.t375 26.106
R1281 VSS.t232 VSS.t41 45.8338
R1282 VSS.t233 VSS.t3281 45.8338
R1283 VSS.n869 VSS.t3222 45.7789
R1284 VSS.t3274 VSS.n103 44.8359
R1285 VSS.t261 VSS.n255 56.194
R1286 VSS.n183 VSS.t298 58.3202
R1287 VSS.n59 VSS.t302 26.1049
R1288 VSS.n131 VSS.t307 26.1056
R1289 VSS.n130 VSS.t312 26.1049
R1290 VSS.t75 VSS.n133 0.225187
R1291 VSS.t75 VSS.n135 0.121827
R1292 VSS.t75 VSS.n136 0.121827
R1293 VSS.n137 VSS.t331 26.1048
R1294 VSS.n187 VSS.t335 58.3202
R1295 VSS.n46 VSS.t339 26.1049
R1296 VSS.n47 VSS.t344 26.0017
R1297 VSS.t3191 VSS.n744 42.9804
R1298 VSS.n166 VSS.t66 50.7208
R1299 VSS.t99 VSS.n788 42.8576
R1300 VSS.n876 VSS.t3261 42.8576
R1301 VSS.n378 VSS.t347 56.7064
R1302 VSS.t11 VSS.t228 42.1172
R1303 VSS.t11 VSS.n158 1.60658
R1304 VSS.t3267 VSS.n807 41.4177
R1305 VSS.t3240 VSS.n858 40.8632
R1306 VSS.t237 VSS.n854 40.8632
R1307 VSS.n846 VSS.t3273 40.8632
R1308 VSS.t212 VSS.n747 38.6824
R1309 VSS.n767 VSS.n763 38.6824
R1310 VSS.t14 VSS.t3245 38.5719
R1311 VSS.t148 VSS.t72 53.8079
R1312 VSS.n895 VSS.t215 37.5005
R1313 VSS.n90 VSS.t3174 37.1968
R1314 VSS.t3253 VSS.n926 37.1319
R1315 VSS.t116 VSS.n859 36.5343
R1316 VSS.t3279 VSS.n855 36.5343
R1317 VSS.t166 VSS.n49 36.5343
R1318 VSS.n762 VSS.t3179 34.3845
R1319 VSS.n791 VSS.t3192 34.2862
R1320 VSS.n774 VSS.t205 34.2862
R1321 VSS.t3290 VSS.n883 34.2862
R1322 VSS.t3212 VSS.t258 33.3338
R1323 VSS.n877 VSS.t113 32.8462
R1324 VSS.t3269 VSS.n856 31.469
R1325 VSS.t3234 VSS.n749 30.0865
R1326 VSS.t3189 VSS.n745 30.0865
R1327 VSS.n763 VSS.t3227 30.0865
R1328 VSS.t3255 VSS.n803 30.0005
R1329 VSS.n792 VSS.t43 30.0005
R1330 VSS.n153 VSS.t3172 26.8308
R1331 VSS.t676 VSS.n151 12.9737
R1332 VSS.n769 VSS.t151 30.0005
R1333 VSS.n939 VSS.t29 30.0005
R1334 VSS.n882 VSS.t3247 30.0005
R1335 VSS.n739 VSS.t185 30.0005
R1336 VSS.t105 VSS.t11 29.2233
R1337 VSS.n896 VSS.t3265 29.1672
R1338 VSS.t225 VSS.n86 28.6008
R1339 VSS.t75 VSS.n109 4.37826
R1340 VSS.t181 VSS.n48 27.6595
R1341 VSS.t74 VSS.n177 38.7811
R1342 VSS.n113 VSS.t189 16.225
R1343 VSS.t222 VSS.n847 27.4346
R1344 VSS.t3286 VSS.n848 27.4346
R1345 VSS.n867 VSS.t253 25.7885
R1346 VSS.t3171 VSS.n814 25.7148
R1347 VSS.t158 VSS.n887 25.7148
R1348 VSS.t3278 VSS.n735 25.7148
R1349 VSS.t204 VSS.t11 24.8989
R1350 VSS.t22 VSS.n5 24.2748
R1351 VSS.t17 VSS.n877 24.2748
R1352 VSS.n107 VSS.t3292 14.2643
R1353 VSS.n171 VSS.t75 2.33071
R1354 VSS.n178 VSS.t3167 13.9422
R1355 VSS.n167 VSS.t152 13.9422
R1356 VSS.t226 VSS.n160 13.9422
R1357 VSS.t2 VSS.n191 13.9422
R1358 VSS.t58 VSS.n165 13.9374
R1359 VSS.t75 VSS.n112 3.36914
R1360 VSS.t3166 VSS.n108 13.9082
R1361 VSS.t96 VSS.n746 21.4905
R1362 VSS.n779 VSS.t32 21.4291
R1363 VSS.t63 VSS.t3238 21.4291
R1364 VSS.t3245 VSS.n884 21.4291
R1365 VSS.t3168 VSS.t17 21.4291
R1366 VSS.t6 VSS.n861 21.2035
R1367 VSS.t3201 VSS.n90 20.0048
R1368 VSS.n926 VSS.t3254 19.9891
R1369 VSS.n177 VSS.t3187 12.8073
R1370 VSS.n853 VSS.t168 18.7838
R1371 VSS.n58 VSS.t219 18.7838
R1372 VSS.n57 VSS.t220 18.7838
R1373 VSS.n171 VSS.t3275 14.8812
R1374 VSS.n178 VSS.t3173 29.5272
R1375 VSS.n167 VSS.t149 29.5272
R1376 VSS.t3184 VSS.n862 18.5589
R1377 VSS.n112 VSS.t100 29.5336
R1378 VSS.t88 VSS.n165 29.5281
R1379 VSS.t3229 VSS.n160 29.5272
R1380 VSS.t240 VSS.n191 29.5272
R1381 VSS.n858 VSS.t82 17.4635
R1382 VSS.n854 VSS.t3260 17.4635
R1383 VSS.t224 VSS.n846 17.4635
R1384 VSS.t231 VSS.t3171 17.1434
R1385 VSS.t126 VSS.t246 17.1434
R1386 VSS.t3249 VSS.t3293 17.1434
R1387 VSS.t3203 VSS.t221 17.1434
R1388 VSS.n255 VSS.t75 2.5939
R1389 VSS.n126 VSS.n319 5.64438
R1390 VSS.n320 VSS.n126 5.64438
R1391 VSS.t75 VSS.n177 2.99891
R1392 VSS.t75 VSS.n178 3.37712
R1393 VSS.t75 VSS.n167 3.37712
R1394 VSS.t75 VSS.n183 0.405951
R1395 VSS.t75 VSS.n230 5.6463
R1396 VSS.n317 VSS.t75 0.405951
R1397 VSS.n862 VSS.t75 17.0005
R1398 VSS.n108 VSS.t75 3.3689
R1399 VSS.n107 VSS.t75 3.49528
R1400 VSS.n860 VSS.t75 17.0005
R1401 VSS.n856 VSS.t75 17.0005
R1402 VSS.n134 VSS.t75 4.63044
R1403 VSS.n231 VSS.t75 5.6463
R1404 VSS.t75 VSS.n851 17.0005
R1405 VSS.t75 VSS.n850 17.0005
R1406 VSS.t75 VSS.n847 17.0005
R1407 VSS.t75 VSS.n848 17.0005
R1408 VSS.t75 VSS.n165 3.37595
R1409 VSS.t75 VSS.n160 3.37712
R1410 VSS.t75 VSS.n191 3.37712
R1411 VSS.n180 VSS.t198 4.17712
R1412 VSS.n302 VSS.n77 5.64438
R1413 VSS.n77 VSS.n303 5.64438
R1414 VSS.n76 VSS.n300 5.64438
R1415 VSS.n301 VSS.n76 5.64438
R1416 VSS.n75 VSS.n298 5.64438
R1417 VSS.n299 VSS.n75 5.64438
R1418 VSS.t1154 VSS.t1209 17.0005
R1419 VSS.t1253 VSS.n280 0.179761
R1420 VSS.t1154 VSS.n598 17.0005
R1421 VSS.t1298 VSS.n586 0.120486
R1422 VSS.n74 VSS.n272 5.64438
R1423 VSS.n273 VSS.n74 5.64438
R1424 VSS.t72 VSS.n669 5.6463
R1425 VSS.t72 VSS.n270 0.666899
R1426 VSS.n930 VSS.t72 17.0005
R1427 VSS.t72 VSS.n931 17.0005
R1428 VSS.t72 VSS.n796 17.0005
R1429 VSS.n932 VSS.t72 17.0005
R1430 VSS.t72 VSS.n933 17.0005
R1431 VSS.n934 VSS.t72 17.0005
R1432 VSS.t72 VSS.n152 7.66905
R1433 VSS.t72 VSS.n784 17.0005
R1434 VSS.t72 VSS.n795 17.0005
R1435 VSS.t72 VSS.n785 17.0005
R1436 VSS.n232 VSS.t72 0.649813
R1437 VSS.t72 VSS.n786 17.0005
R1438 VSS.t72 VSS.n794 17.0005
R1439 VSS.n793 VSS.t72 17.0005
R1440 VSS.t72 VSS.n787 17.0005
R1441 VSS.t72 VSS.n792 17.0005
R1442 VSS.t72 VSS.n788 17.0005
R1443 VSS.t72 VSS.n791 17.0005
R1444 VSS.t72 VSS.n789 17.0005
R1445 VSS.t72 VSS.n790 17.0005
R1446 VSS.t72 VSS.n145 3.31704
R1447 VSS.t72 VSS.n146 13.0749
R1448 VSS.t72 VSS.n798 17.0005
R1449 VSS.n928 VSS.t72 17.0005
R1450 VSS.t72 VSS.n929 17.0005
R1451 VSS.t72 VSS.n797 17.0005
R1452 VSS.n806 VSS.t72 17.0005
R1453 VSS.n805 VSS.t72 17.0005
R1454 VSS.n804 VSS.t72 17.0005
R1455 VSS.n803 VSS.t72 17.0005
R1456 VSS.t72 VSS.n927 17.0005
R1457 VSS.t72 VSS.n799 17.0005
R1458 VSS.t72 VSS.n801 17.0005
R1459 VSS.t72 VSS.n800 17.0005
R1460 VSS.t72 VSS.n143 10.6179
R1461 VSS.t72 VSS.n268 0.649813
R1462 VSS.t72 VSS.n811 17.0005
R1463 VSS.t72 VSS.n812 17.0005
R1464 VSS.t72 VSS.n234 0.649813
R1465 VSS.t72 VSS.n810 17.0005
R1466 VSS.t72 VSS.n269 0.649813
R1467 VSS.t72 VSS.n809 17.0005
R1468 VSS.t72 VSS.n173 0.649813
R1469 VSS.t72 VSS.n802 17.0005
R1470 VSS.t72 VSS.n808 17.0005
R1471 VSS.n148 VSS.t72 7.66905
R1472 VSS.t72 VSS.n132 14.3867
R1473 VSS.n925 VSS.t72 17.0005
R1474 VSS.t72 VSS.n140 3.41984
R1475 VSS.t72 VSS.n813 17.0005
R1476 VSS.t72 VSS.n817 17.0005
R1477 VSS.t72 VSS.n814 17.0005
R1478 VSS.t72 VSS.n816 17.0005
R1479 VSS.t72 VSS.n815 17.0005
R1480 VSS.t72 VSS.n818 17.0005
R1481 VSS.t72 VSS.n923 17.0005
R1482 VSS.n260 VSS.t72 0.649813
R1483 VSS.t72 VSS.n922 17.0005
R1484 VSS.n174 VSS.t72 0.649813
R1485 VSS.t72 VSS.n921 17.0005
R1486 VSS.n261 VSS.t72 0.649813
R1487 VSS.t72 VSS.n920 17.0005
R1488 VSS.n237 VSS.t72 0.649813
R1489 VSS.t72 VSS.n919 17.0005
R1490 VSS.t72 VSS.n262 0.649813
R1491 VSS.t72 VSS.n918 17.0005
R1492 VSS.n184 VSS.t72 0.649813
R1493 VSS.t72 VSS.n833 17.0005
R1494 VSS.n263 VSS.t72 0.649813
R1495 VSS.t72 VSS.n832 17.0005
R1496 VSS.n236 VSS.t72 0.649813
R1497 VSS.t72 VSS.n831 17.0005
R1498 VSS.n264 VSS.t72 0.649813
R1499 VSS.t72 VSS.n830 17.0005
R1500 VSS.n168 VSS.t72 0.649813
R1501 VSS.t72 VSS.n829 17.0005
R1502 VSS.n265 VSS.t72 0.649813
R1503 VSS.t72 VSS.n828 17.0005
R1504 VSS.t72 VSS.n235 0.649813
R1505 VSS.t72 VSS.n827 17.0005
R1506 VSS.n266 VSS.t72 0.649813
R1507 VSS.t72 VSS.n826 17.0005
R1508 VSS.n185 VSS.t72 0.649813
R1509 VSS.t72 VSS.n821 17.0005
R1510 VSS.t72 VSS.n267 0.649813
R1511 VSS.n825 VSS.t72 17.0005
R1512 VSS.n824 VSS.t72 17.0005
R1513 VSS.n822 VSS.t72 17.0005
R1514 VSS.t72 VSS.n141 1.11651
R1515 VSS.t72 VSS.n820 17.0005
R1516 VSS.t72 VSS.n819 17.0005
R1517 VSS.t11 VSS.n775 17.0005
R1518 VSS.t11 VSS.n782 17.0005
R1519 VSS.t11 VSS.n776 17.0005
R1520 VSS.t11 VSS.n781 17.0005
R1521 VSS.t11 VSS.n777 17.0005
R1522 VSS.t11 VSS.n780 17.0005
R1523 VSS.t11 VSS.n778 17.0005
R1524 VSS.t11 VSS.n779 17.0005
R1525 VSS.n938 VSS.t11 17.0005
R1526 VSS.t11 VSS.n939 17.0005
R1527 VSS.n940 VSS.t11 17.0005
R1528 VSS.t11 VSS.n941 17.0005
R1529 VSS.t11 VSS.n771 17.0005
R1530 VSS.n870 VSS.t11 17.0005
R1531 VSS.n871 VSS.t11 17.0005
R1532 VSS.n872 VSS.t11 17.0005
R1533 VSS.n873 VSS.t11 17.0005
R1534 VSS.n150 VSS.t11 3.41984
R1535 VSS.n874 VSS.t11 17.0005
R1536 VSS.n876 VSS.t11 17.0005
R1537 VSS.n879 VSS.t11 17.0005
R1538 VSS.n880 VSS.t11 17.0005
R1539 VSS.n881 VSS.t11 17.0005
R1540 VSS.n882 VSS.t11 17.0005
R1541 VSS.n883 VSS.t11 17.0005
R1542 VSS.n884 VSS.t11 17.0005
R1543 VSS.n885 VSS.t11 17.0005
R1544 VSS.n886 VSS.t11 17.0005
R1545 VSS.n887 VSS.t11 17.0005
R1546 VSS.n888 VSS.t11 17.0005
R1547 VSS.n889 VSS.t11 17.0005
R1548 VSS.n890 VSS.t11 17.0005
R1549 VSS.n891 VSS.t11 17.0005
R1550 VSS.n892 VSS.t11 17.0005
R1551 VSS.n259 VSS.t11 0.649813
R1552 VSS.t11 VSS.n866 17.0005
R1553 VSS.t11 VSS.n772 17.0005
R1554 VSS.t11 VSS.n773 17.0005
R1555 VSS.t11 VSS.n774 17.0005
R1556 VSS.n867 VSS.t11 17.0005
R1557 VSS.t11 VSS.n896 17.0005
R1558 VSS.t11 VSS.n863 17.0005
R1559 VSS.t11 VSS.n895 17.0005
R1560 VSS.t11 VSS.n864 17.0005
R1561 VSS.t11 VSS.n894 17.0005
R1562 VSS.t11 VSS.n865 17.0005
R1563 VSS.t11 VSS.n699 5.64879
R1564 VSS.t11 VSS.n897 17.0005
R1565 VSS.t11 VSS.n898 17.0005
R1566 VSS.t11 VSS.n900 17.0005
R1567 VSS.n901 VSS.t11 17.0005
R1568 VSS.t11 VSS.n125 2.49582
R1569 VSS.n155 VSS.t11 2.91846
R1570 VSS.n770 VSS.t11 17.0005
R1571 VSS.t11 VSS.n769 17.0005
R1572 VSS.t11 VSS.n765 17.0005
R1573 VSS.t11 VSS.n768 17.0005
R1574 VSS.n159 VSS.t11 12.2567
R1575 VSS.t11 VSS.n741 17.0005
R1576 VSS.t11 VSS.n764 17.0005
R1577 VSS.t11 VSS.n742 17.0005
R1578 VSS.t11 VSS.n763 17.0005
R1579 VSS.t11 VSS.n743 17.0005
R1580 VSS.t11 VSS.n762 17.0005
R1581 VSS.t11 VSS.n744 17.0005
R1582 VSS.t11 VSS.n761 17.0005
R1583 VSS.t11 VSS.n745 17.0005
R1584 VSS.t11 VSS.n760 17.0005
R1585 VSS.t11 VSS.n746 17.0005
R1586 VSS.t11 VSS.n759 17.0005
R1587 VSS.t11 VSS.n747 17.0005
R1588 VSS.t11 VSS.n758 17.0005
R1589 VSS.t11 VSS.n748 17.0005
R1590 VSS.t11 VSS.n757 17.0005
R1591 VSS.t11 VSS.n756 17.0005
R1592 VSS.t11 VSS.n754 17.0005
R1593 VSS.t11 VSS.n749 17.0005
R1594 VSS.t11 VSS.n753 17.0005
R1595 VSS.t11 VSS.n752 17.0005
R1596 VSS.t11 VSS.n750 17.0005
R1597 VSS.t11 VSS.n751 17.0005
R1598 VSS.t11 VSS.n943 17.0005
R1599 VSS.t11 VSS.n732 17.0005
R1600 VSS.t11 VSS.n256 0.666899
R1601 VSS.t11 VSS.n733 17.0005
R1602 VSS.t11 VSS.n740 17.0005
R1603 VSS.t11 VSS.n734 17.0005
R1604 VSS.t11 VSS.n739 17.0005
R1605 VSS.t11 VSS.n738 17.0005
R1606 VSS.t11 VSS.n735 17.0005
R1607 VSS.t11 VSS.n737 17.0005
R1608 VSS.t11 VSS.n736 17.0005
R1609 VSS.t246 VSS.n5 15.7034
R1610 VSS.n807 VSS.t3188 15.7034
R1611 VSS.t203 VSS.n845 15.0429
R1612 VSS.n110 VSS.t75 2.23361
R1613 VSS.t269 VSS.n944 14.1658
R1614 VSS.t366 VSS.n834 14.1658
R1615 VSS.n902 VSS.t341 14.1658
R1616 VSS.n949 VSS.n948 14.1658
R1617 VSS.n950 VSS.t3127 14.1658
R1618 VSS.n952 VSS.n951 14.1658
R1619 VSS.n937 VSS.t304 14.1658
R1620 VSS.n944 VSS.t450 13.5005
R1621 VSS.t508 VSS.n731 13.5005
R1622 VSS.t781 VSS.n914 13.5005
R1623 VSS.n913 VSS.t1166 13.5005
R1624 VSS.t1462 VSS.n837 13.5005
R1625 VSS.t1854 VSS.n840 13.5005
R1626 VSS.t2246 VSS.n730 13.5005
R1627 VSS.t2630 VSS.n724 13.5005
R1628 VSS.n953 VSS.t2904 13.5005
R1629 VSS.n902 VSS.t3207 13.5005
R1630 VSS.n903 VSS.t586 13.5005
R1631 VSS.n904 VSS.n836 13.5005
R1632 VSS.n907 VSS.n906 13.5005
R1633 VSS.n909 VSS.n908 13.5005
R1634 VSS.n839 VSS.n728 13.5005
R1635 VSS.n947 VSS.n729 13.5005
R1636 VSS.n948 VSS.n726 13.5005
R1637 VSS.t422 VSS.n834 13.5005
R1638 VSS.t614 VSS.n917 13.5005
R1639 VSS.n916 VSS.t1004 13.5005
R1640 VSS.n905 VSS.n835 13.5005
R1641 VSS.t1685 VSS.n843 13.5005
R1642 VSS.n842 VSS.t2077 13.5005
R1643 VSS.t2469 VSS.n727 13.5005
R1644 VSS.t2749 VSS.n950 13.5005
R1645 VSS.n951 VSS.t2667 13.5005
R1646 VSS.n946 VSS.n725 13.5005
R1647 VSS.n841 VSS.n838 13.5005
R1648 VSS.n911 VSS.n910 13.5005
R1649 VSS.t1361 VSS.n912 13.5005
R1650 VSS.n915 VSS.n783 13.5005
R1651 VSS.n936 VSS.n935 13.5005
R1652 VSS.t132 VSS.n937 13.5005
R1653 VSS.n845 VSS.t15 13.4291
R1654 VSS.n107 VSS.t3271 23.7593
R1655 VSS.t200 VSS.t64 12.8945
R1656 VSS.t3233 VSS.n748 12.8945
R1657 VSS.n758 VSS.t3200 12.8945
R1658 VSS.t54 VSS.n928 12.8576
R1659 VSS.n769 VSS.t115 12.8576
R1660 VSS.t3247 VSS.t3270 12.8576
R1661 VSS.t720 VSS.t68 12.5005
R1662 VSS.n761 VSS.t3190 8.59649
R1663 VSS.t97 VSS.n793 8.57193
R1664 VSS.n879 VSS.t3272 8.57193
R1665 VSS.t198 VSS.n321 3.32131
R1666 VSS.n597 VSS.t1154 4.19248
R1667 VSS.t3164 VSS.n126 8.50199
R1668 VSS.n77 VSS.t2506 8.50198
R1669 VSS.t2114 VSS.n76 8.50198
R1670 VSS.t1722 VSS.n75 8.50198
R1671 VSS.t1041 VSS.n74 8.50198
R1672 VSS.n377 VSS.t3161 0.130189
R1673 VSS.t3159 VSS.n126 8.501
R1674 VSS.n376 VSS.t3156 0.130189
R1675 VSS.t3154 VSS.n126 8.501
R1676 VSS.n375 VSS.t3151 0.130189
R1677 VSS.t3149 VSS.n126 8.501
R1678 VSS.n374 VSS.t3146 0.130189
R1679 VSS.t3144 VSS.n126 8.501
R1680 VSS.n373 VSS.t3141 0.130189
R1681 VSS.t3139 VSS.n126 8.501
R1682 VSS.n372 VSS.t3136 0.130189
R1683 VSS.t3134 VSS.n126 8.501
R1684 VSS.n371 VSS.t3131 0.130189
R1685 VSS.t3129 VSS.n319 0.0362711
R1686 VSS.n370 VSS.t3126 0.0793054
R1687 VSS.n126 VSS.t3124 8.501
R1688 VSS.t3121 VSS.n369 0.130189
R1689 VSS.t3119 VSS.n126 8.501
R1690 VSS.t3116 VSS.n368 0.130189
R1691 VSS.t3114 VSS.n126 8.501
R1692 VSS.t3111 VSS.n367 0.130189
R1693 VSS.t3109 VSS.n126 8.501
R1694 VSS.t3106 VSS.n366 0.130189
R1695 VSS.t3104 VSS.n126 8.501
R1696 VSS.t3101 VSS.n365 0.130189
R1697 VSS.t3099 VSS.n126 8.501
R1698 VSS.t3096 VSS.n364 0.130189
R1699 VSS.t3094 VSS.n126 8.501
R1700 VSS.t3091 VSS.n363 0.130189
R1701 VSS.t3089 VSS.n126 8.501
R1702 VSS.t3086 VSS.n362 0.130189
R1703 VSS.t3084 VSS.n126 8.501
R1704 VSS.t3081 VSS.n361 0.130189
R1705 VSS.t3079 VSS.n126 8.501
R1706 VSS.t3076 VSS.n360 0.130189
R1707 VSS.t3074 VSS.n126 8.501
R1708 VSS.t3071 VSS.n359 0.130189
R1709 VSS.t3069 VSS.n126 8.501
R1710 VSS.t3066 VSS.n358 0.130189
R1711 VSS.t3064 VSS.n126 8.501
R1712 VSS.t3061 VSS.n357 0.130189
R1713 VSS.t3059 VSS.n126 8.501
R1714 VSS.t3056 VSS.n356 0.130189
R1715 VSS.t3054 VSS.n320 0.0362711
R1716 VSS.t3051 VSS.n355 0.0793054
R1717 VSS.t3049 VSS.n126 8.501
R1718 VSS.t3046 VSS.n354 0.130189
R1719 VSS.t3044 VSS.n126 8.501
R1720 VSS.t3041 VSS.n353 0.130189
R1721 VSS.t3039 VSS.n126 8.501
R1722 VSS.t3036 VSS.n352 0.130189
R1723 VSS.t3034 VSS.n126 8.501
R1724 VSS.t3031 VSS.n351 0.130189
R1725 VSS.t3029 VSS.n126 8.501
R1726 VSS.t3026 VSS.n350 0.130189
R1727 VSS.t3024 VSS.n126 8.501
R1728 VSS.t3021 VSS.n349 0.130189
R1729 VSS.t3019 VSS.n126 8.501
R1730 VSS.t3016 VSS.n348 0.130189
R1731 VSS.t3014 VSS.n126 8.501
R1732 VSS.t3011 VSS.n347 0.130189
R1733 VSS.t3009 VSS.n126 8.501
R1734 VSS.t3006 VSS.n346 0.130189
R1735 VSS.t3004 VSS.n126 8.501
R1736 VSS.t3001 VSS.n345 0.130189
R1737 VSS.t2999 VSS.n126 8.501
R1738 VSS.t2996 VSS.n344 0.130189
R1739 VSS.t2994 VSS.n126 8.501
R1740 VSS.t2991 VSS.n343 0.130189
R1741 VSS.t2989 VSS.n126 8.501
R1742 VSS.t2986 VSS.n342 0.130189
R1743 VSS.t2984 VSS.n126 8.501
R1744 VSS.t2981 VSS.n341 0.130189
R1745 VSS.n126 VSS.t2979 8.501
R1746 VSS.t2976 VSS.n340 0.130189
R1747 VSS.t2974 VSS.n126 8.501
R1748 VSS.t2971 VSS.n339 0.130189
R1749 VSS.t2969 VSS.n126 8.501
R1750 VSS.t2966 VSS.n338 0.130189
R1751 VSS.t2964 VSS.n126 8.501
R1752 VSS.t2961 VSS.n337 0.130189
R1753 VSS.t2959 VSS.n126 8.501
R1754 VSS.t2956 VSS.n336 0.130189
R1755 VSS.t2954 VSS.n126 8.501
R1756 VSS.t2951 VSS.n335 0.130189
R1757 VSS.t2949 VSS.n126 8.501
R1758 VSS.t2946 VSS.n334 0.130189
R1759 VSS.t2944 VSS.n126 8.501
R1760 VSS.t2941 VSS.n333 0.130189
R1761 VSS.t2939 VSS.n126 8.501
R1762 VSS.t2936 VSS.n332 0.130189
R1763 VSS.t2934 VSS.n126 8.501
R1764 VSS.t2931 VSS.n331 0.130189
R1765 VSS.t2929 VSS.n126 8.501
R1766 VSS.t2926 VSS.n330 0.130189
R1767 VSS.t2924 VSS.n126 8.501
R1768 VSS.t2921 VSS.n329 0.130189
R1769 VSS.t2919 VSS.n126 8.501
R1770 VSS.t2916 VSS.n328 0.130189
R1771 VSS.t2914 VSS.n126 8.501
R1772 VSS.n327 VSS.t2911 0.130189
R1773 VSS.t2909 VSS.n126 8.501
R1774 VSS.n326 VSS.t2906 0.130189
R1775 VSS.t2901 VSS.n325 0.215686
R1776 VSS.t2899 VSS.n126 8.501
R1777 VSS.n324 VSS.t2896 0.130189
R1778 VSS.t2894 VSS.n126 8.501
R1779 VSS.n323 VSS.t2891 0.130189
R1780 VSS.t2889 VSS.n126 8.501
R1781 VSS.n126 VSS.n322 3.33079
R1782 VSS.t75 VSS.t262 8.501
R1783 VSS.n723 VSS.t75 3.32876
R1784 VSS.t267 VSS.n318 0.801469
R1785 VSS.t150 VSS.n379 0.964792
R1786 VSS.t75 VSS.n380 3.32876
R1787 VSS.t303 VSS.n230 0.0333775
R1788 VSS.n381 VSS.t75 4.20253
R1789 VSS.t308 VSS.t75 8.501
R1790 VSS.n382 VSS.t75 3.32876
R1791 VSS.t313 VSS.t75 8.501
R1792 VSS.n383 VSS.t75 3.32876
R1793 VSS.t318 VSS.t75 8.501
R1794 VSS.n384 VSS.t75 3.32876
R1795 VSS.n385 VSS.t75 0.35896
R1796 VSS.n386 VSS.t75 3.32876
R1797 VSS.t327 VSS.t75 8.501
R1798 VSS.n387 VSS.t75 3.32876
R1799 VSS.t332 VSS.t75 8.501
R1800 VSS.n388 VSS.t75 3.32876
R1801 VSS.t101 VSS.n389 0.835741
R1802 VSS.t75 VSS.n390 3.32876
R1803 VSS.n231 VSS.t340 0.0333775
R1804 VSS.n391 VSS.t75 4.20253
R1805 VSS.t345 VSS.t75 8.501
R1806 VSS.n392 VSS.t75 3.32876
R1807 VSS.n452 VSS.t2503 0.130189
R1808 VSS.t2501 VSS.n77 8.501
R1809 VSS.n451 VSS.t2498 0.130189
R1810 VSS.t2496 VSS.n77 8.501
R1811 VSS.n450 VSS.t2493 0.130189
R1812 VSS.t2491 VSS.n77 8.501
R1813 VSS.n449 VSS.t2488 0.130189
R1814 VSS.t2486 VSS.n77 8.501
R1815 VSS.n448 VSS.t2483 0.130189
R1816 VSS.t2481 VSS.n77 8.501
R1817 VSS.n447 VSS.t2478 0.130189
R1818 VSS.t2476 VSS.n77 8.501
R1819 VSS.n446 VSS.t2473 0.130189
R1820 VSS.t2471 VSS.n302 0.0362711
R1821 VSS.n445 VSS.t2468 0.0793054
R1822 VSS.t2466 VSS.n77 8.501
R1823 VSS.n444 VSS.t2463 0.130189
R1824 VSS.t2461 VSS.n77 8.501
R1825 VSS.n443 VSS.t2458 0.130189
R1826 VSS.t2456 VSS.n77 8.501
R1827 VSS.n442 VSS.t2453 0.130189
R1828 VSS.t2451 VSS.n77 8.501
R1829 VSS.n441 VSS.t2448 0.130189
R1830 VSS.t2446 VSS.n77 8.501
R1831 VSS.n440 VSS.t2443 0.130189
R1832 VSS.t2441 VSS.n77 8.501
R1833 VSS.n439 VSS.t2438 0.130189
R1834 VSS.t2436 VSS.n77 8.501
R1835 VSS.n438 VSS.t2433 0.130189
R1836 VSS.t2431 VSS.n77 8.501
R1837 VSS.n437 VSS.t2428 0.130189
R1838 VSS.t2426 VSS.n77 8.501
R1839 VSS.n436 VSS.t2423 0.130189
R1840 VSS.t2421 VSS.n77 8.501
R1841 VSS.n435 VSS.t2418 0.130189
R1842 VSS.t2416 VSS.n77 8.501
R1843 VSS.n434 VSS.t2413 0.130189
R1844 VSS.t2411 VSS.n77 8.501
R1845 VSS.n433 VSS.t2408 0.130189
R1846 VSS.t2406 VSS.n77 8.501
R1847 VSS.n432 VSS.t2403 0.130189
R1848 VSS.t2401 VSS.n77 8.501
R1849 VSS.n431 VSS.t2398 0.130189
R1850 VSS.t2396 VSS.n303 0.0362711
R1851 VSS.n430 VSS.t2393 0.0793054
R1852 VSS.n77 VSS.t2391 8.501
R1853 VSS.t2388 VSS.n429 0.130189
R1854 VSS.t2386 VSS.n77 8.501
R1855 VSS.t2383 VSS.n428 0.130189
R1856 VSS.t2381 VSS.n77 8.501
R1857 VSS.t2378 VSS.n427 0.130189
R1858 VSS.t2376 VSS.n77 8.501
R1859 VSS.t2373 VSS.n426 0.130189
R1860 VSS.t2371 VSS.n77 8.501
R1861 VSS.t2368 VSS.n425 0.130189
R1862 VSS.t2366 VSS.n77 8.501
R1863 VSS.t2363 VSS.n424 0.130189
R1864 VSS.t2361 VSS.n77 8.501
R1865 VSS.t2358 VSS.n423 0.130189
R1866 VSS.t2356 VSS.n77 8.501
R1867 VSS.t2353 VSS.n422 0.130189
R1868 VSS.t2351 VSS.n77 8.501
R1869 VSS.t2348 VSS.n421 0.130189
R1870 VSS.t2346 VSS.n77 8.501
R1871 VSS.t2343 VSS.n420 0.130189
R1872 VSS.t2341 VSS.n77 8.501
R1873 VSS.t2338 VSS.n419 0.130189
R1874 VSS.t2336 VSS.n77 8.501
R1875 VSS.t2333 VSS.n418 0.130189
R1876 VSS.t2331 VSS.n77 8.501
R1877 VSS.t2328 VSS.n417 0.130189
R1878 VSS.t2326 VSS.n77 8.501
R1879 VSS.t2323 VSS.n416 0.130189
R1880 VSS.t2318 VSS.n415 0.130189
R1881 VSS.t2316 VSS.n77 8.501
R1882 VSS.t2313 VSS.n414 0.130189
R1883 VSS.t2311 VSS.n77 8.501
R1884 VSS.t2308 VSS.n413 0.130189
R1885 VSS.t2306 VSS.n77 8.501
R1886 VSS.t2303 VSS.n412 0.130189
R1887 VSS.t2301 VSS.n77 8.501
R1888 VSS.t2298 VSS.n411 0.130189
R1889 VSS.t2296 VSS.n77 8.501
R1890 VSS.t2293 VSS.n410 0.130189
R1891 VSS.t2291 VSS.n77 8.501
R1892 VSS.t2288 VSS.n409 0.130189
R1893 VSS.t2286 VSS.n77 8.501
R1894 VSS.t2283 VSS.n408 0.130189
R1895 VSS.t2281 VSS.n77 8.501
R1896 VSS.t2278 VSS.n407 0.130189
R1897 VSS.t2276 VSS.n77 8.501
R1898 VSS.t2273 VSS.n406 0.130189
R1899 VSS.t2271 VSS.n77 8.501
R1900 VSS.t2268 VSS.n405 0.130189
R1901 VSS.t2266 VSS.n77 8.501
R1902 VSS.t2263 VSS.n404 0.130189
R1903 VSS.t2261 VSS.n77 8.501
R1904 VSS.t2258 VSS.n403 0.130189
R1905 VSS.t2256 VSS.n77 8.501
R1906 VSS.t2253 VSS.n402 0.130189
R1907 VSS.t2251 VSS.n77 8.501
R1908 VSS.t2248 VSS.n401 0.130189
R1909 VSS.t2246 VSS.n77 8.501
R1910 VSS.t2243 VSS.n400 0.130189
R1911 VSS.t2241 VSS.n77 8.501
R1912 VSS.t2238 VSS.n399 0.130189
R1913 VSS.t2236 VSS.n77 8.501
R1914 VSS.t2233 VSS.n398 0.130189
R1915 VSS.t2231 VSS.n77 8.501
R1916 VSS.n397 VSS.n77 3.33079
R1917 VSS.n509 VSS.t2111 0.130189
R1918 VSS.t2109 VSS.n76 8.501
R1919 VSS.n508 VSS.t2106 0.130189
R1920 VSS.t2104 VSS.n76 8.501
R1921 VSS.n507 VSS.t2101 0.130189
R1922 VSS.t2099 VSS.n76 8.501
R1923 VSS.n506 VSS.t2096 0.130189
R1924 VSS.t2094 VSS.n76 8.501
R1925 VSS.n505 VSS.t2091 0.130189
R1926 VSS.t2089 VSS.n76 8.501
R1927 VSS.n504 VSS.t2086 0.130189
R1928 VSS.t2084 VSS.n76 8.501
R1929 VSS.n503 VSS.t2081 0.130189
R1930 VSS.t2079 VSS.n300 0.0362711
R1931 VSS.n502 VSS.t2076 0.0793054
R1932 VSS.n76 VSS.t2074 8.501
R1933 VSS.t2071 VSS.n501 0.130189
R1934 VSS.t2069 VSS.n76 8.501
R1935 VSS.t2066 VSS.n500 0.130189
R1936 VSS.t2064 VSS.n76 8.501
R1937 VSS.t2061 VSS.n499 0.130189
R1938 VSS.t2059 VSS.n76 8.501
R1939 VSS.t2056 VSS.n498 0.130189
R1940 VSS.t2054 VSS.n76 8.501
R1941 VSS.t2051 VSS.n497 0.130189
R1942 VSS.t2049 VSS.n76 8.501
R1943 VSS.t2046 VSS.n496 0.130189
R1944 VSS.t2044 VSS.n76 8.501
R1945 VSS.t2041 VSS.n495 0.130189
R1946 VSS.t2039 VSS.n76 8.501
R1947 VSS.t2036 VSS.n494 0.130189
R1948 VSS.t2034 VSS.n76 8.501
R1949 VSS.t2031 VSS.n493 0.130189
R1950 VSS.t2029 VSS.n76 8.501
R1951 VSS.t2026 VSS.n492 0.130189
R1952 VSS.t2024 VSS.n76 8.501
R1953 VSS.t2021 VSS.n491 0.130189
R1954 VSS.t2019 VSS.n76 8.501
R1955 VSS.t2016 VSS.n490 0.130189
R1956 VSS.t2014 VSS.n76 8.501
R1957 VSS.t2011 VSS.n489 0.130189
R1958 VSS.t2009 VSS.n76 8.501
R1959 VSS.t2006 VSS.n488 0.130189
R1960 VSS.t2004 VSS.n301 0.0362711
R1961 VSS.t2001 VSS.n487 0.0793054
R1962 VSS.t1999 VSS.n76 8.501
R1963 VSS.t1996 VSS.n486 0.130189
R1964 VSS.t1994 VSS.n76 8.501
R1965 VSS.t1991 VSS.n485 0.130189
R1966 VSS.t1989 VSS.n76 8.501
R1967 VSS.t1986 VSS.n484 0.130189
R1968 VSS.t1984 VSS.n76 8.501
R1969 VSS.t1981 VSS.n483 0.130189
R1970 VSS.t1979 VSS.n76 8.501
R1971 VSS.t1976 VSS.n482 0.130189
R1972 VSS.t1974 VSS.n76 8.501
R1973 VSS.t1971 VSS.n481 0.130189
R1974 VSS.t1969 VSS.n76 8.501
R1975 VSS.t1966 VSS.n480 0.130189
R1976 VSS.t1964 VSS.n76 8.501
R1977 VSS.t1961 VSS.n479 0.130189
R1978 VSS.t1959 VSS.n76 8.501
R1979 VSS.t1956 VSS.n478 0.130189
R1980 VSS.t1954 VSS.n76 8.501
R1981 VSS.t1951 VSS.n477 0.130189
R1982 VSS.t1949 VSS.n76 8.501
R1983 VSS.t1946 VSS.n476 0.130189
R1984 VSS.t1944 VSS.n76 8.501
R1985 VSS.t1941 VSS.n475 0.130189
R1986 VSS.t1939 VSS.n76 8.501
R1987 VSS.t1936 VSS.n474 0.130189
R1988 VSS.t1934 VSS.n76 8.501
R1989 VSS.t1931 VSS.n473 0.130189
R1990 VSS.t1926 VSS.n472 0.130189
R1991 VSS.t1924 VSS.n76 8.501
R1992 VSS.t1921 VSS.n471 0.130189
R1993 VSS.t1919 VSS.n76 8.501
R1994 VSS.t1916 VSS.n470 0.130189
R1995 VSS.t1914 VSS.n76 8.501
R1996 VSS.t1911 VSS.n469 0.130189
R1997 VSS.t1909 VSS.n76 8.501
R1998 VSS.t1906 VSS.n468 0.130189
R1999 VSS.t1904 VSS.n76 8.501
R2000 VSS.t1901 VSS.n467 0.130189
R2001 VSS.t1899 VSS.n76 8.501
R2002 VSS.t1896 VSS.n466 0.130189
R2003 VSS.t1894 VSS.n76 8.501
R2004 VSS.t1891 VSS.n465 0.130189
R2005 VSS.t1889 VSS.n76 8.501
R2006 VSS.t1886 VSS.n464 0.130189
R2007 VSS.t1884 VSS.n76 8.501
R2008 VSS.t1881 VSS.n463 0.130189
R2009 VSS.t1879 VSS.n76 8.501
R2010 VSS.t1876 VSS.n462 0.130189
R2011 VSS.t1874 VSS.n76 8.501
R2012 VSS.t1871 VSS.n461 0.130189
R2013 VSS.t1869 VSS.n76 8.501
R2014 VSS.t1866 VSS.n460 0.130189
R2015 VSS.t1864 VSS.n76 8.501
R2016 VSS.t1861 VSS.n459 0.130189
R2017 VSS.t1859 VSS.n76 8.501
R2018 VSS.t1856 VSS.n458 0.130189
R2019 VSS.t1854 VSS.n76 8.501
R2020 VSS.t1851 VSS.n457 0.130189
R2021 VSS.t1849 VSS.n76 8.501
R2022 VSS.t1846 VSS.n456 0.130189
R2023 VSS.t1844 VSS.n76 8.501
R2024 VSS.t1841 VSS.n455 0.130189
R2025 VSS.t1839 VSS.n76 8.501
R2026 VSS.n454 VSS.n76 3.33079
R2027 VSS.n566 VSS.t1719 0.130189
R2028 VSS.t1717 VSS.n75 8.501
R2029 VSS.n565 VSS.t1714 0.130189
R2030 VSS.t1712 VSS.n75 8.501
R2031 VSS.n564 VSS.t1709 0.130189
R2032 VSS.t1707 VSS.n75 8.501
R2033 VSS.n563 VSS.t1704 0.130189
R2034 VSS.t1702 VSS.n75 8.501
R2035 VSS.n562 VSS.t1699 0.130189
R2036 VSS.t1697 VSS.n75 8.501
R2037 VSS.n561 VSS.t1694 0.130189
R2038 VSS.t1692 VSS.n75 8.501
R2039 VSS.n560 VSS.t1689 0.130189
R2040 VSS.t1687 VSS.n298 0.0362711
R2041 VSS.n559 VSS.t1684 0.0793054
R2042 VSS.t1682 VSS.n75 8.501
R2043 VSS.n558 VSS.t1679 0.130189
R2044 VSS.t1677 VSS.n75 8.501
R2045 VSS.n557 VSS.t1674 0.130189
R2046 VSS.t1672 VSS.n75 8.501
R2047 VSS.n556 VSS.t1669 0.130189
R2048 VSS.t1667 VSS.n75 8.501
R2049 VSS.n555 VSS.t1664 0.130189
R2050 VSS.t1662 VSS.n75 8.501
R2051 VSS.n554 VSS.t1659 0.130189
R2052 VSS.t1657 VSS.n75 8.501
R2053 VSS.n553 VSS.t1654 0.130189
R2054 VSS.t1652 VSS.n75 8.501
R2055 VSS.n552 VSS.t1649 0.130189
R2056 VSS.t1647 VSS.n75 8.501
R2057 VSS.n551 VSS.t1644 0.130189
R2058 VSS.t1642 VSS.n75 8.501
R2059 VSS.n550 VSS.t1639 0.130189
R2060 VSS.t1637 VSS.n75 8.501
R2061 VSS.n549 VSS.t1634 0.130189
R2062 VSS.t1632 VSS.n75 8.501
R2063 VSS.n548 VSS.t1629 0.130189
R2064 VSS.t1627 VSS.n75 8.501
R2065 VSS.n547 VSS.t1624 0.130189
R2066 VSS.t1622 VSS.n75 8.501
R2067 VSS.n546 VSS.t1619 0.130189
R2068 VSS.t1617 VSS.n75 8.501
R2069 VSS.n545 VSS.t1614 0.130189
R2070 VSS.t1612 VSS.n299 0.0362711
R2071 VSS.n544 VSS.t1609 0.0793054
R2072 VSS.t1607 VSS.n75 8.501
R2073 VSS.n543 VSS.t1604 0.130189
R2074 VSS.t1602 VSS.n75 8.501
R2075 VSS.n542 VSS.t1599 0.130189
R2076 VSS.t1597 VSS.n75 8.501
R2077 VSS.n541 VSS.t1594 0.130189
R2078 VSS.t1592 VSS.n75 8.501
R2079 VSS.n540 VSS.t1589 0.130189
R2080 VSS.t1587 VSS.n75 8.501
R2081 VSS.n539 VSS.t1584 0.130189
R2082 VSS.t1582 VSS.n75 8.501
R2083 VSS.n538 VSS.t1579 0.130189
R2084 VSS.t1577 VSS.n75 8.501
R2085 VSS.n537 VSS.t1574 0.130189
R2086 VSS.t1572 VSS.n75 8.501
R2087 VSS.n536 VSS.t1569 0.130189
R2088 VSS.t1567 VSS.n75 8.501
R2089 VSS.n535 VSS.t1564 0.130189
R2090 VSS.t1562 VSS.n75 8.501
R2091 VSS.n534 VSS.t1559 0.130189
R2092 VSS.t1557 VSS.n75 8.501
R2093 VSS.n533 VSS.t1554 0.130189
R2094 VSS.t1552 VSS.n75 8.501
R2095 VSS.n532 VSS.t1549 0.130189
R2096 VSS.t1547 VSS.n75 8.501
R2097 VSS.n531 VSS.t1544 0.130189
R2098 VSS.t1542 VSS.n75 8.501
R2099 VSS.n530 VSS.t1539 0.130189
R2100 VSS.n529 VSS.t1534 0.130189
R2101 VSS.t1532 VSS.n75 8.501
R2102 VSS.t1529 VSS.n528 0.130189
R2103 VSS.t1527 VSS.n75 8.501
R2104 VSS.t1524 VSS.n527 0.130189
R2105 VSS.t1522 VSS.n75 8.501
R2106 VSS.t1519 VSS.n526 0.130189
R2107 VSS.t1517 VSS.n75 8.501
R2108 VSS.t1514 VSS.n525 0.130189
R2109 VSS.t1512 VSS.n75 8.501
R2110 VSS.t1509 VSS.n524 0.130189
R2111 VSS.t1507 VSS.n75 8.501
R2112 VSS.t1504 VSS.n523 0.130189
R2113 VSS.t1502 VSS.n75 8.501
R2114 VSS.t1499 VSS.n522 0.130189
R2115 VSS.t1497 VSS.n75 8.501
R2116 VSS.t1494 VSS.n521 0.130189
R2117 VSS.t1492 VSS.n75 8.501
R2118 VSS.t1489 VSS.n520 0.130189
R2119 VSS.t1487 VSS.n75 8.501
R2120 VSS.t1484 VSS.n519 0.130189
R2121 VSS.t1482 VSS.n75 8.501
R2122 VSS.t1479 VSS.n518 0.130189
R2123 VSS.t1477 VSS.n75 8.501
R2124 VSS.t1474 VSS.n517 0.130189
R2125 VSS.t1472 VSS.n75 8.501
R2126 VSS.t1469 VSS.n516 0.130189
R2127 VSS.t1467 VSS.n75 8.501
R2128 VSS.t1464 VSS.n515 0.130189
R2129 VSS.t1462 VSS.n75 8.501
R2130 VSS.t1459 VSS.n514 0.130189
R2131 VSS.t1457 VSS.n75 8.501
R2132 VSS.t1454 VSS.n513 0.130189
R2133 VSS.t1452 VSS.n75 8.501
R2134 VSS.t1449 VSS.n512 0.130189
R2135 VSS.t1447 VSS.n75 8.501
R2136 VSS.n511 VSS.n75 3.33079
R2137 VSS.t1320 VSS.t1154 8.50331
R2138 VSS.n655 VSS.t1038 0.130189
R2139 VSS.t1036 VSS.n74 8.501
R2140 VSS.n654 VSS.t1033 0.130189
R2141 VSS.t1031 VSS.n74 8.501
R2142 VSS.n653 VSS.t1028 0.130189
R2143 VSS.t1026 VSS.n74 8.501
R2144 VSS.n652 VSS.t1023 0.130189
R2145 VSS.t1021 VSS.n74 8.501
R2146 VSS.n651 VSS.t1018 0.130189
R2147 VSS.t1016 VSS.n74 8.501
R2148 VSS.n650 VSS.t1013 0.130189
R2149 VSS.t1011 VSS.n74 8.501
R2150 VSS.n649 VSS.t1008 0.130189
R2151 VSS.t1006 VSS.n272 0.0362711
R2152 VSS.n648 VSS.t1003 0.0793054
R2153 VSS.n74 VSS.t1001 8.501
R2154 VSS.t998 VSS.n647 0.130189
R2155 VSS.t996 VSS.n74 8.501
R2156 VSS.t993 VSS.n646 0.130189
R2157 VSS.t991 VSS.n74 8.501
R2158 VSS.t988 VSS.n645 0.130189
R2159 VSS.t986 VSS.n74 8.501
R2160 VSS.t983 VSS.n644 0.130189
R2161 VSS.t981 VSS.n74 8.501
R2162 VSS.t978 VSS.n643 0.130189
R2163 VSS.t976 VSS.n74 8.501
R2164 VSS.t973 VSS.n642 0.130189
R2165 VSS.t971 VSS.n74 8.501
R2166 VSS.t968 VSS.n641 0.130189
R2167 VSS.t966 VSS.n74 8.501
R2168 VSS.t963 VSS.n640 0.130189
R2169 VSS.t961 VSS.n74 8.501
R2170 VSS.t958 VSS.n639 0.130189
R2171 VSS.t956 VSS.n74 8.501
R2172 VSS.t953 VSS.n638 0.130189
R2173 VSS.t951 VSS.n74 8.501
R2174 VSS.t948 VSS.n637 0.130189
R2175 VSS.t946 VSS.n74 8.501
R2176 VSS.t943 VSS.n636 0.130189
R2177 VSS.t941 VSS.n74 8.501
R2178 VSS.t938 VSS.n635 0.130189
R2179 VSS.t936 VSS.n74 8.501
R2180 VSS.t933 VSS.n634 0.130189
R2181 VSS.t931 VSS.n273 0.0362711
R2182 VSS.t928 VSS.n633 0.0793054
R2183 VSS.t926 VSS.n74 8.501
R2184 VSS.t923 VSS.n632 0.130189
R2185 VSS.t921 VSS.n74 8.501
R2186 VSS.t918 VSS.n631 0.130189
R2187 VSS.t916 VSS.n74 8.501
R2188 VSS.t913 VSS.n630 0.130189
R2189 VSS.t911 VSS.n74 8.501
R2190 VSS.t908 VSS.n629 0.130189
R2191 VSS.t906 VSS.n74 8.501
R2192 VSS.t903 VSS.n628 0.130189
R2193 VSS.t901 VSS.n74 8.501
R2194 VSS.t898 VSS.n627 0.130189
R2195 VSS.t896 VSS.n74 8.501
R2196 VSS.t893 VSS.n626 0.130189
R2197 VSS.t891 VSS.n74 8.501
R2198 VSS.t888 VSS.n625 0.130189
R2199 VSS.t886 VSS.n74 8.501
R2200 VSS.t883 VSS.n624 0.130189
R2201 VSS.t881 VSS.n74 8.501
R2202 VSS.t878 VSS.n623 0.130189
R2203 VSS.t876 VSS.n74 8.501
R2204 VSS.t873 VSS.n622 0.130189
R2205 VSS.t871 VSS.n74 8.501
R2206 VSS.t868 VSS.n621 0.130189
R2207 VSS.t866 VSS.n74 8.501
R2208 VSS.t863 VSS.n620 0.130189
R2209 VSS.t861 VSS.n74 8.501
R2210 VSS.t858 VSS.n619 0.130189
R2211 VSS.t853 VSS.n618 0.130189
R2212 VSS.t851 VSS.n74 8.501
R2213 VSS.t848 VSS.n617 0.130189
R2214 VSS.t846 VSS.n74 8.501
R2215 VSS.t843 VSS.n616 0.130189
R2216 VSS.t841 VSS.n74 8.501
R2217 VSS.t838 VSS.n615 0.130189
R2218 VSS.t836 VSS.n74 8.501
R2219 VSS.t833 VSS.n614 0.130189
R2220 VSS.t831 VSS.n74 8.501
R2221 VSS.t828 VSS.n613 0.130189
R2222 VSS.t826 VSS.n74 8.501
R2223 VSS.t823 VSS.n612 0.130189
R2224 VSS.t821 VSS.n74 8.501
R2225 VSS.t818 VSS.n611 0.130189
R2226 VSS.t816 VSS.n74 8.501
R2227 VSS.t813 VSS.n610 0.130189
R2228 VSS.t811 VSS.n74 8.501
R2229 VSS.t808 VSS.n609 0.130189
R2230 VSS.t806 VSS.n74 8.501
R2231 VSS.t803 VSS.n608 0.130189
R2232 VSS.t801 VSS.n74 8.501
R2233 VSS.t798 VSS.n607 0.130189
R2234 VSS.t796 VSS.n74 8.501
R2235 VSS.t793 VSS.n606 0.130189
R2236 VSS.t791 VSS.n74 8.501
R2237 VSS.t788 VSS.n605 0.130189
R2238 VSS.t786 VSS.n74 8.501
R2239 VSS.t783 VSS.n604 0.130189
R2240 VSS.t781 VSS.n74 8.501
R2241 VSS.t778 VSS.n603 0.130189
R2242 VSS.t776 VSS.n74 8.501
R2243 VSS.t773 VSS.n602 0.130189
R2244 VSS.t771 VSS.n74 8.501
R2245 VSS.t768 VSS.n601 0.130189
R2246 VSS.t766 VSS.n74 8.501
R2247 VSS.n600 VSS.n74 3.33079
R2248 VSS.t684 VSS.n669 0.0333775
R2249 VSS.t682 VSS.t72 8.501
R2250 VSS.t49 VSS.n668 0.129991
R2251 VSS.t678 VSS.t72 8.501
R2252 VSS.t571 VSS.n667 0.123414
R2253 VSS.t568 VSS.t72 8.501
R2254 VSS.t565 VSS.n666 0.130189
R2255 VSS.t563 VSS.t72 8.501
R2256 VSS.n665 VSS.t560 0.130189
R2257 VSS.n664 VSS.t555 0.130189
R2258 VSS.t553 VSS.t72 8.501
R2259 VSS.t550 VSS.n663 0.130189
R2260 VSS.t548 VSS.t72 8.501
R2261 VSS.t545 VSS.n662 0.130189
R2262 VSS.t543 VSS.t72 8.501
R2263 VSS.t540 VSS.n661 0.130189
R2264 VSS.t538 VSS.t72 8.501
R2265 VSS.t535 VSS.n660 0.130189
R2266 VSS.t533 VSS.t72 8.501
R2267 VSS.t530 VSS.n659 0.130189
R2268 VSS.t528 VSS.t72 8.501
R2269 VSS.t525 VSS.n658 0.130189
R2270 VSS.t523 VSS.t72 8.501
R2271 VSS.t520 VSS.n657 0.130189
R2272 VSS.t252 VSS.n271 0.330919
R2273 VSS.t98 VSS.n656 0.235729
R2274 VSS.n671 VSS.t72 0.983384
R2275 VSS.t688 VSS.n670 0.130189
R2276 VSS.t72 VSS.n254 4.20253
R2277 VSS.n186 VSS.t72 1.74964
R2278 VSS.t588 VSS.n676 0.235729
R2279 VSS.t583 VSS.n675 0.182614
R2280 VSS.t580 VSS.n674 0.235729
R2281 VSS.t578 VSS.n673 0.235729
R2282 VSS.t703 VSS.n672 0.129991
R2283 VSS.n233 VSS.t72 0.991884
R2284 VSS.t590 VSS.t72 8.501
R2285 VSS.t723 VSS.n679 0.130189
R2286 VSS.t721 VSS.t72 8.501
R2287 VSS.n678 VSS.t145 0.130189
R2288 VSS.t67 VSS.n677 0.652244
R2289 VSS.t635 VSS.n696 0.096752
R2290 VSS.t632 VSS.n695 0.235729
R2291 VSS.t629 VSS.n694 0.235729
R2292 VSS.t626 VSS.n693 0.235729
R2293 VSS.t623 VSS.n692 0.235729
R2294 VSS.t620 VSS.n691 0.235729
R2295 VSS.t617 VSS.n690 0.235729
R2296 VSS.t614 VSS.n689 0.235729
R2297 VSS.t611 VSS.n688 0.235729
R2298 VSS.t608 VSS.n687 0.235729
R2299 VSS.t605 VSS.n686 0.235729
R2300 VSS.t602 VSS.n685 0.235729
R2301 VSS.t599 VSS.n684 0.235729
R2302 VSS.t596 VSS.n683 0.235729
R2303 VSS.t593 VSS.n682 0.235729
R2304 VSS.t180 VSS.n681 0.235729
R2305 VSS.t72 VSS.n680 2.31576
R2306 VSS.t726 VSS.t72 8.501
R2307 VSS.n697 VSS.t11 0.983739
R2308 VSS.t27 VSS.t11 8.501
R2309 VSS.n698 VSS.t11 0.482662
R2310 VSS.t111 VSS.n203 0.56497
R2311 VSS.t468 VSS.n699 0.0296542
R2312 VSS.t397 VSS.n181 0.0737702
R2313 VSS.t443 VSS.n715 0.096752
R2314 VSS.t11 VSS.t442 8.501
R2315 VSS.t440 VSS.n714 0.130189
R2316 VSS.t11 VSS.t439 8.501
R2317 VSS.t437 VSS.n713 0.130189
R2318 VSS.t11 VSS.t436 8.501
R2319 VSS.t434 VSS.n712 0.130189
R2320 VSS.t11 VSS.t433 8.501
R2321 VSS.t431 VSS.n711 0.130189
R2322 VSS.t11 VSS.t430 8.501
R2323 VSS.t428 VSS.n710 0.130189
R2324 VSS.t11 VSS.t427 8.501
R2325 VSS.t425 VSS.n709 0.130189
R2326 VSS.t11 VSS.t424 8.501
R2327 VSS.t422 VSS.n708 0.130189
R2328 VSS.t11 VSS.t421 8.501
R2329 VSS.t419 VSS.n707 0.130189
R2330 VSS.t11 VSS.t418 8.501
R2331 VSS.t416 VSS.n706 0.130189
R2332 VSS.t11 VSS.t415 8.501
R2333 VSS.t413 VSS.n705 0.130189
R2334 VSS.t11 VSS.t412 8.501
R2335 VSS.t410 VSS.n704 0.130189
R2336 VSS.t11 VSS.t409 8.501
R2337 VSS.t407 VSS.n703 0.130189
R2338 VSS.t11 VSS.t406 8.501
R2339 VSS.t404 VSS.n702 0.130189
R2340 VSS.t11 VSS.t403 8.501
R2341 VSS.n701 VSS.t401 0.130189
R2342 VSS.t400 VSS.t11 8.501
R2343 VSS.n106 VSS.t241 0.0342296
R2344 VSS.n718 VSS.t458 0.130189
R2345 VSS.t56 VSS.t11 8.501
R2346 VSS.n717 VSS.t129 0.130189
R2347 VSS.t1 VSS.n716 0.752541
R2348 VSS.n128 VSS.t11 0.994
R2349 VSS.n722 VSS.t11 3.33079
R2350 VSS.n721 VSS.t11 0.991912
R2351 VSS.t387 VSS.t11 8.501
R2352 VSS.n720 VSS.t11 3.33079
R2353 VSS.t2321 VSS.n77 8.5005
R2354 VSS.t1929 VSS.n76 8.5005
R2355 VSS.n75 VSS.t1537 8.5005
R2356 VSS.t856 VSS.n74 8.5005
R2357 VSS.t72 VSS.t558 8.5005
R2358 VSS.t760 VSS.t72 8.00267
R2359 VSS.n370 VSS.n126 4.20468
R2360 VSS.n126 VSS.n355 4.20468
R2361 VSS.t304 VSS.n381 0.173604
R2362 VSS.n391 VSS.t341 0.153604
R2363 VSS.t2750 VSS.n393 0.17801
R2364 VSS.t198 VSS.t2871 8.47111
R2365 VSS.t2754 VSS.n297 0.235242
R2366 VSS.t198 VSS.t2753 8.47111
R2367 VSS.n297 VSS.t198 2.72093
R2368 VSS.n188 VSS.t2756 0.119605
R2369 VSS.t198 VSS.n188 4.177
R2370 VSS.n205 VSS.t2758 0.119605
R2371 VSS.t2760 VSS.n394 0.17801
R2372 VSS.t198 VSS.n205 4.177
R2373 VSS.t2763 VSS.n296 0.235242
R2374 VSS.t198 VSS.t2762 8.47111
R2375 VSS.n296 VSS.t198 2.72093
R2376 VSS.t198 VSS.t2765 8.47111
R2377 VSS.n206 VSS.t2766 0.119605
R2378 VSS.t198 VSS.n206 4.177
R2379 VSS.n395 VSS.t198 4.177
R2380 VSS.n395 VSS.t2768 0.119605
R2381 VSS.t198 VSS.n253 3.30688
R2382 VSS.t2741 VSS.n252 0.17801
R2383 VSS.t2737 VSS.n304 0.177814
R2384 VSS.t2732 VSS.n305 0.177814
R2385 VSS.t2727 VSS.n251 0.177814
R2386 VSS.n306 VSS.t2723 0.177814
R2387 VSS.n250 VSS.t2717 0.177814
R2388 VSS.n307 VSS.t2712 0.17801
R2389 VSS.t198 VSS.n225 3.30688
R2390 VSS.n308 VSS.t2706 0.17801
R2391 VSS.n249 VSS.t2700 0.17801
R2392 VSS.t2695 VSS.n309 0.17801
R2393 VSS.t2689 VSS.n310 0.17801
R2394 VSS.t2683 VSS.n248 0.17801
R2395 VSS.n311 VSS.t2679 0.177814
R2396 VSS.n247 VSS.t2674 0.177814
R2397 VSS.n312 VSS.t2670 0.17801
R2398 VSS.n313 VSS.t2665 0.17801
R2399 VSS.n246 VSS.t2660 0.17801
R2400 VSS.t2656 VSS.n314 0.17801
R2401 VSS.t2651 VSS.n315 0.17801
R2402 VSS.t2646 VSS.n245 0.17801
R2403 VSS.t2642 VSS.n316 0.177814
R2404 VSS.n396 VSS.t198 4.177
R2405 VSS.n396 VSS.t2637 0.119605
R2406 VSS.n244 VSS.t198 3.30688
R2407 VSS.n229 VSS.t198 3.30688
R2408 VSS.t198 VSS.n243 3.30688
R2409 VSS.t2622 VSS.n242 0.17801
R2410 VSS.n445 VSS.n77 4.20468
R2411 VSS.n430 VSS.n77 4.20468
R2412 VSS.n502 VSS.n76 4.20468
R2413 VSS.n76 VSS.n487 4.20468
R2414 VSS.n75 VSS.n559 4.20468
R2415 VSS.n544 VSS.n75 4.20468
R2416 VSS.t1210 VSS.n567 0.17801
R2417 VSS.n295 VSS.t1154 2.29759
R2418 VSS.t1212 VSS.t1154 8.47111
R2419 VSS.t1213 VSS.n295 0.2914
R2420 VSS.t1216 VSS.n283 0.17801
R2421 VSS.t1219 VSS.n568 0.177814
R2422 VSS.t1222 VSS.n204 0.231785
R2423 VSS.n241 VSS.t1154 3.30688
R2424 VSS.t1230 VSS.n569 0.119605
R2425 VSS.n569 VSS.t1154 4.177
R2426 VSS.t1233 VSS.n570 0.119605
R2427 VSS.n570 VSS.t1154 4.177
R2428 VSS.t1236 VSS.n571 0.119605
R2429 VSS.n571 VSS.t1154 4.177
R2430 VSS.t1239 VSS.n572 0.119605
R2431 VSS.n572 VSS.t1154 4.177
R2432 VSS.t1241 VSS.t1154 8.47111
R2433 VSS.n282 VSS.t1154 3.30696
R2434 VSS.t1244 VSS.n208 0.119605
R2435 VSS.t1246 VSS.n573 0.17801
R2436 VSS.n208 VSS.t1154 4.177
R2437 VSS.n574 VSS.t1154 4.177
R2438 VSS.t1248 VSS.t1154 8.47111
R2439 VSS.n281 VSS.t1154 4.177
R2440 VSS.t1251 VSS.n281 0.119605
R2441 VSS.t1255 VSS.n279 0.17801
R2442 VSS.t1256 VSS.t1154 8.47111
R2443 VSS.t1154 VSS.n575 4.177
R2444 VSS.n575 VSS.t1258 0.119605
R2445 VSS.n576 VSS.t1259 0.119605
R2446 VSS.t1396 VSS.t1154 8.47111
R2447 VSS.t1154 VSS.n576 4.177
R2448 VSS.n577 VSS.t1154 3.30688
R2449 VSS.t1399 VSS.t1154 8.47111
R2450 VSS.t1264 VSS.n578 0.119605
R2451 VSS.n578 VSS.t1154 4.177
R2452 VSS.t1267 VSS.n579 0.119605
R2453 VSS.n579 VSS.t1154 4.177
R2454 VSS.t1270 VSS.n580 0.17801
R2455 VSS.t1406 VSS.t1154 8.47111
R2456 VSS.n581 VSS.t1154 3.30688
R2457 VSS.t1409 VSS.n278 0.119605
R2458 VSS.n278 VSS.t1154 4.177
R2459 VSS.t1277 VSS.t1154 8.47111
R2460 VSS.n582 VSS.t1278 0.119605
R2461 VSS.t1154 VSS.n582 4.177
R2462 VSS.t1154 VSS.n209 3.30688
R2463 VSS.n583 VSS.t1282 0.119605
R2464 VSS.t1154 VSS.n583 4.177
R2465 VSS.t1154 VSS.n277 4.177
R2466 VSS.n277 VSS.t1286 0.119605
R2467 VSS.t1154 VSS.n276 3.30688
R2468 VSS.t1154 VSS.t1289 8.47111
R2469 VSS.n210 VSS.t1154 4.177
R2470 VSS.n210 VSS.t1290 0.119605
R2471 VSS.t1291 VSS.n584 0.17801
R2472 VSS.t1423 VSS.t1154 8.47111
R2473 VSS.n585 VSS.t1154 3.30688
R2474 VSS.t1426 VSS.t1154 8.47111
R2475 VSS.n586 VSS.t1154 5.61485
R2476 VSS.n179 VSS.t1154 4.177
R2477 VSS.n179 VSS.t1428 0.119605
R2478 VSS.n587 VSS.t1154 3.30688
R2479 VSS.t1431 VSS.n275 0.119605
R2480 VSS.n275 VSS.t1154 4.177
R2481 VSS.n588 VSS.t1308 0.119605
R2482 VSS.t1154 VSS.n588 4.177
R2483 VSS.t1154 VSS.n211 3.30688
R2484 VSS.n589 VSS.t1312 0.119605
R2485 VSS.t1154 VSS.n589 4.177
R2486 VSS.t1154 VSS.n274 4.177
R2487 VSS.n274 VSS.t1316 0.119605
R2488 VSS.n590 VSS.t1154 3.30688
R2489 VSS.t1154 VSS.n207 5.61485
R2490 VSS.t1154 VSS.n238 3.30688
R2491 VSS.t1154 VSS.n591 4.177
R2492 VSS.n591 VSS.t1204 0.119605
R2493 VSS.t1154 VSS.n212 4.177
R2494 VSS.t1202 VSS.n212 0.119605
R2495 VSS.n189 VSS.t1154 4.177
R2496 VSS.t1200 VSS.n189 0.119605
R2497 VSS.n592 VSS.t1154 4.177
R2498 VSS.t1353 VSS.n592 0.119605
R2499 VSS.t1154 VSS.n213 4.177
R2500 VSS.n213 VSS.t1196 0.119605
R2501 VSS.t1154 VSS.n190 4.177
R2502 VSS.n190 VSS.t1194 0.119605
R2503 VSS.t1154 VSS.n593 4.177
R2504 VSS.n593 VSS.t1191 0.119605
R2505 VSS.n214 VSS.t1154 4.177
R2506 VSS.t1189 VSS.n214 0.119605
R2507 VSS.t1188 VSS.n172 0.177814
R2508 VSS.t1186 VSS.n284 0.17801
R2509 VSS.t1184 VSS.n285 0.119605
R2510 VSS.n285 VSS.t1154 4.177
R2511 VSS.n594 VSS.t1154 4.177
R2512 VSS.n594 VSS.t1182 0.119605
R2513 VSS.t1180 VSS.n286 0.177814
R2514 VSS.t1178 VSS.n287 0.17801
R2515 VSS.t1176 VSS.n288 0.119605
R2516 VSS.n288 VSS.t1154 4.177
R2517 VSS.n595 VSS.t1154 4.177
R2518 VSS.n595 VSS.t1174 0.119605
R2519 VSS.t1172 VSS.n289 0.177814
R2520 VSS.t1170 VSS.n290 0.17801
R2521 VSS.t1168 VSS.n291 0.119605
R2522 VSS.n291 VSS.t1154 4.177
R2523 VSS.t1328 VSS.t1154 8.47111
R2524 VSS.t1327 VSS.n292 0.177814
R2525 VSS.t1164 VSS.n293 0.177814
R2526 VSS.n294 VSS.t1154 4.177
R2527 VSS.n596 VSS.t1154 4.177
R2528 VSS.t1159 VSS.n596 0.119605
R2529 VSS.n162 VSS.t1154 3.30688
R2530 VSS.t1156 VSS.n597 0.10425
R2531 VSS.n648 VSS.n74 4.20468
R2532 VSS.n74 VSS.n633 4.20468
R2533 VSS.t685 VSS.n254 0.083315
R2534 VSS.n120 VSS.t98 0.32297
R2535 VSS.n170 VSS.t142 0.834137
R2536 VSS.t19 VSS.n258 0.119605
R2537 VSS.n258 VSS.t11 4.177
R2538 VSS.n181 VSS.t11 4.20744
R2539 VSS.n700 VSS.t89 0.119605
R2540 VSS.n700 VSS.t11 4.177
R2541 VSS.n899 VSS.t11 8.47111
R2542 VSS.t103 VSS.n257 0.17801
R2543 VSS.n851 VSS.t154 8.06935
R2544 VSS.t3183 VSS.t683 7.1604
R2545 VSS.t159 VSS.t93 7.1604
R2546 VSS.t11 VSS.t9 0.737345
R2547 VSS.t4 VSS.t11 0.445764
R2548 VSS.t72 VSS.n696 3.35999
R2549 VSS.n377 VSS.n126 3.33079
R2550 VSS.n126 VSS.n376 3.33079
R2551 VSS.n375 VSS.n126 3.33079
R2552 VSS.n126 VSS.n374 3.33079
R2553 VSS.n373 VSS.n126 3.33079
R2554 VSS.n126 VSS.n372 3.33079
R2555 VSS.n371 VSS.n126 3.33079
R2556 VSS.n126 VSS.n369 3.33079
R2557 VSS.n368 VSS.n126 3.33079
R2558 VSS.n367 VSS.n126 3.33079
R2559 VSS.n366 VSS.n126 3.33079
R2560 VSS.n365 VSS.n126 3.33079
R2561 VSS.n364 VSS.n126 3.33079
R2562 VSS.n363 VSS.n126 3.33079
R2563 VSS.n362 VSS.n126 3.33079
R2564 VSS.n361 VSS.n126 3.33079
R2565 VSS.n360 VSS.n126 3.33079
R2566 VSS.n359 VSS.n126 3.33079
R2567 VSS.n358 VSS.n126 3.33079
R2568 VSS.n357 VSS.n126 3.33079
R2569 VSS.n356 VSS.n126 3.33079
R2570 VSS.n354 VSS.n126 3.33079
R2571 VSS.n353 VSS.n126 3.33079
R2572 VSS.n352 VSS.n126 3.33079
R2573 VSS.n351 VSS.n126 3.33079
R2574 VSS.n350 VSS.n126 3.33079
R2575 VSS.n349 VSS.n126 3.33079
R2576 VSS.n348 VSS.n126 3.33079
R2577 VSS.n347 VSS.n126 3.33079
R2578 VSS.n346 VSS.n126 3.33079
R2579 VSS.n345 VSS.n126 3.33079
R2580 VSS.n344 VSS.n126 3.33079
R2581 VSS.n343 VSS.n126 3.33079
R2582 VSS.n342 VSS.n126 3.33079
R2583 VSS.n341 VSS.n126 3.33079
R2584 VSS.n340 VSS.n126 3.33079
R2585 VSS.n339 VSS.n126 3.33079
R2586 VSS.n338 VSS.n126 3.33079
R2587 VSS.n337 VSS.n126 3.33079
R2588 VSS.n336 VSS.n126 3.33079
R2589 VSS.n335 VSS.n126 3.33079
R2590 VSS.n334 VSS.n126 3.33079
R2591 VSS.n333 VSS.n126 3.33079
R2592 VSS.n332 VSS.n126 3.33079
R2593 VSS.n331 VSS.n126 3.33079
R2594 VSS.n330 VSS.n126 3.33079
R2595 VSS.n329 VSS.n126 3.33079
R2596 VSS.n328 VSS.n126 3.33079
R2597 VSS.n327 VSS.n126 3.33079
R2598 VSS.n126 VSS.n326 3.33079
R2599 VSS.n324 VSS.n126 3.33079
R2600 VSS.n126 VSS.n323 3.33079
R2601 VSS.t2887 VSS.n322 0.0863258
R2602 VSS.t263 VSS.n723 0.0896992
R2603 VSS.t299 VSS.n380 0.0896992
R2604 VSS.t309 VSS.n382 0.0896992
R2605 VSS.t314 VSS.n383 0.0896992
R2606 VSS.t319 VSS.n384 0.0896992
R2607 VSS.t323 VSS.n386 0.0896992
R2608 VSS.t328 VSS.n387 0.0896992
R2609 VSS.t333 VSS.n388 0.0896992
R2610 VSS.t336 VSS.n390 0.0896992
R2611 VSS.n392 VSS.t346 0.0896992
R2612 VSS.t198 VSS.n393 3.30688
R2613 VSS.t198 VSS.n394 3.30688
R2614 VSS.n202 VSS.t2770 0.151914
R2615 VSS.n182 VSS.t2747 0.175714
R2616 VSS.t198 VSS.t2746 5.61485
R2617 VSS.n253 VSS.t2744 0.118323
R2618 VSS.t2743 VSS.n192 0.175714
R2619 VSS.t198 VSS.n192 2.72082
R2620 VSS.t198 VSS.n252 3.30688
R2621 VSS.n194 VSS.t2739 0.175395
R2622 VSS.n194 VSS.t198 2.72098
R2623 VSS.n304 VSS.t198 3.30696
R2624 VSS.n228 VSS.t2735 0.175554
R2625 VSS.t198 VSS.n228 2.7209
R2626 VSS.t2733 VSS.t198 5.61485
R2627 VSS.n305 VSS.t198 3.30696
R2628 VSS.n227 VSS.t2730 0.175554
R2629 VSS.t198 VSS.n227 2.7209
R2630 VSS.t2728 VSS.t198 5.61485
R2631 VSS.n251 VSS.t198 3.30696
R2632 VSS.n195 VSS.t2725 0.175554
R2633 VSS.t198 VSS.n195 2.7209
R2634 VSS.n306 VSS.t198 3.30696
R2635 VSS.t2720 VSS.n226 0.175714
R2636 VSS.t198 VSS.n226 2.72082
R2637 VSS.t198 VSS.t2718 5.61485
R2638 VSS.n250 VSS.t198 3.30696
R2639 VSS.t2714 VSS.n196 0.175714
R2640 VSS.t198 VSS.n196 2.72082
R2641 VSS.t198 VSS.n307 3.30688
R2642 VSS.t2709 VSS.n225 0.118323
R2643 VSS.n180 VSS.t2707 0.0600369
R2644 VSS.t198 VSS.n308 3.30688
R2645 VSS.t2703 VSS.n224 0.175554
R2646 VSS.n224 VSS.t198 2.7209
R2647 VSS.t198 VSS.t2701 5.61485
R2648 VSS.t198 VSS.n249 3.30688
R2649 VSS.t2697 VSS.n197 0.175554
R2650 VSS.n197 VSS.t198 2.7209
R2651 VSS.t198 VSS.n309 3.30688
R2652 VSS.n223 VSS.t2693 0.175395
R2653 VSS.n223 VSS.t198 2.72098
R2654 VSS.t2690 VSS.t198 5.61485
R2655 VSS.t198 VSS.n310 3.30688
R2656 VSS.n222 VSS.t2687 0.175395
R2657 VSS.n222 VSS.t198 2.72098
R2658 VSS.t2684 VSS.t198 5.61485
R2659 VSS.t198 VSS.n248 3.30688
R2660 VSS.n198 VSS.t2681 0.175395
R2661 VSS.n198 VSS.t198 2.72098
R2662 VSS.n311 VSS.t198 3.30696
R2663 VSS.n221 VSS.t2677 0.175554
R2664 VSS.t198 VSS.n221 2.7209
R2665 VSS.t2675 VSS.t198 5.61485
R2666 VSS.n247 VSS.t198 3.30696
R2667 VSS.n199 VSS.t2672 0.175554
R2668 VSS.t198 VSS.n199 2.7209
R2669 VSS.t198 VSS.n312 3.30688
R2670 VSS.t2668 VSS.n220 0.175714
R2671 VSS.t198 VSS.n220 2.72082
R2672 VSS.t198 VSS.t2666 5.61485
R2673 VSS.t198 VSS.n313 3.30688
R2674 VSS.t2663 VSS.n219 0.175714
R2675 VSS.t198 VSS.n219 2.72082
R2676 VSS.t198 VSS.t2661 5.61485
R2677 VSS.t198 VSS.n246 3.30688
R2678 VSS.t2658 VSS.n200 0.175714
R2679 VSS.t198 VSS.n200 2.72082
R2680 VSS.t198 VSS.n314 3.30688
R2681 VSS.n218 VSS.t2654 0.175395
R2682 VSS.n218 VSS.t198 2.72098
R2683 VSS.t198 VSS.t2652 5.61485
R2684 VSS.t198 VSS.n315 3.30688
R2685 VSS.n217 VSS.t2649 0.175395
R2686 VSS.n217 VSS.t198 2.72098
R2687 VSS.t198 VSS.t2647 5.61485
R2688 VSS.t198 VSS.n245 3.30688
R2689 VSS.n201 VSS.t2644 0.175395
R2690 VSS.n201 VSS.t198 2.72098
R2691 VSS.n316 VSS.t198 3.30696
R2692 VSS.n216 VSS.t2640 0.175554
R2693 VSS.t198 VSS.n216 2.7209
R2694 VSS.t2638 VSS.t198 5.61485
R2695 VSS.t2636 VSS.n161 0.175714
R2696 VSS.t198 VSS.n161 2.72082
R2697 VSS.n244 VSS.t2633 0.118323
R2698 VSS.t198 VSS.t2632 5.61485
R2699 VSS.t2631 VSS.n229 0.118323
R2700 VSS.t2629 VSS.n169 0.175714
R2701 VSS.t198 VSS.n169 2.72082
R2702 VSS.n243 VSS.t2626 0.118323
R2703 VSS.t2624 VSS.n193 0.175554
R2704 VSS.n193 VSS.t198 2.7209
R2705 VSS.t198 VSS.n242 3.30688
R2706 VSS.n321 VSS.t2620 0.106161
R2707 VSS.n415 VSS.n77 3.33079
R2708 VSS.n77 VSS.n452 3.33079
R2709 VSS.n451 VSS.n77 3.33079
R2710 VSS.n449 VSS.n77 3.33079
R2711 VSS.n77 VSS.n448 3.33079
R2712 VSS.n447 VSS.n77 3.33079
R2713 VSS.n77 VSS.n446 3.33079
R2714 VSS.n77 VSS.n444 3.33079
R2715 VSS.n443 VSS.n77 3.33079
R2716 VSS.n77 VSS.n442 3.33079
R2717 VSS.n441 VSS.n77 3.33079
R2718 VSS.n77 VSS.n440 3.33079
R2719 VSS.n439 VSS.n77 3.33079
R2720 VSS.n77 VSS.n438 3.33079
R2721 VSS.n437 VSS.n77 3.33079
R2722 VSS.n77 VSS.n436 3.33079
R2723 VSS.n435 VSS.n77 3.33079
R2724 VSS.n77 VSS.n434 3.33079
R2725 VSS.n433 VSS.n77 3.33079
R2726 VSS.n77 VSS.n432 3.33079
R2727 VSS.n431 VSS.n77 3.33079
R2728 VSS.n77 VSS.n429 3.33079
R2729 VSS.n428 VSS.n77 3.33079
R2730 VSS.n427 VSS.n77 3.33079
R2731 VSS.n426 VSS.n77 3.33079
R2732 VSS.n425 VSS.n77 3.33079
R2733 VSS.n424 VSS.n77 3.33079
R2734 VSS.n423 VSS.n77 3.33079
R2735 VSS.n422 VSS.n77 3.33079
R2736 VSS.n421 VSS.n77 3.33079
R2737 VSS.n420 VSS.n77 3.33079
R2738 VSS.n419 VSS.n77 3.33079
R2739 VSS.n418 VSS.n77 3.33079
R2740 VSS.n417 VSS.n77 3.33079
R2741 VSS.n416 VSS.n77 3.33079
R2742 VSS.n414 VSS.n77 3.33079
R2743 VSS.n413 VSS.n77 3.33079
R2744 VSS.n412 VSS.n77 3.33079
R2745 VSS.n411 VSS.n77 3.33079
R2746 VSS.n410 VSS.n77 3.33079
R2747 VSS.n409 VSS.n77 3.33079
R2748 VSS.n408 VSS.n77 3.33079
R2749 VSS.n407 VSS.n77 3.33079
R2750 VSS.n406 VSS.n77 3.33079
R2751 VSS.n405 VSS.n77 3.33079
R2752 VSS.n404 VSS.n77 3.33079
R2753 VSS.n403 VSS.n77 3.33079
R2754 VSS.n402 VSS.n77 3.33079
R2755 VSS.n401 VSS.n77 3.33079
R2756 VSS.n400 VSS.n77 3.33079
R2757 VSS.n399 VSS.n77 3.33079
R2758 VSS.n398 VSS.n77 3.33079
R2759 VSS.t2229 VSS.n397 0.0863258
R2760 VSS.n472 VSS.n76 3.33079
R2761 VSS.n509 VSS.n76 3.33079
R2762 VSS.n76 VSS.n508 3.33079
R2763 VSS.n507 VSS.n76 3.33079
R2764 VSS.n76 VSS.n506 3.33079
R2765 VSS.n505 VSS.n76 3.33079
R2766 VSS.n76 VSS.n504 3.33079
R2767 VSS.n503 VSS.n76 3.33079
R2768 VSS.n76 VSS.n501 3.33079
R2769 VSS.n500 VSS.n76 3.33079
R2770 VSS.n499 VSS.n76 3.33079
R2771 VSS.n498 VSS.n76 3.33079
R2772 VSS.n497 VSS.n76 3.33079
R2773 VSS.n496 VSS.n76 3.33079
R2774 VSS.n495 VSS.n76 3.33079
R2775 VSS.n494 VSS.n76 3.33079
R2776 VSS.n493 VSS.n76 3.33079
R2777 VSS.n492 VSS.n76 3.33079
R2778 VSS.n491 VSS.n76 3.33079
R2779 VSS.n490 VSS.n76 3.33079
R2780 VSS.n489 VSS.n76 3.33079
R2781 VSS.n488 VSS.n76 3.33079
R2782 VSS.n486 VSS.n76 3.33079
R2783 VSS.n485 VSS.n76 3.33079
R2784 VSS.n484 VSS.n76 3.33079
R2785 VSS.n483 VSS.n76 3.33079
R2786 VSS.n482 VSS.n76 3.33079
R2787 VSS.n481 VSS.n76 3.33079
R2788 VSS.n480 VSS.n76 3.33079
R2789 VSS.n479 VSS.n76 3.33079
R2790 VSS.n478 VSS.n76 3.33079
R2791 VSS.n477 VSS.n76 3.33079
R2792 VSS.n476 VSS.n76 3.33079
R2793 VSS.n475 VSS.n76 3.33079
R2794 VSS.n474 VSS.n76 3.33079
R2795 VSS.n473 VSS.n76 3.33079
R2796 VSS.n471 VSS.n76 3.33079
R2797 VSS.n470 VSS.n76 3.33079
R2798 VSS.n469 VSS.n76 3.33079
R2799 VSS.n468 VSS.n76 3.33079
R2800 VSS.n467 VSS.n76 3.33079
R2801 VSS.n466 VSS.n76 3.33079
R2802 VSS.n465 VSS.n76 3.33079
R2803 VSS.n464 VSS.n76 3.33079
R2804 VSS.n463 VSS.n76 3.33079
R2805 VSS.n462 VSS.n76 3.33079
R2806 VSS.n461 VSS.n76 3.33079
R2807 VSS.n460 VSS.n76 3.33079
R2808 VSS.n459 VSS.n76 3.33079
R2809 VSS.n458 VSS.n76 3.33079
R2810 VSS.n456 VSS.n76 3.33079
R2811 VSS.n455 VSS.n76 3.33079
R2812 VSS.t1837 VSS.n454 0.0863258
R2813 VSS.n529 VSS.n75 3.33079
R2814 VSS.n566 VSS.n75 3.33079
R2815 VSS.n75 VSS.n565 3.33079
R2816 VSS.n75 VSS.n563 3.33079
R2817 VSS.n562 VSS.n75 3.33079
R2818 VSS.n75 VSS.n561 3.33079
R2819 VSS.n560 VSS.n75 3.33079
R2820 VSS.n558 VSS.n75 3.33079
R2821 VSS.n75 VSS.n557 3.33079
R2822 VSS.n556 VSS.n75 3.33079
R2823 VSS.n75 VSS.n555 3.33079
R2824 VSS.n554 VSS.n75 3.33079
R2825 VSS.n75 VSS.n553 3.33079
R2826 VSS.n552 VSS.n75 3.33079
R2827 VSS.n75 VSS.n551 3.33079
R2828 VSS.n550 VSS.n75 3.33079
R2829 VSS.n75 VSS.n549 3.33079
R2830 VSS.n548 VSS.n75 3.33079
R2831 VSS.n75 VSS.n547 3.33079
R2832 VSS.n546 VSS.n75 3.33079
R2833 VSS.n75 VSS.n545 3.33079
R2834 VSS.n75 VSS.n543 3.33079
R2835 VSS.n542 VSS.n75 3.33079
R2836 VSS.n75 VSS.n541 3.33079
R2837 VSS.n540 VSS.n75 3.33079
R2838 VSS.n75 VSS.n539 3.33079
R2839 VSS.n538 VSS.n75 3.33079
R2840 VSS.n75 VSS.n537 3.33079
R2841 VSS.n536 VSS.n75 3.33079
R2842 VSS.n75 VSS.n535 3.33079
R2843 VSS.n534 VSS.n75 3.33079
R2844 VSS.n75 VSS.n533 3.33079
R2845 VSS.n532 VSS.n75 3.33079
R2846 VSS.n75 VSS.n531 3.33079
R2847 VSS.n530 VSS.n75 3.33079
R2848 VSS.n528 VSS.n75 3.33079
R2849 VSS.n527 VSS.n75 3.33079
R2850 VSS.n526 VSS.n75 3.33079
R2851 VSS.n525 VSS.n75 3.33079
R2852 VSS.n524 VSS.n75 3.33079
R2853 VSS.n523 VSS.n75 3.33079
R2854 VSS.n522 VSS.n75 3.33079
R2855 VSS.n521 VSS.n75 3.33079
R2856 VSS.n520 VSS.n75 3.33079
R2857 VSS.n519 VSS.n75 3.33079
R2858 VSS.n518 VSS.n75 3.33079
R2859 VSS.n517 VSS.n75 3.33079
R2860 VSS.n516 VSS.n75 3.33079
R2861 VSS.n515 VSS.n75 3.33079
R2862 VSS.n514 VSS.n75 3.33079
R2863 VSS.n513 VSS.n75 3.33079
R2864 VSS.n512 VSS.n75 3.33079
R2865 VSS.t1445 VSS.n511 0.0863258
R2866 VSS.n567 VSS.t1154 3.30688
R2867 VSS.n283 VSS.t1154 3.30688
R2868 VSS.t1218 VSS.t1154 5.61485
R2869 VSS.n568 VSS.t1154 3.30696
R2870 VSS.t1225 VSS.n241 0.118323
R2871 VSS.t1226 VSS.n240 0.175554
R2872 VSS.n240 VSS.t1154 2.7209
R2873 VSS.t1229 VSS.t1154 5.61485
R2874 VSS.t1232 VSS.t1154 5.61485
R2875 VSS.t1235 VSS.t1154 5.61485
R2876 VSS.t1238 VSS.t1154 5.61485
R2877 VSS.t1242 VSS.n282 0.118193
R2878 VSS.n573 VSS.t1154 3.30688
R2879 VSS.n280 VSS.t1154 4.17712
R2880 VSS.n279 VSS.t1154 3.30688
R2881 VSS.n577 VSS.t1262 0.118323
R2882 VSS.t1266 VSS.t1154 5.61485
R2883 VSS.t1269 VSS.t1154 5.61485
R2884 VSS.t1154 VSS.n580 3.30688
R2885 VSS.n581 VSS.t1274 0.118323
R2886 VSS.t1280 VSS.n209 0.118323
R2887 VSS.t1154 VSS.t1284 5.61485
R2888 VSS.n276 VSS.t1287 0.118323
R2889 VSS.t1154 VSS.n584 3.30688
R2890 VSS.n585 VSS.t1295 0.118323
R2891 VSS.n587 VSS.t1301 0.118323
R2892 VSS.n239 VSS.t1304 0.175554
R2893 VSS.t1154 VSS.n239 2.7209
R2894 VSS.t1307 VSS.t1154 5.61485
R2895 VSS.t1310 VSS.n211 0.118323
R2896 VSS.t1154 VSS.t1314 5.61485
R2897 VSS.t1154 VSS.t1317 5.61485
R2898 VSS.t1318 VSS.n590 0.118323
R2899 VSS.n238 VSS.t1206 0.118323
R2900 VSS.t1199 VSS.t1154 5.61485
R2901 VSS.t1154 VSS.t1193 5.61485
R2902 VSS.n172 VSS.t1154 3.30696
R2903 VSS.t1154 VSS.n284 3.30688
R2904 VSS.t1181 VSS.t1154 5.61485
R2905 VSS.n286 VSS.t1154 3.30696
R2906 VSS.t1154 VSS.n287 3.30688
R2907 VSS.t1173 VSS.t1154 5.61485
R2908 VSS.n289 VSS.t1154 3.30696
R2909 VSS.t1154 VSS.n290 3.30688
R2910 VSS.n292 VSS.t1154 3.30696
R2911 VSS.n293 VSS.t1154 3.30696
R2912 VSS.t1158 VSS.n162 0.118323
R2913 VSS.n618 VSS.n74 3.33079
R2914 VSS.n655 VSS.n74 3.33079
R2915 VSS.n74 VSS.n654 3.33079
R2916 VSS.n74 VSS.n652 3.33079
R2917 VSS.n651 VSS.n74 3.33079
R2918 VSS.n74 VSS.n650 3.33079
R2919 VSS.n649 VSS.n74 3.33079
R2920 VSS.n74 VSS.n647 3.33079
R2921 VSS.n646 VSS.n74 3.33079
R2922 VSS.n645 VSS.n74 3.33079
R2923 VSS.n644 VSS.n74 3.33079
R2924 VSS.n643 VSS.n74 3.33079
R2925 VSS.n642 VSS.n74 3.33079
R2926 VSS.n641 VSS.n74 3.33079
R2927 VSS.n640 VSS.n74 3.33079
R2928 VSS.n639 VSS.n74 3.33079
R2929 VSS.n638 VSS.n74 3.33079
R2930 VSS.n637 VSS.n74 3.33079
R2931 VSS.n636 VSS.n74 3.33079
R2932 VSS.n635 VSS.n74 3.33079
R2933 VSS.n634 VSS.n74 3.33079
R2934 VSS.n632 VSS.n74 3.33079
R2935 VSS.n631 VSS.n74 3.33079
R2936 VSS.n630 VSS.n74 3.33079
R2937 VSS.n629 VSS.n74 3.33079
R2938 VSS.n628 VSS.n74 3.33079
R2939 VSS.n627 VSS.n74 3.33079
R2940 VSS.n626 VSS.n74 3.33079
R2941 VSS.n625 VSS.n74 3.33079
R2942 VSS.n624 VSS.n74 3.33079
R2943 VSS.n623 VSS.n74 3.33079
R2944 VSS.n622 VSS.n74 3.33079
R2945 VSS.n621 VSS.n74 3.33079
R2946 VSS.n620 VSS.n74 3.33079
R2947 VSS.n619 VSS.n74 3.33079
R2948 VSS.n617 VSS.n74 3.33079
R2949 VSS.n616 VSS.n74 3.33079
R2950 VSS.n615 VSS.n74 3.33079
R2951 VSS.n614 VSS.n74 3.33079
R2952 VSS.n613 VSS.n74 3.33079
R2953 VSS.n612 VSS.n74 3.33079
R2954 VSS.n611 VSS.n74 3.33079
R2955 VSS.n610 VSS.n74 3.33079
R2956 VSS.n609 VSS.n74 3.33079
R2957 VSS.n608 VSS.n74 3.33079
R2958 VSS.n607 VSS.n74 3.33079
R2959 VSS.n606 VSS.n74 3.33079
R2960 VSS.n605 VSS.n74 3.33079
R2961 VSS.n604 VSS.n74 3.33079
R2962 VSS.n603 VSS.n74 3.33079
R2963 VSS.n602 VSS.n74 3.33079
R2964 VSS.n601 VSS.n74 3.33079
R2965 VSS.t764 VSS.n600 0.0863258
R2966 VSS.n664 VSS.t72 3.33079
R2967 VSS.t72 VSS.n668 3.33087
R2968 VSS.t72 VSS.n667 3.33348
R2969 VSS.n666 VSS.t72 3.33079
R2970 VSS.n665 VSS.t72 3.33079
R2971 VSS.n663 VSS.t72 3.33079
R2972 VSS.n662 VSS.t72 3.33079
R2973 VSS.n661 VSS.t72 3.33079
R2974 VSS.n660 VSS.t72 3.33079
R2975 VSS.n659 VSS.t72 3.33079
R2976 VSS.n658 VSS.t72 3.33079
R2977 VSS.n657 VSS.t72 3.33079
R2978 VSS.t72 VSS.n670 3.33079
R2979 VSS.t72 VSS.n672 3.33087
R2980 VSS.n678 VSS.t72 3.33079
R2981 VSS.t72 VSS.n679 3.33079
R2982 VSS.t11 VSS.n718 3.33079
R2983 VSS.n164 VSS.t11 3.30696
R2984 VSS.n215 VSS.t11 2.72098
R2985 VSS.n105 VSS.t11 0.85581
R2986 VSS.n257 VSS.t11 3.30688
R2987 VSS.n176 VSS.t11 1.97603
R2988 VSS.t11 VSS.n714 3.33079
R2989 VSS.t11 VSS.n713 3.33079
R2990 VSS.t11 VSS.n712 3.33079
R2991 VSS.t11 VSS.n711 3.33079
R2992 VSS.t11 VSS.n710 3.33079
R2993 VSS.t11 VSS.n709 3.33079
R2994 VSS.t11 VSS.n708 3.33079
R2995 VSS.t11 VSS.n707 3.33079
R2996 VSS.t11 VSS.n706 3.33079
R2997 VSS.t11 VSS.n705 3.33079
R2998 VSS.t11 VSS.n704 3.33079
R2999 VSS.t11 VSS.n703 3.33079
R3000 VSS.t11 VSS.n702 3.33079
R3001 VSS.t11 VSS.n701 3.33079
R3002 VSS.n717 VSS.t11 3.33079
R3003 VSS.t448 VSS.n722 0.0863258
R3004 VSS.t385 VSS.n720 0.0863258
R3005 VSS.t3262 VSS.n110 16.952
R3006 VSS.n760 VSS.t3202 4.29849
R3007 VSS.t31 VSS.n938 4.28621
R3008 VSS.n774 VSS.t110 4.28621
R3009 VSS.n891 VSS.t40 4.28621
R3010 VSS.n883 VSS.t3246 4.28621
R3011 VSS.n202 VSS.t198 2.74026
R3012 VSS.t72 VSS.t3183 4.251
R3013 VSS.n715 VSS.t11 3.36082
R3014 VSS.t11 VSS.t93 4.2505
R3015 VSS.t72 VSS.n675 2.74175
R3016 VSS.t159 VSS.n766 3.50108
R3017 VSS.n766 VSS.t92 3.50108
R3018 VSS.n186 VSS.t138 0.331253
R3019 VSS.t72 VSS.n656 2.31585
R3020 VSS.t72 VSS.n676 2.31585
R3021 VSS.t72 VSS.n674 2.31585
R3022 VSS.t72 VSS.n673 2.31585
R3023 VSS.t72 VSS.n695 2.31585
R3024 VSS.t72 VSS.n694 2.31585
R3025 VSS.t72 VSS.n693 2.31585
R3026 VSS.t72 VSS.n692 2.31585
R3027 VSS.t72 VSS.n691 2.31585
R3028 VSS.t72 VSS.n690 2.31585
R3029 VSS.t72 VSS.n689 2.31585
R3030 VSS.t72 VSS.n688 2.31585
R3031 VSS.t72 VSS.n687 2.31585
R3032 VSS.t72 VSS.n686 2.31585
R3033 VSS.t72 VSS.n685 2.31585
R3034 VSS.t72 VSS.n684 2.31585
R3035 VSS.t72 VSS.n683 2.31585
R3036 VSS.t72 VSS.n682 2.31585
R3037 VSS.t72 VSS.n681 2.31585
R3038 VSS.n271 VSS.t72 1.74963
R3039 VSS.t728 VSS.n680 0.0923917
R3040 VSS.n852 VSS.t75 2.72109
R3041 VSS.t3184 VSS.n317 72.8451
R3042 VSS.n858 VSS.t75 2.59384
R3043 VSS.n857 VSS.t75 2.59384
R3044 VSS.n854 VSS.t75 2.59384
R3045 VSS.n187 VSS.t75 0.405951
R3046 VSS.t75 VSS.n378 0.405951
R3047 VSS.t75 VSS.n845 2.59384
R3048 VSS.t75 VSS.n846 2.59384
R3049 VSS.n844 VSS.t75 2.29778
R3050 VSS.t11 VSS.n766 1.88939
R3051 VSS.t18 VSS.t9 1.37665
R3052 VSS.n105 VSS.t42 0.0560059
R3053 VSS.n129 VSS.t184 0.380447
R3054 VSS.t11 VSS.n203 0.99289
R3055 VSS.t121 VSS.n721 0.0822487
R3056 VSS.n697 VSS.t35 0.082792
R3057 VSS.n671 VSS.t573 0.083181
R3058 VSS.n106 VSS.t11 0.854305
R3059 VSS.t351 VSS.t59 1.17344
R3060 VSS.t37 VSS.n128 0.0268837
R3061 VSS.n379 VSS.t291 0.0329209
R3062 VSS.n385 VSS.t322 0.94915
R3063 VSS.t279 VSS.t283 1.1131
R3064 VSS.n849 VSS.t155 1.10319
R3065 VSS.t227 VSS.t355 1.08659
R3066 VSS.t3 VSS.t373 1.08583
R3067 VSS.t72 VSS.n120 0.893546
R3068 VSS.t269 VSS.t274 1.01774
R3069 VSS.n175 VSS.t13 1.14113
R3070 VSS.t291 VSS.t286 1.01465
R3071 VSS.n389 VSS.t236 1.06044
R3072 VSS.n170 VSS.t172 0.0725222
R3073 VSS.t201 VSS.t172 1.00316
R3074 VSS.t227 VSS.t366 0.975846
R3075 VSS.n677 VSS.t72 0.808749
R3076 VSS.n698 VSS.t21 0.819475
R3077 VSS.t269 VSS.n318 0.845789
R3078 VSS.n716 VSS.t129 1.00103
R3079 VSS.t1 VSS.t39 0.876684
R3080 VSS.n129 VSS.t39 0.229787
R3081 VSS.t274 VSS.t279 0.841646
R3082 VSS.t4 VSS.t64 0.829229
R3083 VSS.t75 VSS.t370 0.815996
R3084 VSS.t351 VSS.t355 0.807755
R3085 VSS.t23 VSS.t145 0.806182
R3086 VSS.n677 VSS.t23 0.0757059
R3087 VSS.t11 VSS.n170 0.604816
R3088 VSS.t573 VSS.t135 0.716723
R3089 VSS.t132 VSS.t35 0.714038
R3090 VSS.t87 VSS.n671 0.581374
R3091 VSS.t501 VSS.t503 0.708889
R3092 VSS.n697 VSS.t30 0.578618
R3093 VSS.n849 VSS.t59 0.698053
R3094 VSS.n721 VSS.t119 0.570079
R3095 VSS.n203 VSS.t394 0.0815508
R3096 VSS.t11 VSS.n716 0.574293
R3097 VSS.t72 VSS.n26 0.666899
R3098 VSS.n924 VSS.t72 0.666899
R3099 VSS.t11 VSS.n100 0.666899
R3100 VSS.t11 VSS.n102 0.666899
R3101 VSS.t11 VSS.n103 0.666899
R3102 VSS.t11 VSS.n82 0.666899
R3103 VSS.t11 VSS.n84 0.666899
R3104 VSS.n953 VSS.n724 0.66578
R3105 VSS.n730 VSS.n724 0.66578
R3106 VSS.n840 VSS.n730 0.66578
R3107 VSS.n840 VSS.n837 0.66578
R3108 VSS.n913 VSS.n837 0.66578
R3109 VSS.n914 VSS.n913 0.66578
R3110 VSS.n914 VSS.n731 0.66578
R3111 VSS.n944 VSS.n731 0.66578
R3112 VSS.n948 VSS.n947 0.66578
R3113 VSS.n947 VSS.n728 0.66578
R3114 VSS.n908 VSS.n728 0.66578
R3115 VSS.n908 VSS.n907 0.66578
R3116 VSS.n907 VSS.n904 0.66578
R3117 VSS.n904 VSS.n903 0.66578
R3118 VSS.n903 VSS.n902 0.66578
R3119 VSS.n950 VSS.n727 0.66578
R3120 VSS.n842 VSS.n727 0.66578
R3121 VSS.n843 VSS.n842 0.66578
R3122 VSS.n843 VSS.n835 0.66578
R3123 VSS.n916 VSS.n835 0.66578
R3124 VSS.n917 VSS.n916 0.66578
R3125 VSS.n917 VSS.n834 0.66578
R3126 VSS.n951 VSS.n725 0.66578
R3127 VSS.n838 VSS.n725 0.66578
R3128 VSS.n911 VSS.n838 0.66578
R3129 VSS.n912 VSS.n911 0.66578
R3130 VSS.n912 VSS.n783 0.66578
R3131 VSS.n936 VSS.n783 0.66578
R3132 VSS.n937 VSS.n936 0.66578
R3133 VSS.n869 VSS.t11 0.655024
R3134 VSS.t11 VSS.n99 0.655024
R3135 VSS.t72 VSS.n3 0.649813
R3136 VSS.t72 VSS.n2 0.649813
R3137 VSS.t72 VSS.n1 0.649813
R3138 VSS.t72 VSS.n25 0.649813
R3139 VSS.n926 VSS.t72 0.649813
R3140 VSS.t72 VSS.n0 9.30147
R3141 VSS.t72 VSS.n7 0.649813
R3142 VSS.t72 VSS.n8 0.649813
R3143 VSS.t72 VSS.n9 0.649813
R3144 VSS.t72 VSS.n12 0.649813
R3145 VSS.t72 VSS.n13 0.649813
R3146 VSS.t72 VSS.n11 0.649813
R3147 VSS.t72 VSS.n10 0.649813
R3148 VSS.t72 VSS.n24 0.649813
R3149 VSS.n807 VSS.t72 0.649813
R3150 VSS.t72 VSS.n4 0.649813
R3151 VSS.t72 VSS.n6 0.649813
R3152 VSS.t72 VSS.n5 0.649813
R3153 VSS.n111 VSS.t759 243.139
R3154 VSS.t72 VSS.n27 0.649813
R3155 VSS.t72 VSS.n28 0.649813
R3156 VSS.t72 VSS.n29 0.649813
R3157 VSS.t72 VSS.n39 0.649813
R3158 VSS.t72 VSS.n38 0.649813
R3159 VSS.t72 VSS.n40 0.649813
R3160 VSS.t72 VSS.n41 0.649813
R3161 VSS.t72 VSS.n44 0.649813
R3162 VSS.t72 VSS.n45 0.649813
R3163 VSS.t72 VSS.n43 0.649813
R3164 VSS.t72 VSS.n42 0.649813
R3165 VSS.t72 VSS.n36 0.649813
R3166 VSS.t72 VSS.n37 0.649813
R3167 VSS.t72 VSS.n35 0.649813
R3168 VSS.t72 VSS.n34 0.649813
R3169 VSS.t72 VSS.n31 0.649813
R3170 VSS.t72 VSS.n30 0.649813
R3171 VSS.t72 VSS.n32 0.649813
R3172 VSS.t72 VSS.n33 0.649813
R3173 VSS.t72 VSS.n17 0.649813
R3174 VSS.t72 VSS.n16 0.649813
R3175 VSS.t72 VSS.n18 0.649813
R3176 VSS.t72 VSS.n19 0.649813
R3177 VSS.t72 VSS.n22 0.649813
R3178 VSS.t72 VSS.n23 0.649813
R3179 VSS.t72 VSS.n21 0.649813
R3180 VSS.t72 VSS.n20 0.649813
R3181 VSS.t72 VSS.n14 0.649813
R3182 VSS.t72 VSS.n15 0.649813
R3183 VSS.n823 VSS.t72 0.649813
R3184 VSS.t11 VSS.n98 0.649813
R3185 VSS.t11 VSS.n95 0.649813
R3186 VSS.t11 VSS.n97 0.649813
R3187 VSS.t11 VSS.n96 0.649813
R3188 VSS.n156 VSS.t24 320.269
R3189 VSS.n875 VSS.t11 0.649813
R3190 VSS.n877 VSS.t11 0.649813
R3191 VSS.n878 VSS.t11 0.649813
R3192 VSS.n893 VSS.t11 0.649813
R3193 VSS.t11 VSS.n85 0.649813
R3194 VSS.t11 VSS.n83 0.649813
R3195 VSS.n868 VSS.t11 0.648101
R3196 VSS.t11 VSS.n101 0.648101
R3197 VSS.t11 VSS.n104 0.648101
R3198 VSS.t11 VSS.n94 0.648101
R3199 VSS.t11 VSS.n93 0.648101
R3200 VSS.t11 VSS.n86 0.648101
R3201 VSS.t11 VSS.n92 0.648101
R3202 VSS.t11 VSS.n91 0.648101
R3203 VSS.t11 VSS.n90 0.648101
R3204 VSS.t11 VSS.n87 0.648101
R3205 VSS.t11 VSS.n88 0.648101
R3206 VSS.t11 VSS.n89 0.648101
R3207 VSS.n942 VSS.t11 0.648101
R3208 VSS.n318 VSS.t75 0.532065
R3209 VSS.t366 VSS.t370 0.626987
R3210 VSS.n233 VSS.t576 0.575462
R3211 VSS.t283 VSS.t286 0.611475
R3212 VSS.t698 VSS.n233 0.571832
R3213 VSS.t121 VSS.t187 0.600657
R3214 VSS.t75 VSS.n849 0.594402
R3215 VSS.t13 VSS.n698 1.01616
R3216 VSS.n389 VSS.t75 0.480953
R3217 VSS.t75 VSS.t283 0.508724
R3218 VSS.t394 VSS.t132 0.489392
R3219 VSS.t370 VSS.t373 0.453971
R3220 VSS.t16 VSS.n844 0.452661
R3221 VSS.t83 VSS.n385 1.13923
R3222 VSS.n147 VSS.t75 0.219075
R3223 VSS.t75 VSS.n71 0.405951
R3224 VSS.t75 VSS.n60 0.405951
R3225 VSS.n80 VSS.t271 47.2102
R3226 VSS.n79 VSS.t276 47.2102
R3227 VSS.t75 VSS.n61 0.405951
R3228 VSS.t75 VSS.n68 0.219018
R3229 VSS.t75 VSS.n66 0.219018
R3230 VSS.t75 VSS.n62 0.22519
R3231 VSS.t75 VSS.n64 0.405951
R3232 VSS.t75 VSS.n63 0.219075
R3233 VSS.n127 VSS.t298 47.2102
R3234 VSS.t75 VSS.n59 0.121827
R3235 VSS.n130 VSS.t75 0.121827
R3236 VSS.n861 VSS.t75 0.405951
R3237 VSS.n859 VSS.t75 0.405951
R3238 VSS.n855 VSS.t75 0.405951
R3239 VSS.n853 VSS.t75 0.405951
R3240 VSS.n138 VSS.t75 0.219019
R3241 VSS.t75 VSS.n47 0.225187
R3242 VSS.t75 VSS.n48 0.405951
R3243 VSS.t75 VSS.n49 0.405951
R3244 VSS.t75 VSS.n58 0.405951
R3245 VSS.t75 VSS.n57 0.405951
R3246 VSS.t75 VSS.n56 0.203701
R3247 VSS.t75 VSS.n55 0.405951
R3248 VSS.n114 VSS.t349 47.2102
R3249 VSS.t75 VSS.n54 0.121828
R3250 VSS.t75 VSS.n53 0.121828
R3251 VSS.n117 VSS.t361 26.1052
R3252 VSS.t75 VSS.n52 0.405951
R3253 VSS.n119 VSS.t364 47.2102
R3254 VSS.n121 VSS.t372 26.1053
R3255 VSS.t75 VSS.n51 0.405951
R3256 VSS.t75 VSS.n50 0.219073
R3257 VSS.n852 VSS.t7 0.396535
R3258 VSS.n182 VSS.t2748 0.175714
R3259 VSS.t2742 VSS.n192 0.175714
R3260 VSS.t2677 VSS.t2678 0.36115
R3261 VSS.t2672 VSS.t2673 0.36115
R3262 VSS.t2811 VSS.n220 0.175714
R3263 VSS.t2662 VSS.n219 0.175714
R3264 VSS.t2657 VSS.n200 0.175714
R3265 VSS.t2652 VSS.t2653 0.36115
R3266 VSS.t2647 VSS.t2648 0.36115
R3267 VSS.t2635 VSS.n161 0.175714
R3268 VSS.t2701 VSS.t2702 0.36115
R3269 VSS.t2713 VSS.n196 0.175714
R3270 VSS.t2719 VSS.n226 0.175714
R3271 VSS.t2725 VSS.t2726 0.36115
R3272 VSS.t2730 VSS.t2731 0.36115
R3273 VSS.t2735 VSS.t2736 0.36115
R3274 VSS.t2628 VSS.n169 0.175714
R3275 VSS.t2640 VSS.t2641 0.36115
R3276 VSS.t2684 VSS.t2685 0.360811
R3277 VSS.t2690 VSS.t2691 0.360811
R3278 VSS.t2696 VSS.n197 0.175554
R3279 VSS.t2702 VSS.n224 0.175554
R3280 VSS.t2714 VSS.t2715 0.360811
R3281 VSS.t2720 VSS.t2721 0.360811
R3282 VSS.t1218 VSS.t1217 0.360811
R3283 VSS.t1222 VSS.t1220 0.360811
R3284 VSS.t1228 VSS.n240 0.175554
R3285 VSS.t1318 VSS.t1317 0.360811
R3286 VSS.n239 VSS.t1306 0.175554
R3287 VSS.n105 VSS.t5 0.288845
R3288 VSS.t2747 VSS.t2746 0.360811
R3289 VSS.t2739 VSS.t2740 0.360811
R3290 VSS.t2734 VSS.n228 0.175554
R3291 VSS.t2729 VSS.n227 0.175554
R3292 VSS.t2724 VSS.n195 0.175554
R3293 VSS.t2718 VSS.t2719 0.360811
R3294 VSS.t2694 VSS.t2693 0.360811
R3295 VSS.t2688 VSS.t2687 0.360811
R3296 VSS.t2682 VSS.t2681 0.360811
R3297 VSS.n221 VSS.t2676 0.175554
R3298 VSS.n199 VSS.t2671 0.175554
R3299 VSS.t2623 VSS.n193 0.175554
R3300 VSS.t2662 VSS.t2661 0.360811
R3301 VSS.t2654 VSS.t2655 0.360811
R3302 VSS.t2649 VSS.t2650 0.360811
R3303 VSS.t2644 VSS.t2645 0.360811
R3304 VSS.t2639 VSS.n216 0.175554
R3305 VSS.t2632 VSS.t2633 0.360811
R3306 VSS.t1229 VSS.t1228 0.360471
R3307 VSS.t1307 VSS.t1306 0.360471
R3308 VSS.n215 VSS.t3226 0.175395
R3309 VSS.t2743 VSS.t2744 0.360471
R3310 VSS.t2738 VSS.n194 0.175395
R3311 VSS.t2733 VSS.t2734 0.360471
R3312 VSS.t2728 VSS.t2729 0.360471
R3313 VSS.t2709 VSS.t2711 0.360471
R3314 VSS.t2703 VSS.t2705 0.360471
R3315 VSS.t2697 VSS.t2699 0.360471
R3316 VSS.t2691 VSS.n223 0.175395
R3317 VSS.t2685 VSS.n222 0.175395
R3318 VSS.t2680 VSS.n198 0.175395
R3319 VSS.t2675 VSS.t2676 0.360471
R3320 VSS.t2668 VSS.t2669 0.360471
R3321 VSS.t2663 VSS.t2664 0.360471
R3322 VSS.t2658 VSS.t2659 0.360471
R3323 VSS.t2653 VSS.n218 0.175395
R3324 VSS.t2648 VSS.n217 0.175395
R3325 VSS.t2643 VSS.n201 0.175395
R3326 VSS.t2638 VSS.t2639 0.360471
R3327 VSS.t2631 VSS.t2632 0.360471
R3328 VSS.t2624 VSS.t2626 0.360471
R3329 VSS.t2620 VSS.t2621 0.360471
R3330 VSS.t713 VSS.t590 0.344562
R3331 VSS.n656 VSS.t209 0.436369
R3332 VSS.n271 VSS.t209 0.328762
R3333 VSS.t632 VSS.n694 0.433869
R3334 VSS.t629 VSS.n693 0.433869
R3335 VSS.t626 VSS.n692 0.433869
R3336 VSS.t623 VSS.n691 0.433869
R3337 VSS.t620 VSS.n690 0.433869
R3338 VSS.t617 VSS.n689 0.433869
R3339 VSS.t614 VSS.n688 0.433869
R3340 VSS.t611 VSS.n687 0.433869
R3341 VSS.t608 VSS.n686 0.433869
R3342 VSS.t605 VSS.n685 0.433869
R3343 VSS.t602 VSS.n684 0.433869
R3344 VSS.t599 VSS.n683 0.433869
R3345 VSS.t596 VSS.n682 0.433869
R3346 VSS.t583 VSS.n674 0.433869
R3347 VSS.t580 VSS.n673 0.433869
R3348 VSS.t728 VSS.t180 0.341746
R3349 VSS.t135 VSS.n186 0.328435
R3350 VSS.t83 VSS.n852 0.338658
R3351 VSS.t147 VSS.n680 0.23595
R3352 VSS.n681 VSS.t593 0.433869
R3353 VSS.n676 VSS.t713 0.0923073
R3354 VSS.t635 VSS.n695 0.422619
R3355 VSS.t2771 VSS.n202 0.15275
R3356 VSS.n325 VSS.t2902 0.0850573
R3357 VSS.t2841 VSS.n225 0.17801
R3358 VSS.t2727 VSS.t2728 0.301114
R3359 VSS.t2732 VSS.t2733 0.301114
R3360 VSS.t2737 VSS.t2738 0.301114
R3361 VSS.t1162 VSS.n294 0.420219
R3362 VSS.t1172 VSS.t1173 0.301114
R3363 VSS.t1180 VSS.t1181 0.301114
R3364 VSS.t1214 VSS.n295 0.232176
R3365 VSS.t1226 VSS.n241 0.478624
R3366 VSS.t1269 VSS.t1270 0.301114
R3367 VSS.t1266 VSS.t1267 0.301114
R3368 VSS.t1254 VSS.n279 0.118323
R3369 VSS.t1185 VSS.n284 0.118323
R3370 VSS.t1177 VSS.n287 0.118323
R3371 VSS.t1169 VSS.n290 0.118323
R3372 VSS.t2694 VSS.n309 0.118323
R3373 VSS.t2688 VSS.n310 0.118323
R3374 VSS.t2682 VSS.n248 0.118323
R3375 VSS.t2779 VSS.n229 0.17801
R3376 VSS.t2786 VSS.t2638 0.301114
R3377 VSS.t2642 VSS.t2643 0.301114
R3378 VSS.t2621 VSS.n242 0.118323
R3379 VSS.t1211 VSS.n567 0.118323
R3380 VSS.t1217 VSS.n283 0.118323
R3381 VSS.t1247 VSS.n573 0.118323
R3382 VSS.t5 VSS.n899 0.301114
R3383 VSS.t2683 VSS.t2684 0.301114
R3384 VSS.t2689 VSS.t2690 0.301114
R3385 VSS.t2695 VSS.t2696 0.301114
R3386 VSS.n162 VSS.t1157 0.17801
R3387 VSS.t2740 VSS.n252 0.118323
R3388 VSS.t1165 VSS.t1164 0.301114
R3389 VSS.t1170 VSS.t1171 0.301114
R3390 VSS.t1178 VSS.t1179 0.301114
R3391 VSS.t1186 VSS.t1187 0.301114
R3392 VSS.t1198 VSS.t1199 0.301114
R3393 VSS.t1230 VSS.t1229 0.301114
R3394 VSS.t1233 VSS.t1232 0.301114
R3395 VSS.t1236 VSS.t1235 0.301114
R3396 VSS.t1239 VSS.t1238 0.301114
R3397 VSS.t1242 VSS.t1241 0.301114
R3398 VSS.n590 VSS.t1319 0.17801
R3399 VSS.t1314 VSS.t1315 0.301114
R3400 VSS.n211 VSS.t1311 0.17801
R3401 VSS.t1307 VSS.t1308 0.301114
R3402 VSS.t1303 VSS.t1304 0.301114
R3403 VSS.t1300 VSS.n587 0.17801
R3404 VSS.t1294 VSS.n585 0.17801
R3405 VSS.n584 VSS.t1292 0.118323
R3406 VSS.n276 VSS.t1288 0.17801
R3407 VSS.t1284 VSS.t1285 0.301114
R3408 VSS.n209 VSS.t1281 0.17801
R3409 VSS.t1273 VSS.n581 0.17801
R3410 VSS.n580 VSS.t1271 0.118323
R3411 VSS.t1261 VSS.n577 0.17801
R3412 VSS.n257 VSS.t3221 0.118323
R3413 VSS.t3226 VSS.t123 0.301114
R3414 VSS.n238 VSS.t1207 0.17801
R3415 VSS.t1194 VSS.t1193 0.301114
R3416 VSS.t2770 VSS.t2769 0.301114
R3417 VSS.t2761 VSS.n394 0.118323
R3418 VSS.t2752 VSS.n393 0.118323
R3419 VSS.t2745 VSS.n253 0.17801
R3420 VSS.n307 VSS.t2711 0.118323
R3421 VSS.n308 VSS.t2705 0.118323
R3422 VSS.n249 VSS.t2699 0.118323
R3423 VSS.t2679 VSS.t2680 0.301114
R3424 VSS.t2674 VSS.t2675 0.301114
R3425 VSS.t2669 VSS.n312 0.118323
R3426 VSS.t2622 VSS.t2623 0.301114
R3427 VSS.t2664 VSS.n313 0.118323
R3428 VSS.n244 VSS.t2634 0.17801
R3429 VSS.t2645 VSS.n245 0.118323
R3430 VSS.t2650 VSS.n315 0.118323
R3431 VSS.t2655 VSS.n314 0.118323
R3432 VSS.t2659 VSS.n246 0.118323
R3433 VSS.t2627 VSS.n243 0.17801
R3434 VSS.t2726 VSS.n251 0.118193
R3435 VSS.t2731 VSS.n305 0.118193
R3436 VSS.t2736 VSS.n304 0.118193
R3437 VSS.t2673 VSS.n247 0.118193
R3438 VSS.t2678 VSS.n311 0.118193
R3439 VSS.t2715 VSS.n250 0.118193
R3440 VSS.t2721 VSS.n306 0.118193
R3441 VSS.t1159 VSS.t1158 0.300775
R3442 VSS.n293 VSS.t1162 0.118193
R3443 VSS.n292 VSS.t1165 0.118193
R3444 VSS.t1171 VSS.n289 0.118193
R3445 VSS.t1179 VSS.n286 0.118193
R3446 VSS.t1187 VSS.n172 0.118193
R3447 VSS.t1199 VSS.t1200 0.300775
R3448 VSS.t1225 VSS.t1223 0.300775
R3449 VSS.t1173 VSS.t1174 0.300775
R3450 VSS.t1181 VSS.t1182 0.300775
R3451 VSS.t1212 VSS.t1211 0.300775
R3452 VSS.t1216 VSS.t1214 0.300775
R3453 VSS.t1219 VSS.t1218 0.300775
R3454 VSS.t1220 VSS.n568 0.118193
R3455 VSS.t1232 VSS.t1231 0.300775
R3456 VSS.t1235 VSS.t1234 0.300775
R3457 VSS.t1238 VSS.t1237 0.300775
R3458 VSS.t1243 VSS.n282 0.177814
R3459 VSS.t1248 VSS.t1247 0.300775
R3460 VSS.t1252 VSS.t1251 0.300775
R3461 VSS.t1316 VSS.t1317 0.300775
R3462 VSS.t1313 VSS.t1314 0.300775
R3463 VSS.t1310 VSS.t1309 0.300775
R3464 VSS.t1301 VSS.t1431 0.300775
R3465 VSS.t1295 VSS.t1426 0.300775
R3466 VSS.t1292 VSS.t1423 0.300775
R3467 VSS.t1286 VSS.t1287 0.300775
R3468 VSS.t1283 VSS.t1284 0.300775
R3469 VSS.t1280 VSS.t1279 0.300775
R3470 VSS.t1274 VSS.t1409 0.300775
R3471 VSS.t1271 VSS.t1406 0.300775
R3472 VSS.t1269 VSS.t1268 0.300775
R3473 VSS.t1266 VSS.t1265 0.300775
R3474 VSS.t1262 VSS.t1399 0.300775
R3475 VSS.t65 VSS.n176 0.346587
R3476 VSS.t3221 VSS.t65 0.300775
R3477 VSS.n175 VSS.t162 0.985338
R3478 VSS.t52 VSS.n164 0.118193
R3479 VSS.t1205 VSS.t1206 0.300775
R3480 VSS.t1192 VSS.t1193 0.300775
R3481 VSS.t1184 VSS.t1185 0.300775
R3482 VSS.t1176 VSS.t1177 0.300775
R3483 VSS.t1168 VSS.t1169 0.300775
R3484 VSS.t2752 VSS.t2753 0.300775
R3485 VSS.t2761 VSS.t2762 0.300775
R3486 VSS.t2745 VSS.t2746 0.300775
R3487 VSS.t2741 VSS.t2742 0.300775
R3488 VSS.t2723 VSS.t2724 0.300775
R3489 VSS.t2717 VSS.t2718 0.300775
R3490 VSS.t2712 VSS.t2713 0.300775
R3491 VSS.t2706 VSS.t2707 0.300775
R3492 VSS.t2700 VSS.t2701 0.300775
R3493 VSS.t2670 VSS.t2671 0.300775
R3494 VSS.t2641 VSS.n316 0.118193
R3495 VSS.t2636 VSS.t2637 0.300775
R3496 VSS.t2660 VSS.t2661 0.300775
R3497 VSS.t2656 VSS.t2657 0.300775
R3498 VSS.t2651 VSS.t2652 0.300775
R3499 VSS.t2646 VSS.t2647 0.300775
R3500 VSS.t2634 VSS.t2635 0.300775
R3501 VSS.t2627 VSS.t2628 0.300775
R3502 VSS.t2665 VSS.t2666 0.300775
R3503 VSS.t75 VSS.n379 0.242614
R3504 VSS.t586 VSS.n675 0.379757
R3505 VSS.n321 VSS.t199 0.160265
R3506 VSS.t1328 VSS.t1167 0.241078
R3507 VSS.t1335 VSS.t1175 0.241078
R3508 VSS.t1342 VSS.t1183 0.241078
R3509 VSS.t1188 VSS.t1189 0.241078
R3510 VSS.n592 VSS.t1198 0.119605
R3511 VSS.n189 VSS.t1201 0.119605
R3512 VSS.t1250 VSS.n574 0.360183
R3513 VSS.t1223 VSS.n204 0.291785
R3514 VSS.t1396 VSS.t1261 0.241078
R3515 VSS.t1399 VSS.t1264 0.241078
R3516 VSS.t1406 VSS.t1273 0.241078
R3517 VSS.n278 VSS.t1276 0.119605
R3518 VSS.t1420 VSS.t1291 0.241078
R3519 VSS.t1423 VSS.t1294 0.241078
R3520 VSS.t1426 VSS.t1297 0.241078
R3521 VSS.n179 VSS.t1299 0.119605
R3522 VSS.t1299 VSS.t1300 0.241078
R3523 VSS.n275 VSS.t1303 0.119605
R3524 VSS.n899 VSS.t103 0.241078
R3525 VSS.n700 VSS.t201 0.119605
R3526 VSS.t2871 VSS.t2750 0.241078
R3527 VSS.t2765 VSS.t2764 0.241078
R3528 VSS.t2756 VSS.t2755 0.241078
R3529 VSS.n164 VSS.t162 0.418392
R3530 VSS.n294 VSS.t1161 0.119605
R3531 VSS.t1157 VSS.t1156 0.241078
R3532 VSS.t1160 VSS.n596 0.119605
R3533 VSS.t1161 VSS.t1160 0.241078
R3534 VSS.t1167 VSS.n291 0.119605
R3535 VSS.t1175 VSS.n288 0.119605
R3536 VSS.t1183 VSS.n285 0.119605
R3537 VSS.n214 VSS.t1190 0.119605
R3538 VSS.t1201 VSS.t1202 0.241078
R3539 VSS.n574 VSS.t1249 0.119605
R3540 VSS.t1213 VSS.t1212 0.241078
R3541 VSS.t1231 VSS.n569 0.119605
R3542 VSS.t1234 VSS.n570 0.119605
R3543 VSS.t1237 VSS.n571 0.119605
R3544 VSS.t1240 VSS.n572 0.119605
R3545 VSS.t1241 VSS.t1240 0.241078
R3546 VSS.t1244 VSS.t1243 0.241078
R3547 VSS.t1245 VSS.n208 0.119605
R3548 VSS.t1246 VSS.t1245 0.241078
R3549 VSS.t1249 VSS.t1248 0.241078
R3550 VSS.n281 VSS.t1250 0.119605
R3551 VSS.t1255 VSS.t1256 0.241078
R3552 VSS.n578 VSS.t1265 0.119605
R3553 VSS.n579 VSS.t1268 0.119605
R3554 VSS.t1276 VSS.t1277 0.241078
R3555 VSS.t1315 VSS.n274 0.119605
R3556 VSS.n589 VSS.t1313 0.119605
R3557 VSS.t1311 VSS.t1312 0.241078
R3558 VSS.n588 VSS.t1309 0.119605
R3559 VSS.n210 VSS.t1420 0.119605
R3560 VSS.t1289 VSS.t1290 0.241078
R3561 VSS.t1288 VSS.t1289 0.241078
R3562 VSS.t1285 VSS.n277 0.119605
R3563 VSS.n583 VSS.t1283 0.119605
R3564 VSS.t1281 VSS.t1282 0.241078
R3565 VSS.t1277 VSS.t1278 0.241078
R3566 VSS.n582 VSS.t1279 0.119605
R3567 VSS.t1260 VSS.t1396 0.241078
R3568 VSS.n576 VSS.t1260 0.119605
R3569 VSS.t1258 VSS.t1259 0.241078
R3570 VSS.t1256 VSS.t1257 0.241078
R3571 VSS.t1257 VSS.n575 0.119605
R3572 VSS.n258 VSS.t467 0.119605
R3573 VSS.t142 VSS.t19 0.241078
R3574 VSS.t1207 VSS.t1208 0.241078
R3575 VSS.n591 VSS.t1205 0.119605
R3576 VSS.n212 VSS.t1203 0.119605
R3577 VSS.t1203 VSS.t1204 0.241078
R3578 VSS.t1197 VSS.t1353 0.241078
R3579 VSS.n213 VSS.t1197 0.119605
R3580 VSS.t1195 VSS.t1196 0.241078
R3581 VSS.n190 VSS.t1195 0.119605
R3582 VSS.t1190 VSS.t1191 0.241078
R3583 VSS.n593 VSS.t1192 0.119605
R3584 VSS.n594 VSS.t1342 0.119605
R3585 VSS.n595 VSS.t1335 0.119605
R3586 VSS.n297 VSS.t2755 0.235599
R3587 VSS.n296 VSS.t2764 0.235599
R3588 VSS.n395 VSS.t2769 0.119605
R3589 VSS.t2767 VSS.t2768 0.241078
R3590 VSS.t2765 VSS.t2766 0.241078
R3591 VSS.n206 VSS.t2767 0.119605
R3592 VSS.t2762 VSS.t2763 0.241078
R3593 VSS.t2759 VSS.t2760 0.241078
R3594 VSS.n205 VSS.t2759 0.119605
R3595 VSS.n188 VSS.t2757 0.119605
R3596 VSS.t2757 VSS.t2758 0.241078
R3597 VSS.t2753 VSS.t2754 0.241078
R3598 VSS.n396 VSS.t2786 0.119605
R3599 VSS.n180 VSS.t2708 0.179761
R3600 VSS.n280 VSS.t1252 0.0600369
R3601 VSS.t1254 VSS.n598 0.240486
R3602 VSS.n844 VSS.t155 0.232128
R3603 VSS.t3207 VSS.n215 0.40572
R3604 VSS.t75 VSS.t351 0.228622
R3605 VSS.n723 VSS.t265 0.135296
R3606 VSS.t338 VSS.n390 0.135296
R3607 VSS.t236 VSS.n388 0.135296
R3608 VSS.t330 VSS.n387 0.135296
R3609 VSS.t325 VSS.n386 0.135296
R3610 VSS.t7 VSS.n384 0.135296
R3611 VSS.t316 VSS.n383 0.135296
R3612 VSS.t311 VSS.n382 0.135296
R3613 VSS.t301 VSS.n380 0.135296
R3614 VSS.n392 VSS.t16 0.135296
R3615 VSS.t680 VSS.t682 0.227075
R3616 VSS.t678 VSS.t570 0.227075
R3617 VSS.t2887 VSS.t2889 0.226736
R3618 VSS.t2894 VSS.t2892 0.226736
R3619 VSS.t2897 VSS.t2899 0.226736
R3620 VSS.t3059 VSS.t3057 0.226736
R3621 VSS.t3064 VSS.t3062 0.226736
R3622 VSS.t3069 VSS.t3067 0.226736
R3623 VSS.t3074 VSS.t3072 0.226736
R3624 VSS.t3079 VSS.t3077 0.226736
R3625 VSS.t3084 VSS.t3082 0.226736
R3626 VSS.t3089 VSS.t3087 0.226736
R3627 VSS.t3094 VSS.t3092 0.226736
R3628 VSS.t3099 VSS.t3097 0.226736
R3629 VSS.t3104 VSS.t3102 0.226736
R3630 VSS.t3109 VSS.t3107 0.226736
R3631 VSS.t3114 VSS.t3112 0.226736
R3632 VSS.t3119 VSS.t3117 0.226736
R3633 VSS.t3124 VSS.t3122 0.226736
R3634 VSS.t3132 VSS.t3134 0.226736
R3635 VSS.t3139 VSS.t3137 0.226736
R3636 VSS.t3142 VSS.t3144 0.226736
R3637 VSS.t3149 VSS.t3147 0.226736
R3638 VSS.t3152 VSS.t3154 0.226736
R3639 VSS.t3159 VSS.t3157 0.226736
R3640 VSS.t3162 VSS.t3164 0.226736
R3641 VSS.t2984 VSS.t2982 0.226736
R3642 VSS.t2989 VSS.t2987 0.226736
R3643 VSS.t2994 VSS.t2992 0.226736
R3644 VSS.t2999 VSS.t2997 0.226736
R3645 VSS.t3004 VSS.t3002 0.226736
R3646 VSS.t3009 VSS.t3007 0.226736
R3647 VSS.t3014 VSS.t3012 0.226736
R3648 VSS.t3019 VSS.t3017 0.226736
R3649 VSS.t3024 VSS.t3022 0.226736
R3650 VSS.t3029 VSS.t3027 0.226736
R3651 VSS.t3034 VSS.t3032 0.226736
R3652 VSS.t3039 VSS.t3037 0.226736
R3653 VSS.t3044 VSS.t3042 0.226736
R3654 VSS.t3049 VSS.t3047 0.226736
R3655 VSS.t2972 VSS.t2974 0.226736
R3656 VSS.t2967 VSS.t2969 0.226736
R3657 VSS.t2962 VSS.t2964 0.226736
R3658 VSS.t2957 VSS.t2959 0.226736
R3659 VSS.t2952 VSS.t2954 0.226736
R3660 VSS.t2947 VSS.t2949 0.226736
R3661 VSS.t2942 VSS.t2944 0.226736
R3662 VSS.t2937 VSS.t2939 0.226736
R3663 VSS.t2932 VSS.t2934 0.226736
R3664 VSS.t2927 VSS.t2929 0.226736
R3665 VSS.t2922 VSS.t2924 0.226736
R3666 VSS.t2917 VSS.t2919 0.226736
R3667 VSS.t2912 VSS.t2914 0.226736
R3668 VSS.t2909 VSS.t2907 0.226736
R3669 VSS.t2231 VSS.t2229 0.226736
R3670 VSS.t2236 VSS.t2234 0.226736
R3671 VSS.t2241 VSS.t2239 0.226736
R3672 VSS.t2246 VSS.t2244 0.226736
R3673 VSS.t2251 VSS.t2249 0.226736
R3674 VSS.t2256 VSS.t2254 0.226736
R3675 VSS.t2261 VSS.t2259 0.226736
R3676 VSS.t2266 VSS.t2264 0.226736
R3677 VSS.t2271 VSS.t2269 0.226736
R3678 VSS.t2276 VSS.t2274 0.226736
R3679 VSS.t2281 VSS.t2279 0.226736
R3680 VSS.t2286 VSS.t2284 0.226736
R3681 VSS.t2291 VSS.t2289 0.226736
R3682 VSS.t2296 VSS.t2294 0.226736
R3683 VSS.t2301 VSS.t2299 0.226736
R3684 VSS.t2306 VSS.t2304 0.226736
R3685 VSS.t2311 VSS.t2309 0.226736
R3686 VSS.t2316 VSS.t2314 0.226736
R3687 VSS.t2326 VSS.t2324 0.226736
R3688 VSS.t2331 VSS.t2329 0.226736
R3689 VSS.t2336 VSS.t2334 0.226736
R3690 VSS.t2341 VSS.t2339 0.226736
R3691 VSS.t2346 VSS.t2344 0.226736
R3692 VSS.t2351 VSS.t2349 0.226736
R3693 VSS.t2356 VSS.t2354 0.226736
R3694 VSS.t2361 VSS.t2359 0.226736
R3695 VSS.t2366 VSS.t2364 0.226736
R3696 VSS.t2371 VSS.t2369 0.226736
R3697 VSS.t2376 VSS.t2374 0.226736
R3698 VSS.t2381 VSS.t2379 0.226736
R3699 VSS.t2386 VSS.t2384 0.226736
R3700 VSS.t2391 VSS.t2389 0.226736
R3701 VSS.t2399 VSS.t2401 0.226736
R3702 VSS.t2406 VSS.t2404 0.226736
R3703 VSS.t2409 VSS.t2411 0.226736
R3704 VSS.t2416 VSS.t2414 0.226736
R3705 VSS.t2419 VSS.t2421 0.226736
R3706 VSS.t2426 VSS.t2424 0.226736
R3707 VSS.t2429 VSS.t2431 0.226736
R3708 VSS.t2436 VSS.t2434 0.226736
R3709 VSS.t2439 VSS.t2441 0.226736
R3710 VSS.t2446 VSS.t2444 0.226736
R3711 VSS.t2449 VSS.t2451 0.226736
R3712 VSS.t2456 VSS.t2454 0.226736
R3713 VSS.t2459 VSS.t2461 0.226736
R3714 VSS.t2466 VSS.t2464 0.226736
R3715 VSS.t2476 VSS.t2474 0.226736
R3716 VSS.t2479 VSS.t2481 0.226736
R3717 VSS.t2486 VSS.t2484 0.226736
R3718 VSS.t2489 VSS.t2491 0.226736
R3719 VSS.t2496 VSS.t2494 0.226736
R3720 VSS.t2499 VSS.t2501 0.226736
R3721 VSS.t2506 VSS.t2504 0.226736
R3722 VSS.t1839 VSS.t1837 0.226736
R3723 VSS.t1844 VSS.t1842 0.226736
R3724 VSS.t1849 VSS.t1847 0.226736
R3725 VSS.t1854 VSS.t1852 0.226736
R3726 VSS.t1859 VSS.t1857 0.226736
R3727 VSS.t1864 VSS.t1862 0.226736
R3728 VSS.t1869 VSS.t1867 0.226736
R3729 VSS.t1874 VSS.t1872 0.226736
R3730 VSS.t1879 VSS.t1877 0.226736
R3731 VSS.t1884 VSS.t1882 0.226736
R3732 VSS.t1889 VSS.t1887 0.226736
R3733 VSS.t1894 VSS.t1892 0.226736
R3734 VSS.t1899 VSS.t1897 0.226736
R3735 VSS.t1904 VSS.t1902 0.226736
R3736 VSS.t1909 VSS.t1907 0.226736
R3737 VSS.t1914 VSS.t1912 0.226736
R3738 VSS.t1919 VSS.t1917 0.226736
R3739 VSS.t1924 VSS.t1922 0.226736
R3740 VSS.t1934 VSS.t1932 0.226736
R3741 VSS.t1939 VSS.t1937 0.226736
R3742 VSS.t1944 VSS.t1942 0.226736
R3743 VSS.t1949 VSS.t1947 0.226736
R3744 VSS.t1954 VSS.t1952 0.226736
R3745 VSS.t1959 VSS.t1957 0.226736
R3746 VSS.t1964 VSS.t1962 0.226736
R3747 VSS.t1969 VSS.t1967 0.226736
R3748 VSS.t1974 VSS.t1972 0.226736
R3749 VSS.t1979 VSS.t1977 0.226736
R3750 VSS.t1984 VSS.t1982 0.226736
R3751 VSS.t1989 VSS.t1987 0.226736
R3752 VSS.t1994 VSS.t1992 0.226736
R3753 VSS.t1999 VSS.t1997 0.226736
R3754 VSS.t2009 VSS.t2007 0.226736
R3755 VSS.t2014 VSS.t2012 0.226736
R3756 VSS.t2019 VSS.t2017 0.226736
R3757 VSS.t2024 VSS.t2022 0.226736
R3758 VSS.t2029 VSS.t2027 0.226736
R3759 VSS.t2034 VSS.t2032 0.226736
R3760 VSS.t2039 VSS.t2037 0.226736
R3761 VSS.t2044 VSS.t2042 0.226736
R3762 VSS.t2049 VSS.t2047 0.226736
R3763 VSS.t2054 VSS.t2052 0.226736
R3764 VSS.t2059 VSS.t2057 0.226736
R3765 VSS.t2064 VSS.t2062 0.226736
R3766 VSS.t2069 VSS.t2067 0.226736
R3767 VSS.t2074 VSS.t2072 0.226736
R3768 VSS.t2082 VSS.t2084 0.226736
R3769 VSS.t2089 VSS.t2087 0.226736
R3770 VSS.t2092 VSS.t2094 0.226736
R3771 VSS.t2099 VSS.t2097 0.226736
R3772 VSS.t2102 VSS.t2104 0.226736
R3773 VSS.t2109 VSS.t2107 0.226736
R3774 VSS.t2112 VSS.t2114 0.226736
R3775 VSS.t1447 VSS.t1445 0.226736
R3776 VSS.t1452 VSS.t1450 0.226736
R3777 VSS.t1457 VSS.t1455 0.226736
R3778 VSS.t1462 VSS.t1460 0.226736
R3779 VSS.t1467 VSS.t1465 0.226736
R3780 VSS.t1472 VSS.t1470 0.226736
R3781 VSS.t1477 VSS.t1475 0.226736
R3782 VSS.t1482 VSS.t1480 0.226736
R3783 VSS.t1487 VSS.t1485 0.226736
R3784 VSS.t1492 VSS.t1490 0.226736
R3785 VSS.t1497 VSS.t1495 0.226736
R3786 VSS.t1502 VSS.t1500 0.226736
R3787 VSS.t1507 VSS.t1505 0.226736
R3788 VSS.t1512 VSS.t1510 0.226736
R3789 VSS.t1517 VSS.t1515 0.226736
R3790 VSS.t1522 VSS.t1520 0.226736
R3791 VSS.t1527 VSS.t1525 0.226736
R3792 VSS.t1532 VSS.t1530 0.226736
R3793 VSS.t1540 VSS.t1542 0.226736
R3794 VSS.t1547 VSS.t1545 0.226736
R3795 VSS.t1550 VSS.t1552 0.226736
R3796 VSS.t1557 VSS.t1555 0.226736
R3797 VSS.t1560 VSS.t1562 0.226736
R3798 VSS.t1567 VSS.t1565 0.226736
R3799 VSS.t1570 VSS.t1572 0.226736
R3800 VSS.t1577 VSS.t1575 0.226736
R3801 VSS.t1580 VSS.t1582 0.226736
R3802 VSS.t1587 VSS.t1585 0.226736
R3803 VSS.t1590 VSS.t1592 0.226736
R3804 VSS.t1597 VSS.t1595 0.226736
R3805 VSS.t1600 VSS.t1602 0.226736
R3806 VSS.t1607 VSS.t1605 0.226736
R3807 VSS.t1617 VSS.t1615 0.226736
R3808 VSS.t1620 VSS.t1622 0.226736
R3809 VSS.t1627 VSS.t1625 0.226736
R3810 VSS.t1630 VSS.t1632 0.226736
R3811 VSS.t1637 VSS.t1635 0.226736
R3812 VSS.t1640 VSS.t1642 0.226736
R3813 VSS.t1647 VSS.t1645 0.226736
R3814 VSS.t1650 VSS.t1652 0.226736
R3815 VSS.t1657 VSS.t1655 0.226736
R3816 VSS.t1660 VSS.t1662 0.226736
R3817 VSS.t1667 VSS.t1665 0.226736
R3818 VSS.t1670 VSS.t1672 0.226736
R3819 VSS.t1677 VSS.t1675 0.226736
R3820 VSS.t1680 VSS.t1682 0.226736
R3821 VSS.t1690 VSS.t1692 0.226736
R3822 VSS.t1697 VSS.t1695 0.226736
R3823 VSS.t1700 VSS.t1702 0.226736
R3824 VSS.t1707 VSS.t1705 0.226736
R3825 VSS.t1710 VSS.t1712 0.226736
R3826 VSS.t1717 VSS.t1715 0.226736
R3827 VSS.t1720 VSS.t1722 0.226736
R3828 VSS.t766 VSS.t764 0.226736
R3829 VSS.t771 VSS.t769 0.226736
R3830 VSS.t776 VSS.t774 0.226736
R3831 VSS.t781 VSS.t779 0.226736
R3832 VSS.t786 VSS.t784 0.226736
R3833 VSS.t791 VSS.t789 0.226736
R3834 VSS.t796 VSS.t794 0.226736
R3835 VSS.t801 VSS.t799 0.226736
R3836 VSS.t806 VSS.t804 0.226736
R3837 VSS.t811 VSS.t809 0.226736
R3838 VSS.t816 VSS.t814 0.226736
R3839 VSS.t821 VSS.t819 0.226736
R3840 VSS.t826 VSS.t824 0.226736
R3841 VSS.t831 VSS.t829 0.226736
R3842 VSS.t836 VSS.t834 0.226736
R3843 VSS.t841 VSS.t839 0.226736
R3844 VSS.t846 VSS.t844 0.226736
R3845 VSS.t851 VSS.t849 0.226736
R3846 VSS.t861 VSS.t859 0.226736
R3847 VSS.t866 VSS.t864 0.226736
R3848 VSS.t871 VSS.t869 0.226736
R3849 VSS.t876 VSS.t874 0.226736
R3850 VSS.t881 VSS.t879 0.226736
R3851 VSS.t886 VSS.t884 0.226736
R3852 VSS.t891 VSS.t889 0.226736
R3853 VSS.t896 VSS.t894 0.226736
R3854 VSS.t901 VSS.t899 0.226736
R3855 VSS.t906 VSS.t904 0.226736
R3856 VSS.t911 VSS.t909 0.226736
R3857 VSS.t916 VSS.t914 0.226736
R3858 VSS.t921 VSS.t919 0.226736
R3859 VSS.t926 VSS.t924 0.226736
R3860 VSS.t936 VSS.t934 0.226736
R3861 VSS.t941 VSS.t939 0.226736
R3862 VSS.t946 VSS.t944 0.226736
R3863 VSS.t951 VSS.t949 0.226736
R3864 VSS.t956 VSS.t954 0.226736
R3865 VSS.t961 VSS.t959 0.226736
R3866 VSS.t966 VSS.t964 0.226736
R3867 VSS.t971 VSS.t969 0.226736
R3868 VSS.t976 VSS.t974 0.226736
R3869 VSS.t981 VSS.t979 0.226736
R3870 VSS.t986 VSS.t984 0.226736
R3871 VSS.t991 VSS.t989 0.226736
R3872 VSS.t996 VSS.t994 0.226736
R3873 VSS.t1001 VSS.t999 0.226736
R3874 VSS.t1009 VSS.t1011 0.226736
R3875 VSS.t1016 VSS.t1014 0.226736
R3876 VSS.t1019 VSS.t1021 0.226736
R3877 VSS.t1026 VSS.t1024 0.226736
R3878 VSS.t1029 VSS.t1031 0.226736
R3879 VSS.t1036 VSS.t1034 0.226736
R3880 VSS.t1039 VSS.t1041 0.226736
R3881 VSS.t726 VSS.t724 0.226736
R3882 VSS.t719 VSS.t721 0.226736
R3883 VSS.t566 VSS.t568 0.226736
R3884 VSS.t561 VSS.t563 0.226736
R3885 VSS.t523 VSS.t521 0.226736
R3886 VSS.t528 VSS.t526 0.226736
R3887 VSS.t533 VSS.t531 0.226736
R3888 VSS.t538 VSS.t536 0.226736
R3889 VSS.t543 VSS.t541 0.226736
R3890 VSS.t548 VSS.t546 0.226736
R3891 VSS.t553 VSS.t551 0.226736
R3892 VSS.t399 VSS.t400 0.226736
R3893 VSS.t403 VSS.t402 0.226736
R3894 VSS.t406 VSS.t405 0.226736
R3895 VSS.t409 VSS.t408 0.226736
R3896 VSS.t412 VSS.t411 0.226736
R3897 VSS.t415 VSS.t414 0.226736
R3898 VSS.t418 VSS.t417 0.226736
R3899 VSS.t421 VSS.t420 0.226736
R3900 VSS.t424 VSS.t423 0.226736
R3901 VSS.t427 VSS.t426 0.226736
R3902 VSS.t430 VSS.t429 0.226736
R3903 VSS.t433 VSS.t432 0.226736
R3904 VSS.t436 VSS.t435 0.226736
R3905 VSS.t439 VSS.t438 0.226736
R3906 VSS.t442 VSS.t441 0.226736
R3907 VSS.t387 VSS.t385 0.226736
R3908 VSS.t450 VSS.t448 0.226736
R3909 VSS.t455 VSS.t56 0.226736
R3910 VSS.t27 VSS.t25 0.226736
R3911 VSS.t87 VSS.t689 0.226736
R3912 VSS.t578 VSS.t704 0.224575
R3913 VSS.t450 VSS.n128 0.19172
R3914 VSS.n327 VSS.t2912 0.0863258
R3915 VSS.n328 VSS.t2917 0.0863258
R3916 VSS.n329 VSS.t2922 0.0863258
R3917 VSS.n330 VSS.t2927 0.0863258
R3918 VSS.n331 VSS.t2932 0.0863258
R3919 VSS.n332 VSS.t2937 0.0863258
R3920 VSS.n333 VSS.t2942 0.0863258
R3921 VSS.n334 VSS.t2947 0.0863258
R3922 VSS.n335 VSS.t2952 0.0863258
R3923 VSS.n336 VSS.t2957 0.0863258
R3924 VSS.n337 VSS.t2962 0.0863258
R3925 VSS.n338 VSS.t2967 0.0863258
R3926 VSS.n339 VSS.t2972 0.0863258
R3927 VSS.n340 VSS.t2977 0.0863258
R3928 VSS.n371 VSS.t3132 0.0863258
R3929 VSS.n373 VSS.t3142 0.0863258
R3930 VSS.n375 VSS.t3152 0.0863258
R3931 VSS.n377 VSS.t3162 0.0863258
R3932 VSS.t3157 VSS.n376 0.0863258
R3933 VSS.t3147 VSS.n374 0.0863258
R3934 VSS.t3137 VSS.n372 0.0863258
R3935 VSS.t3122 VSS.n369 0.0863258
R3936 VSS.t2982 VSS.n341 0.0863258
R3937 VSS.t2987 VSS.n342 0.0863258
R3938 VSS.t2992 VSS.n343 0.0863258
R3939 VSS.t2997 VSS.n344 0.0863258
R3940 VSS.t3002 VSS.n345 0.0863258
R3941 VSS.t3007 VSS.n346 0.0863258
R3942 VSS.t3012 VSS.n347 0.0863258
R3943 VSS.t3017 VSS.n348 0.0863258
R3944 VSS.t3022 VSS.n349 0.0863258
R3945 VSS.t3027 VSS.n350 0.0863258
R3946 VSS.t3032 VSS.n351 0.0863258
R3947 VSS.t3037 VSS.n352 0.0863258
R3948 VSS.t3042 VSS.n353 0.0863258
R3949 VSS.t3047 VSS.n354 0.0863258
R3950 VSS.n431 VSS.t2399 0.0863258
R3951 VSS.n433 VSS.t2409 0.0863258
R3952 VSS.n435 VSS.t2419 0.0863258
R3953 VSS.n437 VSS.t2429 0.0863258
R3954 VSS.n439 VSS.t2439 0.0863258
R3955 VSS.n441 VSS.t2449 0.0863258
R3956 VSS.n443 VSS.t2459 0.0863258
R3957 VSS.n447 VSS.t2479 0.0863258
R3958 VSS.n449 VSS.t2489 0.0863258
R3959 VSS.n451 VSS.t2499 0.0863258
R3960 VSS.t2504 VSS.n452 0.0863258
R3961 VSS.t2494 VSS.n450 0.0863258
R3962 VSS.t2484 VSS.n448 0.0863258
R3963 VSS.t2474 VSS.n446 0.0863258
R3964 VSS.t2464 VSS.n444 0.0863258
R3965 VSS.t2454 VSS.n442 0.0863258
R3966 VSS.t2444 VSS.n440 0.0863258
R3967 VSS.t2434 VSS.n438 0.0863258
R3968 VSS.t2424 VSS.n436 0.0863258
R3969 VSS.t2414 VSS.n434 0.0863258
R3970 VSS.t2404 VSS.n432 0.0863258
R3971 VSS.t2389 VSS.n429 0.0863258
R3972 VSS.t2319 VSS.n415 0.0863258
R3973 VSS.n717 VSS.t455 0.0863258
R3974 VSS.n665 VSS.t561 0.0863258
R3975 VSS.n666 VSS.t566 0.0863258
R3976 VSS.n678 VSS.t719 0.0863258
R3977 VSS.n649 VSS.t1009 0.0863258
R3978 VSS.n651 VSS.t1019 0.0863258
R3979 VSS.n653 VSS.t1029 0.0863258
R3980 VSS.n655 VSS.t1039 0.0863258
R3981 VSS.t1034 VSS.n654 0.0863258
R3982 VSS.t1024 VSS.n652 0.0863258
R3983 VSS.t1014 VSS.n650 0.0863258
R3984 VSS.t999 VSS.n647 0.0863258
R3985 VSS.t854 VSS.n618 0.0863258
R3986 VSS.n600 VSS.t763 0.130189
R3987 VSS.t769 VSS.n601 0.0863258
R3988 VSS.t774 VSS.n602 0.0863258
R3989 VSS.t779 VSS.n603 0.0863258
R3990 VSS.n530 VSS.t1540 0.0863258
R3991 VSS.n532 VSS.t1550 0.0863258
R3992 VSS.n534 VSS.t1560 0.0863258
R3993 VSS.n536 VSS.t1570 0.0863258
R3994 VSS.n538 VSS.t1580 0.0863258
R3995 VSS.n540 VSS.t1590 0.0863258
R3996 VSS.n542 VSS.t1600 0.0863258
R3997 VSS.n106 VSS.t399 0.17967
R3998 VSS.n714 VSS.t441 0.0863258
R3999 VSS.n713 VSS.t438 0.0863258
R4000 VSS.n712 VSS.t435 0.0863258
R4001 VSS.n711 VSS.t432 0.0863258
R4002 VSS.n710 VSS.t429 0.0863258
R4003 VSS.n709 VSS.t426 0.0863258
R4004 VSS.n708 VSS.t423 0.0863258
R4005 VSS.n707 VSS.t420 0.0863258
R4006 VSS.n706 VSS.t417 0.0863258
R4007 VSS.n705 VSS.t414 0.0863258
R4008 VSS.n704 VSS.t411 0.0863258
R4009 VSS.n703 VSS.t408 0.0863258
R4010 VSS.n702 VSS.t405 0.0863258
R4011 VSS.t402 VSS.n701 0.0863258
R4012 VSS.n546 VSS.t1620 0.0863258
R4013 VSS.n548 VSS.t1630 0.0863258
R4014 VSS.n550 VSS.t1640 0.0863258
R4015 VSS.n552 VSS.t1650 0.0863258
R4016 VSS.n554 VSS.t1660 0.0863258
R4017 VSS.n556 VSS.t1670 0.0863258
R4018 VSS.n558 VSS.t1680 0.0863258
R4019 VSS.n560 VSS.t1690 0.0863258
R4020 VSS.n562 VSS.t1700 0.0863258
R4021 VSS.n564 VSS.t1710 0.0863258
R4022 VSS.n566 VSS.t1720 0.0863258
R4023 VSS.t1715 VSS.n565 0.0863258
R4024 VSS.t1705 VSS.n563 0.0863258
R4025 VSS.t1695 VSS.n561 0.0863258
R4026 VSS.n503 VSS.t2082 0.0863258
R4027 VSS.n505 VSS.t2092 0.0863258
R4028 VSS.n507 VSS.t2102 0.0863258
R4029 VSS.n509 VSS.t2112 0.0863258
R4030 VSS.t2107 VSS.n508 0.0863258
R4031 VSS.t2097 VSS.n506 0.0863258
R4032 VSS.t2087 VSS.n504 0.0863258
R4033 VSS.t2072 VSS.n501 0.0863258
R4034 VSS.t1927 VSS.n472 0.0863258
R4035 VSS.n454 VSS.t1836 0.130189
R4036 VSS.t1842 VSS.n455 0.0863258
R4037 VSS.t1847 VSS.n456 0.0863258
R4038 VSS.t1852 VSS.n457 0.0863258
R4039 VSS.t1857 VSS.n458 0.0863258
R4040 VSS.t1862 VSS.n459 0.0863258
R4041 VSS.t1867 VSS.n460 0.0863258
R4042 VSS.t1872 VSS.n461 0.0863258
R4043 VSS.t1877 VSS.n462 0.0863258
R4044 VSS.t1882 VSS.n463 0.0863258
R4045 VSS.t1887 VSS.n464 0.0863258
R4046 VSS.t1892 VSS.n465 0.0863258
R4047 VSS.t1897 VSS.n466 0.0863258
R4048 VSS.t1902 VSS.n467 0.0863258
R4049 VSS.t1907 VSS.n468 0.0863258
R4050 VSS.t1912 VSS.n469 0.0863258
R4051 VSS.t1917 VSS.n470 0.0863258
R4052 VSS.t1922 VSS.n471 0.0863258
R4053 VSS.t1932 VSS.n473 0.0863258
R4054 VSS.t1937 VSS.n474 0.0863258
R4055 VSS.t1942 VSS.n475 0.0863258
R4056 VSS.t1947 VSS.n476 0.0863258
R4057 VSS.t1952 VSS.n477 0.0863258
R4058 VSS.t1957 VSS.n478 0.0863258
R4059 VSS.t1962 VSS.n479 0.0863258
R4060 VSS.t1967 VSS.n480 0.0863258
R4061 VSS.t1972 VSS.n481 0.0863258
R4062 VSS.t1977 VSS.n482 0.0863258
R4063 VSS.t1982 VSS.n483 0.0863258
R4064 VSS.t1987 VSS.n484 0.0863258
R4065 VSS.t1992 VSS.n485 0.0863258
R4066 VSS.t1997 VSS.n486 0.0863258
R4067 VSS.t2007 VSS.n488 0.0863258
R4068 VSS.t2012 VSS.n489 0.0863258
R4069 VSS.t2017 VSS.n490 0.0863258
R4070 VSS.t2022 VSS.n491 0.0863258
R4071 VSS.t2027 VSS.n492 0.0863258
R4072 VSS.t2032 VSS.n493 0.0863258
R4073 VSS.t2037 VSS.n494 0.0863258
R4074 VSS.t2042 VSS.n495 0.0863258
R4075 VSS.t2047 VSS.n496 0.0863258
R4076 VSS.t2052 VSS.n497 0.0863258
R4077 VSS.t2057 VSS.n498 0.0863258
R4078 VSS.t2062 VSS.n499 0.0863258
R4079 VSS.t2067 VSS.n500 0.0863258
R4080 VSS.t1675 VSS.n557 0.0863258
R4081 VSS.t1665 VSS.n555 0.0863258
R4082 VSS.t1655 VSS.n553 0.0863258
R4083 VSS.t1645 VSS.n551 0.0863258
R4084 VSS.t1635 VSS.n549 0.0863258
R4085 VSS.t1625 VSS.n547 0.0863258
R4086 VSS.t1615 VSS.n545 0.0863258
R4087 VSS.t1605 VSS.n543 0.0863258
R4088 VSS.t1595 VSS.n541 0.0863258
R4089 VSS.t1585 VSS.n539 0.0863258
R4090 VSS.t1575 VSS.n537 0.0863258
R4091 VSS.t1565 VSS.n535 0.0863258
R4092 VSS.t1555 VSS.n533 0.0863258
R4093 VSS.t1545 VSS.n531 0.0863258
R4094 VSS.n511 VSS.t1444 0.130189
R4095 VSS.t1450 VSS.n512 0.0863258
R4096 VSS.t1455 VSS.n513 0.0863258
R4097 VSS.t1460 VSS.n514 0.0863258
R4098 VSS.t1465 VSS.n515 0.0863258
R4099 VSS.t1470 VSS.n516 0.0863258
R4100 VSS.t1475 VSS.n517 0.0863258
R4101 VSS.t1480 VSS.n518 0.0863258
R4102 VSS.t1485 VSS.n519 0.0863258
R4103 VSS.t1490 VSS.n520 0.0863258
R4104 VSS.t1495 VSS.n521 0.0863258
R4105 VSS.t1500 VSS.n522 0.0863258
R4106 VSS.t1505 VSS.n523 0.0863258
R4107 VSS.t1510 VSS.n524 0.0863258
R4108 VSS.t1515 VSS.n525 0.0863258
R4109 VSS.t1520 VSS.n526 0.0863258
R4110 VSS.t1525 VSS.n527 0.0863258
R4111 VSS.t1530 VSS.n528 0.0863258
R4112 VSS.n529 VSS.t1535 0.0863258
R4113 VSS.t784 VSS.n604 0.0863258
R4114 VSS.t789 VSS.n605 0.0863258
R4115 VSS.t794 VSS.n606 0.0863258
R4116 VSS.t799 VSS.n607 0.0863258
R4117 VSS.t804 VSS.n608 0.0863258
R4118 VSS.t809 VSS.n609 0.0863258
R4119 VSS.t814 VSS.n610 0.0863258
R4120 VSS.t819 VSS.n611 0.0863258
R4121 VSS.t824 VSS.n612 0.0863258
R4122 VSS.t829 VSS.n613 0.0863258
R4123 VSS.t834 VSS.n614 0.0863258
R4124 VSS.t839 VSS.n615 0.0863258
R4125 VSS.t844 VSS.n616 0.0863258
R4126 VSS.t849 VSS.n617 0.0863258
R4127 VSS.t859 VSS.n619 0.0863258
R4128 VSS.t864 VSS.n620 0.0863258
R4129 VSS.t869 VSS.n621 0.0863258
R4130 VSS.t874 VSS.n622 0.0863258
R4131 VSS.t879 VSS.n623 0.0863258
R4132 VSS.t884 VSS.n624 0.0863258
R4133 VSS.t889 VSS.n625 0.0863258
R4134 VSS.t894 VSS.n626 0.0863258
R4135 VSS.t899 VSS.n627 0.0863258
R4136 VSS.t904 VSS.n628 0.0863258
R4137 VSS.t909 VSS.n629 0.0863258
R4138 VSS.t914 VSS.n630 0.0863258
R4139 VSS.t919 VSS.n631 0.0863258
R4140 VSS.t924 VSS.n632 0.0863258
R4141 VSS.t934 VSS.n634 0.0863258
R4142 VSS.t939 VSS.n635 0.0863258
R4143 VSS.t944 VSS.n636 0.0863258
R4144 VSS.t949 VSS.n637 0.0863258
R4145 VSS.t954 VSS.n638 0.0863258
R4146 VSS.t959 VSS.n639 0.0863258
R4147 VSS.t964 VSS.n640 0.0863258
R4148 VSS.t969 VSS.n641 0.0863258
R4149 VSS.t974 VSS.n642 0.0863258
R4150 VSS.t979 VSS.n643 0.0863258
R4151 VSS.t984 VSS.n644 0.0863258
R4152 VSS.t989 VSS.n645 0.0863258
R4153 VSS.t994 VSS.n646 0.0863258
R4154 VSS.n679 VSS.t724 0.0863258
R4155 VSS.t689 VSS.n670 0.0863258
R4156 VSS.t521 VSS.n657 0.0863258
R4157 VSS.t526 VSS.n658 0.0863258
R4158 VSS.t531 VSS.n659 0.0863258
R4159 VSS.t536 VSS.n660 0.0863258
R4160 VSS.t541 VSS.n661 0.0863258
R4161 VSS.t546 VSS.n662 0.0863258
R4162 VSS.t551 VSS.n663 0.0863258
R4163 VSS.n664 VSS.t556 0.0863258
R4164 VSS.t25 VSS.n718 0.0863258
R4165 VSS.n720 VSS.t384 0.130189
R4166 VSS.n722 VSS.t187 0.130189
R4167 VSS.n397 VSS.t2228 0.130189
R4168 VSS.t2234 VSS.n398 0.0863258
R4169 VSS.t2239 VSS.n399 0.0863258
R4170 VSS.t2244 VSS.n400 0.0863258
R4171 VSS.t2249 VSS.n401 0.0863258
R4172 VSS.t2254 VSS.n402 0.0863258
R4173 VSS.t2259 VSS.n403 0.0863258
R4174 VSS.t2264 VSS.n404 0.0863258
R4175 VSS.t2269 VSS.n405 0.0863258
R4176 VSS.t2274 VSS.n406 0.0863258
R4177 VSS.t2279 VSS.n407 0.0863258
R4178 VSS.t2284 VSS.n408 0.0863258
R4179 VSS.t2289 VSS.n409 0.0863258
R4180 VSS.t2294 VSS.n410 0.0863258
R4181 VSS.t2299 VSS.n411 0.0863258
R4182 VSS.t2304 VSS.n412 0.0863258
R4183 VSS.t2309 VSS.n413 0.0863258
R4184 VSS.t2314 VSS.n414 0.0863258
R4185 VSS.t2324 VSS.n416 0.0863258
R4186 VSS.t2329 VSS.n417 0.0863258
R4187 VSS.t2334 VSS.n418 0.0863258
R4188 VSS.t2339 VSS.n419 0.0863258
R4189 VSS.t2344 VSS.n420 0.0863258
R4190 VSS.t2349 VSS.n421 0.0863258
R4191 VSS.t2354 VSS.n422 0.0863258
R4192 VSS.t2359 VSS.n423 0.0863258
R4193 VSS.t2364 VSS.n424 0.0863258
R4194 VSS.t2369 VSS.n425 0.0863258
R4195 VSS.t2374 VSS.n426 0.0863258
R4196 VSS.t2379 VSS.n427 0.0863258
R4197 VSS.t2384 VSS.n428 0.0863258
R4198 VSS.t3057 VSS.n356 0.0863258
R4199 VSS.t3062 VSS.n357 0.0863258
R4200 VSS.t3067 VSS.n358 0.0863258
R4201 VSS.t3072 VSS.n359 0.0863258
R4202 VSS.t3077 VSS.n360 0.0863258
R4203 VSS.t3082 VSS.n361 0.0863258
R4204 VSS.t3087 VSS.n362 0.0863258
R4205 VSS.t3092 VSS.n363 0.0863258
R4206 VSS.t3097 VSS.n364 0.0863258
R4207 VSS.t3102 VSS.n365 0.0863258
R4208 VSS.t3107 VSS.n366 0.0863258
R4209 VSS.t3112 VSS.n367 0.0863258
R4210 VSS.t3117 VSS.n368 0.0863258
R4211 VSS.t2886 VSS.n322 0.130189
R4212 VSS.n324 VSS.t2897 0.0863258
R4213 VSS.t2892 VSS.n323 0.0863258
R4214 VSS.t2907 VSS.n326 0.0863258
R4215 VSS.t262 VSS.t263 0.217986
R4216 VSS.t336 VSS.t101 0.217986
R4217 VSS.t333 VSS.t332 0.217986
R4218 VSS.t328 VSS.t327 0.217986
R4219 VSS.t323 VSS.t322 0.217986
R4220 VSS.t319 VSS.t318 0.217986
R4221 VSS.t314 VSS.t313 0.217986
R4222 VSS.t309 VSS.t308 0.217986
R4223 VSS.t299 VSS.t150 0.217986
R4224 VSS.t346 VSS.t345 0.217986
R4225 VSS.n672 VSS.t704 0.0861948
R4226 VSS.n668 VSS.t680 0.0861948
R4227 VSS.t468 VSS.t52 0.213325
R4228 VSS.t2667 VSS.t2666 0.210825
R4229 VSS.t2977 VSS.n952 0.210486
R4230 VSS.n946 VSS.t2319 0.210486
R4231 VSS.n841 VSS.t1927 0.210486
R4232 VSS.n910 VSS.t1535 0.210486
R4233 VSS.n915 VSS.t854 0.210486
R4234 VSS.n935 VSS.t556 0.210486
R4235 VSS.n597 VSS.t1155 0.104635
R4236 VSS.n667 VSS.t570 0.0818513
R4237 VSS.t75 VSS.t3 0.204291
R4238 VSS.t75 VSS.t227 0.203557
R4239 VSS.t2629 VSS.t2630 0.190486
R4240 VSS.n669 VSS.t685 0.24604
R4241 VSS.t1297 VSS.n586 0.0605362
R4242 VSS.t467 VSS.t3225 0.180789
R4243 VSS.t1210 VSS.t1209 0.180789
R4244 VSS.t1208 VSS.n207 0.0605362
R4245 VSS.t44 VSS.n120 0.019997
R4246 VSS.t2871 VSS.t2749 0.170789
R4247 VSS.t1428 VSS.n905 0.170789
R4248 VSS.t3052 VSS.n949 0.170789
R4249 VSS.n729 VSS.t2394 0.170789
R4250 VSS.t929 VSS.n836 0.170789
R4251 VSS.t1610 VSS.n909 0.170789
R4252 VSS.t2002 VSS.n839 0.170789
R4253 VSS.n391 VSS.t343 0.0836055
R4254 VSS.t1319 VSS.t1320 0.167039
R4255 VSS.n254 VSS.t686 0.0836055
R4256 VSS.t306 VSS.n381 0.0836055
R4257 VSS.t761 VSS.n696 0.0647427
R4258 VSS.n715 VSS.t444 0.0647427
R4259 VSS.t3052 VSS.n355 0.07903
R4260 VSS.t2394 VSS.n430 0.07903
R4261 VSS.t2002 VSS.n487 0.07903
R4262 VSS.n544 VSS.t1610 0.07903
R4263 VSS.t929 VSS.n633 0.07903
R4264 VSS.t75 VSS.t274 0.157212
R4265 VSS.t89 VSS.t397 0.153289
R4266 VSS.t2667 VSS.t2811 0.150486
R4267 VSS.n181 VSS.t123 0.0735143
R4268 VSS.t2904 VSS.t2902 0.135506
R4269 VSS.t1166 VSS.t1327 0.130789
R4270 VSS.t3207 VSS.n176 0.416712
R4271 VSS.t2749 VSS.t2748 0.130486
R4272 VSS.t2630 VSS.t2779 0.110789
R4273 VSS.t1166 VSS.t1328 0.110789
R4274 VSS.t341 VSS.n231 0.175751
R4275 VSS.t2708 VSS.n726 0.1105
R4276 VSS.n906 VSS.t1253 0.1105
R4277 VSS.n320 VSS.n949 0.081538
R4278 VSS.n319 VSS.t3127 0.181538
R4279 VSS.n303 VSS.n729 0.081538
R4280 VSS.t2469 VSS.n302 0.181538
R4281 VSS.n301 VSS.n839 0.081538
R4282 VSS.n300 VSS.t2077 0.181538
R4283 VSS.n909 VSS.n299 0.081538
R4284 VSS.n298 VSS.t1685 0.181538
R4285 VSS.n273 VSS.n836 0.081538
R4286 VSS.n272 VSS.t1004 0.181538
R4287 VSS.t588 VSS.n811 0.10425
R4288 VSS.n230 VSS.t304 0.155751
R4289 VSS.t1361 VSS.n207 0.210486
R4290 VSS.t3225 VSS.n699 0.0583051
R4291 VSS.t2889 VSS.t2891 0.0855
R4292 VSS.t2896 VSS.t2894 0.0855
R4293 VSS.t2899 VSS.t2901 0.0855
R4294 VSS.t338 VSS.t340 0.0855
R4295 VSS.t343 VSS.t345 0.0855
R4296 VSS.t3056 VSS.t3054 0.0855
R4297 VSS.t3061 VSS.t3059 0.0855
R4298 VSS.t3066 VSS.t3064 0.0855
R4299 VSS.t3071 VSS.t3069 0.0855
R4300 VSS.t3076 VSS.t3074 0.0855
R4301 VSS.t3081 VSS.t3079 0.0855
R4302 VSS.t3086 VSS.t3084 0.0855
R4303 VSS.t3091 VSS.t3089 0.0855
R4304 VSS.t3096 VSS.t3094 0.0855
R4305 VSS.t3101 VSS.t3099 0.0855
R4306 VSS.t3106 VSS.t3104 0.0855
R4307 VSS.t3111 VSS.t3109 0.0855
R4308 VSS.t3116 VSS.t3114 0.0855
R4309 VSS.t3121 VSS.t3119 0.0855
R4310 VSS.t3124 VSS.t3126 0.0855
R4311 VSS.t3131 VSS.t3129 0.0855
R4312 VSS.t3134 VSS.t3136 0.0855
R4313 VSS.t3141 VSS.t3139 0.0855
R4314 VSS.t3144 VSS.t3146 0.0855
R4315 VSS.t3151 VSS.t3149 0.0855
R4316 VSS.t3154 VSS.t3156 0.0855
R4317 VSS.t3161 VSS.t3159 0.0855
R4318 VSS.t2981 VSS.t2979 0.0855
R4319 VSS.t2986 VSS.t2984 0.0855
R4320 VSS.t2991 VSS.t2989 0.0855
R4321 VSS.t2996 VSS.t2994 0.0855
R4322 VSS.t3001 VSS.t2999 0.0855
R4323 VSS.t3006 VSS.t3004 0.0855
R4324 VSS.t3011 VSS.t3009 0.0855
R4325 VSS.t3016 VSS.t3014 0.0855
R4326 VSS.t3021 VSS.t3019 0.0855
R4327 VSS.t3026 VSS.t3024 0.0855
R4328 VSS.t3031 VSS.t3029 0.0855
R4329 VSS.t3036 VSS.t3034 0.0855
R4330 VSS.t3041 VSS.t3039 0.0855
R4331 VSS.t3046 VSS.t3044 0.0855
R4332 VSS.t3051 VSS.t3049 0.0855
R4333 VSS.t2974 VSS.t2976 0.0855
R4334 VSS.t2969 VSS.t2971 0.0855
R4335 VSS.t2964 VSS.t2966 0.0855
R4336 VSS.t2959 VSS.t2961 0.0855
R4337 VSS.t2954 VSS.t2956 0.0855
R4338 VSS.t2949 VSS.t2951 0.0855
R4339 VSS.t2944 VSS.t2946 0.0855
R4340 VSS.t2939 VSS.t2941 0.0855
R4341 VSS.t2934 VSS.t2936 0.0855
R4342 VSS.t2929 VSS.t2931 0.0855
R4343 VSS.t2924 VSS.t2926 0.0855
R4344 VSS.t2919 VSS.t2921 0.0855
R4345 VSS.t2914 VSS.t2916 0.0855
R4346 VSS.t2911 VSS.t2909 0.0855
R4347 VSS.t2904 VSS.t2906 0.0855
R4348 VSS.t2233 VSS.t2231 0.0855
R4349 VSS.t2238 VSS.t2236 0.0855
R4350 VSS.t2243 VSS.t2241 0.0855
R4351 VSS.t2248 VSS.t2246 0.0855
R4352 VSS.t2253 VSS.t2251 0.0855
R4353 VSS.t2258 VSS.t2256 0.0855
R4354 VSS.t2263 VSS.t2261 0.0855
R4355 VSS.t2268 VSS.t2266 0.0855
R4356 VSS.t2273 VSS.t2271 0.0855
R4357 VSS.t2278 VSS.t2276 0.0855
R4358 VSS.t2283 VSS.t2281 0.0855
R4359 VSS.t2288 VSS.t2286 0.0855
R4360 VSS.t2293 VSS.t2291 0.0855
R4361 VSS.t2298 VSS.t2296 0.0855
R4362 VSS.t2303 VSS.t2301 0.0855
R4363 VSS.t2308 VSS.t2306 0.0855
R4364 VSS.t2313 VSS.t2311 0.0855
R4365 VSS.t2318 VSS.t2316 0.0855
R4366 VSS.t2323 VSS.t2321 0.0855
R4367 VSS.t2328 VSS.t2326 0.0855
R4368 VSS.t2333 VSS.t2331 0.0855
R4369 VSS.t2338 VSS.t2336 0.0855
R4370 VSS.t2343 VSS.t2341 0.0855
R4371 VSS.t2348 VSS.t2346 0.0855
R4372 VSS.t2353 VSS.t2351 0.0855
R4373 VSS.t2358 VSS.t2356 0.0855
R4374 VSS.t2363 VSS.t2361 0.0855
R4375 VSS.t2368 VSS.t2366 0.0855
R4376 VSS.t2373 VSS.t2371 0.0855
R4377 VSS.t2378 VSS.t2376 0.0855
R4378 VSS.t2383 VSS.t2381 0.0855
R4379 VSS.t2388 VSS.t2386 0.0855
R4380 VSS.t2391 VSS.t2393 0.0855
R4381 VSS.t2398 VSS.t2396 0.0855
R4382 VSS.t2401 VSS.t2403 0.0855
R4383 VSS.t2408 VSS.t2406 0.0855
R4384 VSS.t2411 VSS.t2413 0.0855
R4385 VSS.t2418 VSS.t2416 0.0855
R4386 VSS.t2421 VSS.t2423 0.0855
R4387 VSS.t2428 VSS.t2426 0.0855
R4388 VSS.t2431 VSS.t2433 0.0855
R4389 VSS.t2438 VSS.t2436 0.0855
R4390 VSS.t2441 VSS.t2443 0.0855
R4391 VSS.t2448 VSS.t2446 0.0855
R4392 VSS.t2451 VSS.t2453 0.0855
R4393 VSS.t2458 VSS.t2456 0.0855
R4394 VSS.t2461 VSS.t2463 0.0855
R4395 VSS.t2468 VSS.t2466 0.0855
R4396 VSS.t2471 VSS.t2473 0.0855
R4397 VSS.t2478 VSS.t2476 0.0855
R4398 VSS.t2481 VSS.t2483 0.0855
R4399 VSS.t2488 VSS.t2486 0.0855
R4400 VSS.t2491 VSS.t2493 0.0855
R4401 VSS.t2498 VSS.t2496 0.0855
R4402 VSS.t2501 VSS.t2503 0.0855
R4403 VSS.t1841 VSS.t1839 0.0855
R4404 VSS.t1846 VSS.t1844 0.0855
R4405 VSS.t1851 VSS.t1849 0.0855
R4406 VSS.t1856 VSS.t1854 0.0855
R4407 VSS.t1861 VSS.t1859 0.0855
R4408 VSS.t1866 VSS.t1864 0.0855
R4409 VSS.t1871 VSS.t1869 0.0855
R4410 VSS.t1876 VSS.t1874 0.0855
R4411 VSS.t1881 VSS.t1879 0.0855
R4412 VSS.t1886 VSS.t1884 0.0855
R4413 VSS.t1891 VSS.t1889 0.0855
R4414 VSS.t1896 VSS.t1894 0.0855
R4415 VSS.t1901 VSS.t1899 0.0855
R4416 VSS.t1906 VSS.t1904 0.0855
R4417 VSS.t1911 VSS.t1909 0.0855
R4418 VSS.t1916 VSS.t1914 0.0855
R4419 VSS.t1921 VSS.t1919 0.0855
R4420 VSS.t1926 VSS.t1924 0.0855
R4421 VSS.t1931 VSS.t1929 0.0855
R4422 VSS.t1936 VSS.t1934 0.0855
R4423 VSS.t1941 VSS.t1939 0.0855
R4424 VSS.t1946 VSS.t1944 0.0855
R4425 VSS.t1951 VSS.t1949 0.0855
R4426 VSS.t1956 VSS.t1954 0.0855
R4427 VSS.t1961 VSS.t1959 0.0855
R4428 VSS.t1966 VSS.t1964 0.0855
R4429 VSS.t1971 VSS.t1969 0.0855
R4430 VSS.t1976 VSS.t1974 0.0855
R4431 VSS.t1981 VSS.t1979 0.0855
R4432 VSS.t1986 VSS.t1984 0.0855
R4433 VSS.t1991 VSS.t1989 0.0855
R4434 VSS.t1996 VSS.t1994 0.0855
R4435 VSS.t2001 VSS.t1999 0.0855
R4436 VSS.t2006 VSS.t2004 0.0855
R4437 VSS.t2011 VSS.t2009 0.0855
R4438 VSS.t2016 VSS.t2014 0.0855
R4439 VSS.t2021 VSS.t2019 0.0855
R4440 VSS.t2026 VSS.t2024 0.0855
R4441 VSS.t2031 VSS.t2029 0.0855
R4442 VSS.t2036 VSS.t2034 0.0855
R4443 VSS.t2041 VSS.t2039 0.0855
R4444 VSS.t2046 VSS.t2044 0.0855
R4445 VSS.t2051 VSS.t2049 0.0855
R4446 VSS.t2056 VSS.t2054 0.0855
R4447 VSS.t2061 VSS.t2059 0.0855
R4448 VSS.t2066 VSS.t2064 0.0855
R4449 VSS.t2071 VSS.t2069 0.0855
R4450 VSS.t2074 VSS.t2076 0.0855
R4451 VSS.t2081 VSS.t2079 0.0855
R4452 VSS.t2084 VSS.t2086 0.0855
R4453 VSS.t2091 VSS.t2089 0.0855
R4454 VSS.t2094 VSS.t2096 0.0855
R4455 VSS.t2101 VSS.t2099 0.0855
R4456 VSS.t2104 VSS.t2106 0.0855
R4457 VSS.t2111 VSS.t2109 0.0855
R4458 VSS.t1449 VSS.t1447 0.0855
R4459 VSS.t1454 VSS.t1452 0.0855
R4460 VSS.t1459 VSS.t1457 0.0855
R4461 VSS.t1464 VSS.t1462 0.0855
R4462 VSS.t1469 VSS.t1467 0.0855
R4463 VSS.t1474 VSS.t1472 0.0855
R4464 VSS.t1479 VSS.t1477 0.0855
R4465 VSS.t1484 VSS.t1482 0.0855
R4466 VSS.t1489 VSS.t1487 0.0855
R4467 VSS.t1494 VSS.t1492 0.0855
R4468 VSS.t1499 VSS.t1497 0.0855
R4469 VSS.t1504 VSS.t1502 0.0855
R4470 VSS.t1509 VSS.t1507 0.0855
R4471 VSS.t1514 VSS.t1512 0.0855
R4472 VSS.t1519 VSS.t1517 0.0855
R4473 VSS.t1524 VSS.t1522 0.0855
R4474 VSS.t1529 VSS.t1527 0.0855
R4475 VSS.t1534 VSS.t1532 0.0855
R4476 VSS.t1539 VSS.t1537 0.0855
R4477 VSS.t1542 VSS.t1544 0.0855
R4478 VSS.t1549 VSS.t1547 0.0855
R4479 VSS.t1552 VSS.t1554 0.0855
R4480 VSS.t1559 VSS.t1557 0.0855
R4481 VSS.t1562 VSS.t1564 0.0855
R4482 VSS.t1569 VSS.t1567 0.0855
R4483 VSS.t1572 VSS.t1574 0.0855
R4484 VSS.t1579 VSS.t1577 0.0855
R4485 VSS.t1582 VSS.t1584 0.0855
R4486 VSS.t1589 VSS.t1587 0.0855
R4487 VSS.t1592 VSS.t1594 0.0855
R4488 VSS.t1599 VSS.t1597 0.0855
R4489 VSS.t1602 VSS.t1604 0.0855
R4490 VSS.t1609 VSS.t1607 0.0855
R4491 VSS.t1612 VSS.t1614 0.0855
R4492 VSS.t1619 VSS.t1617 0.0855
R4493 VSS.t1622 VSS.t1624 0.0855
R4494 VSS.t1629 VSS.t1627 0.0855
R4495 VSS.t1632 VSS.t1634 0.0855
R4496 VSS.t1639 VSS.t1637 0.0855
R4497 VSS.t1642 VSS.t1644 0.0855
R4498 VSS.t1649 VSS.t1647 0.0855
R4499 VSS.t1652 VSS.t1654 0.0855
R4500 VSS.t1659 VSS.t1657 0.0855
R4501 VSS.t1662 VSS.t1664 0.0855
R4502 VSS.t1669 VSS.t1667 0.0855
R4503 VSS.t1672 VSS.t1674 0.0855
R4504 VSS.t1679 VSS.t1677 0.0855
R4505 VSS.t1682 VSS.t1684 0.0855
R4506 VSS.t1689 VSS.t1687 0.0855
R4507 VSS.t1692 VSS.t1694 0.0855
R4508 VSS.t1699 VSS.t1697 0.0855
R4509 VSS.t1702 VSS.t1704 0.0855
R4510 VSS.t1709 VSS.t1707 0.0855
R4511 VSS.t1712 VSS.t1714 0.0855
R4512 VSS.t1719 VSS.t1717 0.0855
R4513 VSS.t768 VSS.t766 0.0855
R4514 VSS.t773 VSS.t771 0.0855
R4515 VSS.t778 VSS.t776 0.0855
R4516 VSS.t783 VSS.t781 0.0855
R4517 VSS.t788 VSS.t786 0.0855
R4518 VSS.t793 VSS.t791 0.0855
R4519 VSS.t798 VSS.t796 0.0855
R4520 VSS.t803 VSS.t801 0.0855
R4521 VSS.t808 VSS.t806 0.0855
R4522 VSS.t813 VSS.t811 0.0855
R4523 VSS.t818 VSS.t816 0.0855
R4524 VSS.t823 VSS.t821 0.0855
R4525 VSS.t828 VSS.t826 0.0855
R4526 VSS.t833 VSS.t831 0.0855
R4527 VSS.t838 VSS.t836 0.0855
R4528 VSS.t843 VSS.t841 0.0855
R4529 VSS.t848 VSS.t846 0.0855
R4530 VSS.t853 VSS.t851 0.0855
R4531 VSS.t858 VSS.t856 0.0855
R4532 VSS.t863 VSS.t861 0.0855
R4533 VSS.t868 VSS.t866 0.0855
R4534 VSS.t873 VSS.t871 0.0855
R4535 VSS.t878 VSS.t876 0.0855
R4536 VSS.t883 VSS.t881 0.0855
R4537 VSS.t888 VSS.t886 0.0855
R4538 VSS.t893 VSS.t891 0.0855
R4539 VSS.t898 VSS.t896 0.0855
R4540 VSS.t903 VSS.t901 0.0855
R4541 VSS.t908 VSS.t906 0.0855
R4542 VSS.t913 VSS.t911 0.0855
R4543 VSS.t918 VSS.t916 0.0855
R4544 VSS.t923 VSS.t921 0.0855
R4545 VSS.t928 VSS.t926 0.0855
R4546 VSS.t933 VSS.t931 0.0855
R4547 VSS.t938 VSS.t936 0.0855
R4548 VSS.t943 VSS.t941 0.0855
R4549 VSS.t948 VSS.t946 0.0855
R4550 VSS.t953 VSS.t951 0.0855
R4551 VSS.t958 VSS.t956 0.0855
R4552 VSS.t963 VSS.t961 0.0855
R4553 VSS.t968 VSS.t966 0.0855
R4554 VSS.t973 VSS.t971 0.0855
R4555 VSS.t978 VSS.t976 0.0855
R4556 VSS.t983 VSS.t981 0.0855
R4557 VSS.t988 VSS.t986 0.0855
R4558 VSS.t993 VSS.t991 0.0855
R4559 VSS.t998 VSS.t996 0.0855
R4560 VSS.t1001 VSS.t1003 0.0855
R4561 VSS.t1008 VSS.t1006 0.0855
R4562 VSS.t1011 VSS.t1013 0.0855
R4563 VSS.t1018 VSS.t1016 0.0855
R4564 VSS.t1021 VSS.t1023 0.0855
R4565 VSS.t1028 VSS.t1026 0.0855
R4566 VSS.t1031 VSS.t1033 0.0855
R4567 VSS.t1038 VSS.t1036 0.0855
R4568 VSS.t147 VSS.t726 0.0855
R4569 VSS.t721 VSS.t723 0.0855
R4570 VSS.t698 VSS.t138 0.0855
R4571 VSS.t688 VSS.t686 0.0855
R4572 VSS.t684 VSS.t682 0.0855
R4573 VSS.t49 VSS.t678 0.0855
R4574 VSS.t563 VSS.t565 0.0855
R4575 VSS.t560 VSS.t558 0.0855
R4576 VSS.t520 VSS.t252 0.0855
R4577 VSS.t525 VSS.t523 0.0855
R4578 VSS.t530 VSS.t528 0.0855
R4579 VSS.t535 VSS.t533 0.0855
R4580 VSS.t540 VSS.t538 0.0855
R4581 VSS.t545 VSS.t543 0.0855
R4582 VSS.t550 VSS.t548 0.0855
R4583 VSS.t555 VSS.t553 0.0855
R4584 VSS.t400 VSS.t401 0.0855
R4585 VSS.t403 VSS.t404 0.0855
R4586 VSS.t406 VSS.t407 0.0855
R4587 VSS.t409 VSS.t410 0.0855
R4588 VSS.t412 VSS.t413 0.0855
R4589 VSS.t415 VSS.t416 0.0855
R4590 VSS.t418 VSS.t419 0.0855
R4591 VSS.t421 VSS.t422 0.0855
R4592 VSS.t424 VSS.t425 0.0855
R4593 VSS.t427 VSS.t428 0.0855
R4594 VSS.t430 VSS.t431 0.0855
R4595 VSS.t433 VSS.t434 0.0855
R4596 VSS.t436 VSS.t437 0.0855
R4597 VSS.t439 VSS.t440 0.0855
R4598 VSS.t119 VSS.t387 0.0855
R4599 VSS.t56 VSS.t458 0.0855
R4600 VSS.t30 VSS.t27 0.0855
R4601 VSS.t308 VSS.t306 0.0855
R4602 VSS.t313 VSS.t311 0.0855
R4603 VSS.t318 VSS.t316 0.0855
R4604 VSS.t327 VSS.t325 0.0855
R4605 VSS.t332 VSS.t330 0.0855
R4606 VSS.t301 VSS.t303 0.0855
R4607 VSS.t576 VSS.t703 0.0855
R4608 VSS.t590 VSS.t67 0.07425
R4609 VSS.t568 VSS.t571 0.07425
R4610 VSS.t442 VSS.t443 0.07425
R4611 VSS.t265 VSS.t267 0.07425
R4612 VSS.t2841 VSS.n726 0.070789
R4613 VSS.t3127 VSS.n370 0.149319
R4614 VSS.n445 VSS.t2469 0.149319
R4615 VSS.t1004 VSS.n648 0.149319
R4616 VSS.n559 VSS.t1685 0.149319
R4617 VSS.t2077 VSS.n502 0.149319
R4618 VSS.t75 VSS.n70 0.0643474
R4619 VSS.t75 VSS.n69 0.0643474
R4620 VSS.t75 VSS.n67 0.0643474
R4621 VSS.n63 VSS.t296 26.1613
R4622 VSS.n163 VSS.t75 4.38457
R4623 VSS.t21 VSS.t111 0.05925
R4624 VSS.t1209 VSS.t1361 0.0305
R4625 VSS.t2490 VSS.n77 109.96
R4626 VSS.t2460 VSS.n77 109.992
R4627 VSS.t2440 VSS.n77 109.992
R4628 VSS.t2420 VSS.n77 109.992
R4629 VSS.n77 VSS.t2390 109.992
R4630 VSS.n77 VSS.t2365 109.992
R4631 VSS.n77 VSS.t2340 109.992
R4632 VSS.n77 VSS.t2300 109.992
R4633 VSS.n77 VSS.t2270 109.992
R4634 VSS.n77 VSS.t2250 109.992
R4635 VSS.n76 VSS.t2098 109.96
R4636 VSS.t2083 VSS.n76 109.992
R4637 VSS.n76 VSS.t2028 109.992
R4638 VSS.n76 VSS.t2008 109.992
R4639 VSS.n76 VSS.t2003 109.992
R4640 VSS.n76 VSS.t1978 109.992
R4641 VSS.n76 VSS.t1953 109.992
R4642 VSS.n76 VSS.t1918 109.992
R4643 VSS.n76 VSS.t1908 109.992
R4644 VSS.n76 VSS.t1888 109.992
R4645 VSS.n75 VSS.t1716 109.992
R4646 VSS.n75 VSS.t1686 109.992
R4647 VSS.n75 VSS.t1676 109.992
R4648 VSS.t1661 VSS.n75 109.992
R4649 VSS.t1611 VSS.n75 109.992
R4650 VSS.t1591 VSS.n75 109.992
R4651 VSS.t1561 VSS.n75 109.992
R4652 VSS.t1541 VSS.n75 109.992
R4653 VSS.n75 VSS.t1521 109.992
R4654 VSS.n75 VSS.t1496 109.992
R4655 VSS.n75 VSS.t1466 109.992
R4656 VSS.n74 VSS.t1015 109.992
R4657 VSS.n74 VSS.t995 109.992
R4658 VSS.n74 VSS.t975 109.992
R4659 VSS.n74 VSS.t920 109.992
R4660 VSS.n74 VSS.t815 109.992
R4661 VSS.n74 VSS.t785 109.992
R4662 VSS.t72 VSS.t552 109.992
R4663 VSS.t72 VSS.t547 109.992
R4664 VSS.t72 VSS.t542 109.992
R4665 VSS.t72 VSS.t514 109.992
R4666 VSS VSS.n953 0.01986
R4667 VSS.n952 VSS.t2979 0.01675
R4668 VSS.t2321 VSS.n946 0.01675
R4669 VSS.t1929 VSS.n841 0.01675
R4670 VSS.n910 VSS.t1537 0.01675
R4671 VSS.t856 VSS.n915 0.01675
R4672 VSS.n935 VSS.t558 0.01675
R4673 VSS.n906 VSS.n598 0.0105
R4674 VSS.t1298 VSS.n905 0.0105
R4675 VSS.t586 VSS.n811 0.0105
R4676 VSS.n126 VSS.t2903 183.805
R4677 VSS.n126 VSS.t3123 183.805
R4678 VSS.n126 VSS.t3108 183.805
R4679 VSS.n126 VSS.t3078 183.805
R4680 VSS.n126 VSS.t3053 183.805
R4681 VSS.n126 VSS.t2983 183.805
R4682 VSS.t2958 VSS.n126 183.805
R4683 VSS.t2938 VSS.n126 183.805
R4684 VSS.t2918 VSS.n126 183.805
R4685 VSS.n653 VSS.n74 4.26806
R4686 VSS.n564 VSS.n75 4.26805
R4687 VSS.n77 VSS.n450 4.26804
R4688 VSS.n457 VSS.n76 4.26804
R4689 VSS.t198 VSS.n182 3.02533
R4690 VSS.n325 VSS.n126 2.85742
R4691 VSS.n204 VSS.t1154 2.60639
R4692 VSS.t508 VSS.t72 1.34849
R4693 VSS.t11 VSS.n129 1.24019
R4694 VSS.t503 VSS.t72 1.08402
R4695 VSS.t75 VSS.n65 1.02901
R4696 VSS.n175 VSS.t11 1.01251
R4697 VSS.t75 VSS.n72 1.01233
C0 sg13cmos5l_dfrbpq_1_7.Q a_27882_14484# 0.09875f
C1 sg13cmos5l_or3_1_2.C sg13cmos5l_o21ai_1_1.Y 0.03402f
C2 a_6086_14922# sg13cmos5l_dfrbpq_1_2.CLK 0.01616f
C3 sg13cmos5l_or3_1_1.B a_17584_13942# 0.01425f
C4 a_10618_14448# sg13cmos5l_buf_1_10.X 0.01712f
C5 a_7822_13911# a_7937_13912# 0.3854f
C6 a_5687_15549# sg13cmos5l_dlygate4sd3_1_3.A 0.01959f
C7 a_6372_14488# a_6891_14495# 0.20754f
C8 a_6789_14495# a_6660_14909# 0.01562f
C9 sg13cmos5l_inv_1_0.Y a_16168_15996# 0.03785f
C10 a_26633_16334# a_26757_16033# 0.08186f
C11 sg13cmos5l_and2_1_2.B a_8685_14832# 0.17752f
C12 sg13cmos5l_buf_1_0.X sg13cmos5l_nand3_1_0.Y 0.18201f
C13 a_25786_15960# a_25505_16262# 0.18796f
C14 VDD a_20376_14464# 0.01867f
C15 sg13cmos5l_xor2_1_0.B a_6372_14488# 0.02396f
C16 sg13cmos5l_xnor2_1_2.B a_6286_13911# 0.05827f
C17 VDD a_38720_15366# 0.09056f
C18 sg13cmos5l_or3_1_1.X a_25094_14484# 0.03354f
C19 VDD a_3333_16033# 0.07215f
C20 a_22508_15960# counter_value_o[4] 0.15504f
C21 sg13cmos5l_dfrbpq_1_2.Q sg13cmos5l_dfrbpq_1_2.CLK 0.01544f
C22 sg13cmos5l_or3_1_1.C sg13cmos5l_o21ai_1_2.Y 0.14946f
C23 a_7888_14726# a_7631_14845# 0.23043f
C24 sg13cmos5l_dlygate4sd3_1_8.X sg13cmos5l_dlygate4sd3_1_1.A 0.16183f
C25 VDD a_24824_14525# 0.2598f
C26 a_25786_15960# sg13cmos5l_dfrbpq_1_7.RESET_B 0.03625f
C27 a_17238_15302# sg13cmos5l_a21oi_1_0.A2 0.03082f
C28 sg13cmos5l_dlygate4sd3_1_3.A clock_i 0.14753f
C29 sg13cmos5l_a21oi_1_3.B1 sg13cmos5l_o21ai_1_2.Y 0.01177f
C30 sg13cmos5l_dfrbpq_1_6.D a_20774_14922# 0.17726f
C31 sg13cmos5l_xnor2_1_2.A sg13cmos5l_dfrbpq_1_2.CLK 0.07807f
C32 sg13cmos5l_o21ai_1_2.B1 sg13cmos5l_buf_8_2.X 0.22463f
C33 sg13cmos5l_dfrbpq_1_3.Q sg13cmos5l_dfrbpq_1_6.Q 0.18548f
C34 VDD a_24923_15996# 0.16154f
C35 VDD counter_value_o[3] 0.07686f
C36 VDD a_32492_15960# 0.22858f
C37 a_3333_15213# a_3204_15247# 0.01562f
C38 sg13cmos5l_dfrbpq_1_1.RESET_B sg13cmos5l_dlygate4sd3_1_1.A 0.02096f
C39 VDD a_15671_15549# 0.08776f
C40 VDD a_9737_14822# 0.0769f
C41 VDD a_6401_13912# 0.20914f
C42 a_10618_14448# a_10337_14750# 0.18796f
C43 sg13cmos5l_and2_1_1.X sg13cmos5l_dfrbpq_1_2.CLK 0.02079f
C44 a_4474_14448# sg13cmos5l_dfrbpq_1_2.CLK 0.01341f
C45 a_25094_14484# sg13cmos5l_buf_8_2.X 0.01175f
C46 a_2890_15457# a_3333_15213# 0.02241f
C47 sg13cmos5l_and2_1_0.X a_2630_15234# 0.18471f
C48 sg13cmos5l_a21oi_1_0.Y a_16955_14484# 0.0998f
C49 sg13cmos5l_or3_1_2.A sg13cmos5l_or3_1_1.B 0.02451f
C50 a_8582_15238# sg13cmos5l_nand4_1_0.Y 0.0177f
C51 sg13cmos5l_buf_1_0.X sg13cmos5l_xnor2_1_2.B 0.22918f
C52 VDD a_10016_14570# 0.07441f
C53 sg13cmos5l_dfrbpq_1_2.RESET_B a_17327_13799# 0.10868f
C54 VDD sg13cmos5l_o21ai_1_3.Y 0.48036f
C55 a_10703_15311# a_10960_15454# 0.23043f
C56 a_15579_14854# sg13cmos5l_dfrbpq_1_2.D 0.09154f
C57 sg13cmos5l_or3_1_2.A a_20278_14862# 0.02431f
C58 sg13cmos5l_dlygate4sd3_1_8.X a_9861_14521# 0.02311f
C59 sg13cmos5l_a21oi_1_3.B1 sg13cmos5l_dfrbpq_1_2.CLK 0.1602f
C60 VDD sg13cmos5l_a21oi_1_0.A1 0.33029f
C61 VDD a_15782_13722# 0.52997f
C62 sg13cmos5l_or3_1_1.B a_16168_15996# 0.18678f
C63 VDD sg13cmos5l_buf_8_2.A 1.75883f
C64 sg13cmos5l_dfrbpq_1_2.Q sg13cmos5l_dfrbpq_1_6.Q 0.44792f
C65 a_16042_13945# a_16485_13701# 0.02241f
C66 sg13cmos5l_o21ai_1_1.Y a_20774_14922# 0.03526f
C67 VDD a_19120_14726# 0.13647f
C68 VDD counter_value_o[2] 0.12104f
C69 sg13cmos5l_dfrbpq_1_2.Q a_17318_14922# 0.02985f
C70 sg13cmos5l_dfrbpq_1_6.RESET_B a_22025_16334# 0.01142f
C71 a_21281_16262# a_21166_16263# 0.3854f
C72 a_21579_14495# sg13cmos5l_buf_8_2.X 0.03908f
C73 sg13cmos5l_xnor2_1_2.A sg13cmos5l_dlygate4sd3_1_1.A 0.06433f
C74 a_3333_15213# sg13cmos5l_dfrbpq_1_2.CLK 0.20287f
C75 a_3209_16334# sg13cmos5l_dfrbpq_1_0.RESET_B 0.01409f
C76 VDD a_17584_13942# 0.13897f
C77 a_6891_14495# sg13cmos5l_dfrbpq_1_2.CLK 0.02479f
C78 a_26373_14495# a_27121_14845# 0.01058f
C79 a_18123_14495# a_18863_14845# 0.17382f
C80 a_16068_14040# a_17327_13799# 0.01412f
C81 sg13cmos5l_buf_8_2.X sg13cmos5l_dfrbpq_1_5.RESET_B 0.10136f
C82 VDD a_1965_14832# 0.305f
C83 a_25930_14452# sg13cmos5l_dfrbpq_1_7.RESET_B 0.17295f
C84 VDD sg13cmos5l_dlygate4sd3_1_4.X 0.58517f
C85 sg13cmos5l_o21ai_1_1.Y a_21348_14909# 0.02008f
C86 sg13cmos5l_dlygate4sd3_1_4.X sg13cmos5l_a21oi_1_0.A1 0.09426f
C87 sg13cmos5l_xor2_1_0.B sg13cmos5l_dfrbpq_1_2.CLK 0.10767f
C88 sg13cmos5l_buf_1_0.X sg13cmos5l_dlygate4sd3_1_8.X 0.15391f
C89 sg13cmos5l_a21oi_1_2.A1 sg13cmos5l_dlygate4sd3_1_17.A 0.07757f
C90 sg13cmos5l_a21oi_1_3.A2 sg13cmos5l_buf_8_2.X 0.01098f
C91 sg13cmos5l_a21oi_1_3.B1 a_18769_14845# 0.01028f
C92 VDD a_19450_15202# 0.27372f
C93 VDD a_22508_15960# 0.22831f
C94 a_27215_14845# a_27882_14484# 0.09257f
C95 a_17327_13799# a_17994_14020# 0.09257f
C96 sg13cmos5l_or3_1_1.X sg13cmos5l_or3_1_1.A 0.269f
C97 sg13cmos5l_dlygate4sd3_1_3.A a_2916_15552# 0.0212f
C98 sg13cmos5l_dfrbpq_1_7.Q sg13cmos5l_buf_8_2.X 0.1448f
C99 sg13cmos5l_or3_1_1.C sg13cmos5l_dfrbpq_1_6.Q 0.13093f
C100 sg13cmos5l_xnor2_1_2.A a_7937_13912# 0.01378f
C101 sg13cmos5l_dfrbpq_1_1.RESET_B sg13cmos5l_buf_1_0.X 0.16585f
C102 a_19054_15423# a_18789_15277# 0.0144f
C103 a_5687_15315# a_5600_15366# 0.03131f
C104 sg13cmos5l_a21oi_1_0.A2 sg13cmos5l_a21oi_1_0.A1 0.83799f
C105 VDD sg13cmos5l_a21oi_1_0.A2 0.3392f
C106 a_18106_15960# a_18454_16374# 0.02803f
C107 sg13cmos5l_a21oi_1_3.B1 sg13cmos5l_dfrbpq_1_6.Q 0.03563f
C108 a_26148_14040# a_27313_13799# 0.25046f
C109 a_27407_13799# a_27664_13942# 0.23043f
C110 a_26667_13844# a_26436_13735# 0.07823f
C111 sg13cmos5l_dlygate4sd3_1_3.A a_4175_15311# 0.04571f
C112 VDD a_25956_14488# 0.07273f
C113 VDD a_18021_14495# 0.24448f
C114 sg13cmos5l_a21oi_1_3.B1 a_17318_14922# 0.01499f
C115 sg13cmos5l_inv_1_0.A sg13cmos5l_or3_1_2.B 0.02593f
C116 sg13cmos5l_and2_1_2.B sg13cmos5l_buf_1_10.X 0.19757f
C117 sg13cmos5l_a21oi_1_3.A1 a_25206_14508# 0.03685f
C118 VDD counter_value_o[1] 0.11682f
C119 sg13cmos5l_dfrbpq_1_6.D sg13cmos5l_dlygate4sd3_1_9.X 0.09017f
C120 sg13cmos5l_dfrbpq_1_6.D sg13cmos5l_dfrbpq_1_6.RESET_B 0.64332f
C121 sg13cmos5l_buf_8_2.A a_18021_14495# 0.01317f
C122 a_6575_13342# sg13cmos5l_dlygate4sd3_1_0.A 0.03821f
C123 a_20603_15532# sg13cmos5l_a21oi_1_1.Y 0.09955f
C124 VDD sg13cmos5l_or3_1_2.A 0.38339f
C125 a_17604_14488# a_18863_14845# 0.01412f
C126 VDD sg13cmos5l_xor2_1_0.X 0.14666f
C127 VDD a_2824_16082# 0.12267f
C128 sg13cmos5l_buf_1_10.X a_6372_14488# 0.01881f
C129 sg13cmos5l_dlygate4sd3_1_4.X sg13cmos5l_a21oi_1_0.A2 0.04461f
C130 a_6891_14495# sg13cmos5l_dlygate4sd3_1_1.A 0.03657f
C131 sg13cmos5l_dlygate4sd3_1_3.A a_5886_15486# 0.03759f
C132 sg13cmos5l_nand3_1_0.Y a_6680_15242# 0.01437f
C133 sg13cmos5l_or3_1_1.A sg13cmos5l_buf_8_2.X 0.02847f
C134 VDD a_26475_14495# 0.20647f
C135 sg13cmos5l_nor2_1_0.B sg13cmos5l_a21oi_1_3.B1 0.08511f
C136 sg13cmos5l_xor2_1_0.B sg13cmos5l_dlygate4sd3_1_1.A 0.01964f
C137 sg13cmos5l_dlygate4sd3_1_0.X a_6080_13854# 0.01464f
C138 sg13cmos5l_inv_1_0.A a_17921_15424# 0.01143f
C139 sg13cmos5l_buf_8_2.X a_19530_14484# 0.02075f
C140 sg13cmos5l_buf_1_10.X a_8298_14484# 0.03737f
C141 a_9158_15234# a_9963_15356# 0.07916f
C142 a_9444_15552# a_9861_15213# 0.28324f
C143 a_22030_15423# a_21824_15366# 0.01604f
C144 a_8685_14832# sg13cmos5l_dlygate4sd3_1_1.A 0.06006f
C145 sg13cmos5l_buf_8_2.X sg13cmos5l_or3_1_2.X 0.02259f
C146 VDD a_16168_15996# 0.22709f
C147 VDD sg13cmos5l_dfrbpq_1_7.D 0.19689f
C148 sg13cmos5l_a21oi_1_0.Y sg13cmos5l_inv_1_0.Y 0.02996f
C149 sg13cmos5l_buf_1_0.X sg13cmos5l_xnor2_1_2.A 0.16524f
C150 sg13cmos5l_or3_1_2.B a_24169_14508# 0.16618f
C151 sg13cmos5l_xor2_1_0.X a_1965_14832# 0.19131f
C152 a_9418_15457# VDD 0.1001f
C153 VDD a_1192_3900# 0.18614f
C154 VDD a_4193_14750# 0.20555f
C155 sg13cmos5l_or3_1_1.A a_25774_15423# 0.01031f
C156 VDD a_26122_13945# 0.09474f
C157 sg13cmos5l_a21oi_1_3.B1 sg13cmos5l_dfrbpq_1_2.D 0.08258f
C158 VDD counter_value_o[0] 0.11896f
C159 a_16969_16020# a_17710_16263# 0.01693f
C160 sg13cmos5l_dfrbpq_1_6.RESET_B sg13cmos5l_o21ai_1_1.Y 0.02262f
C161 a_25930_14452# a_26373_14495# 0.02241f
C162 sg13cmos5l_dfrbpq_1_5.D a_25670_14922# 0.04812f
C163 a_25862_13722# sg13cmos5l_dfrbpq_1_5.RESET_B 0.11402f
C164 VDD a_6789_14495# 0.24623f
C165 sg13cmos5l_or3_1_1.X a_24841_13726# 0.12621f
C166 sg13cmos5l_dfrbpq_1_2.Q a_17892_14909# 0.02394f
C167 a_26373_14495# a_26244_14909# 0.01562f
C168 a_25956_14488# a_26475_14495# 0.20754f
C169 a_27664_13942# sg13cmos5l_dfrbpq_1_5.RESET_B 0.09962f
C170 a_37484_15960# a_37192_16082# 0.01635f
C171 sg13cmos5l_dlygate4sd3_1_8.X a_7888_14726# 0.01017f
C172 sg13cmos5l_buf_1_0.X a_3333_15213# 0.01557f
C173 a_17126_15238# sg13cmos5l_inv_1_0.A 0.01214f
C174 sg13cmos5l_a21oi_1_3.Y sg13cmos5l_dfrbpq_1_5.D 0.30057f
C175 a_21185_15424# a_21466_15202# 0.18796f
C176 VDD sg13cmos5l_dlygate4sd3_1_8.A 0.84676f
C177 sg13cmos5l_buf_1_10.X sg13cmos5l_dfrbpq_1_2.CLK 2.24876f
C178 a_22426_15202# sg13cmos5l_dfrbpq_1_6.Q 0.27955f
C179 sg13cmos5l_buf_1_0.X sg13cmos5l_xor2_1_0.B 0.67613f
C180 a_14261_15238# sg13cmos5l_or3_1_1.B 0.25178f
C181 sg13cmos5l_a21oi_1_0.Y sg13cmos5l_or3_1_1.B 0.21476f
C182 sg13cmos5l_a21oi_1_3.B1 sg13cmos5l_a21oi_1_2.A1 0.05556f
C183 a_3435_15356# sg13cmos5l_dfrbpq_1_0.RESET_B 0.28294f
C184 sg13cmos5l_o21ai_1_2.B1 sg13cmos5l_o21ai_1_2.A2 0.18866f
C185 a_6540_13238# a_6280_13058# 0.01728f
C186 a_26638_15423# sg13cmos5l_a21oi_1_3.Y 0.01596f
C187 sg13cmos5l_a21oi_1_3.B1 a_25670_14922# 0.0136f
C188 sg13cmos5l_dfrbpq_1_1.RESET_B a_7888_14726# 0.09622f
C189 counter_value_o[2] sg13cmos5l_dlygate4sd3_1_8.A 0.01367f
C190 sg13cmos5l_dfrbpq_1_6.D sg13cmos5l_or3_1_2.B 0.02411f
C191 sg13cmos5l_or3_1_1.A a_24824_15238# 0.02528f
C192 VDD a_2528_15366# 0.08632f
C193 a_26565_13701# VDD 0.28166f
C194 a_2540_15960# sg13cmos5l_dfrbpq_1_0.RESET_B 0.0105f
C195 sg13cmos5l_dfrbpq_1_2.RESET_B sg13cmos5l_dfrbpq_1_2.CLK 0.04617f
C196 a_20774_14922# a_21060_14488# 0.26205f
C197 a_18586_15455# a_18789_15277# 0.02453f
C198 sg13cmos5l_a21oi_1_3.B1 sg13cmos5l_a21oi_1_3.Y 0.63581f
C199 a_26753_15424# a_27034_15202# 0.18796f
C200 sg13cmos5l_a21oi_1_3.A1 a_25203_13320# 0.01172f
C201 a_25094_15238# a_25206_15302# 0.3854f
C202 sg13cmos5l_dlygate4sd3_1_17.A sg13cmos5l_o21ai_1_2.B1 0.02204f
C203 a_8694_15302# sg13cmos5l_and2_1_2.X 0.02064f
C204 a_24841_13726# a_24935_14020# 0.02103f
C205 a_24520_13854# a_24704_13854# 0.05762f
C206 a_21060_14488# a_21348_14909# 0.24435f
C207 sg13cmos5l_or3_1_2.B sg13cmos5l_dlygate4sd3_1_5.A 0.19226f
C208 sg13cmos5l_or3_1_1.C a_24704_13854# 0.02884f
C209 sg13cmos5l_buf_1_10.X sg13cmos5l_dlygate4sd3_1_1.A 0.16121f
C210 sg13cmos5l_o21ai_1_2.A2 a_23638_14862# 0.10051f
C211 sg13cmos5l_a21oi_1_3.B1 a_25206_15302# 0.01649f
C212 a_7532_15960# sg13cmos5l_dlygate4sd3_1_1.A 0.19272f
C213 a_16068_14040# sg13cmos5l_dfrbpq_1_2.CLK 0.04723f
C214 a_15671_15315# sg13cmos5l_inv_1_0.A 0.03242f
C215 a_21579_14495# a_22576_14726# 0.03546f
C216 sg13cmos5l_o21ai_1_1.Y sg13cmos5l_or3_1_2.B 0.1545f
C217 VDD sg13cmos5l_dlygate4sd3_1_3.A 1.34734f
C218 a_10703_15311# a_10609_15311# 0.16704f
C219 sg13cmos5l_dfrbpq_1_2.Q sg13cmos5l_dfrbpq_1_3.RESET_B 0.24996f
C220 sg13cmos5l_dfrbpq_1_7.Q a_27034_15202# 0.28887f
C221 sg13cmos5l_dfrbpq_1_7.RESET_B sg13cmos5l_dfrbpq_1_6.Q 0.01935f
C222 sg13cmos5l_inv_1_0.Y a_18106_15960# 0.01212f
C223 a_26170_16237# a_26373_16033# 0.02453f
C224 sg13cmos5l_or3_1_1.B a_16042_13945# 0.0385f
C225 sg13cmos5l_xor2_1_0.B a_2516_14484# 0.01121f
C226 a_9158_15234# sg13cmos5l_nand4_1_0.Y 0.02144f
C227 sg13cmos5l_a21oi_1_0.Y sg13cmos5l_a21oi_1_0.A1 0.0944f
C228 VDD a_14261_15238# 0.49384f
C229 VDD sg13cmos5l_a21oi_1_0.Y 0.26526f
C230 sg13cmos5l_a21oi_1_0.Y sg13cmos5l_buf_8_2.A 0.21299f
C231 sg13cmos5l_nand4_1_0.Y clock_i 0.14857f
C232 a_18769_14845# a_18863_14845# 0.16704f
C233 sg13cmos5l_buf_1_0.X enable_i 0.0337f
C234 a_26249_16334# a_26554_16237# 0.01055f
C235 VDD a_21477_14495# 0.24916f
C236 sg13cmos5l_dfrbpq_1_2.RESET_B sg13cmos5l_nor2_1_0.B 0.07964f
C237 a_15870_15486# a_15671_15549# 0.08889f
C238 sg13cmos5l_or3_1_1.A a_27034_15202# 0.05929f
C239 sg13cmos5l_dlygate4sd3_1_17.A sg13cmos5l_a21oi_1_3.A2 0.05288f
C240 VDD a_27617_15424# 0.20604f
C241 sg13cmos5l_or3_1_1.C a_24408_15552# 0.01124f
C242 a_6891_14495# a_7888_14726# 0.03546f
C243 a_6789_14495# a_7537_14845# 0.01058f
C244 a_21034_14452# sg13cmos5l_or3_1_2.X 0.02296f
C245 VDD a_23552_14570# 0.06435f
C246 a_17057_14832# sg13cmos5l_a21oi_1_0.A1 0.01159f
C247 sg13cmos5l_xnor2_1_2.B sg13cmos5l_dlygate4sd3_1_0.A 0.34813f
C248 a_9963_15356# a_9732_15247# 0.07823f
C249 a_9444_15552# a_10609_15311# 0.25046f
C250 sg13cmos5l_a21oi_1_3.B1 sg13cmos5l_dfrbpq_1_3.RESET_B 0.04636f
C251 VDD a_27882_14484# 0.28095f
C252 a_38536_13854# a_38720_13854# 0.05762f
C253 a_9658_14725# a_9861_14521# 0.02453f
C254 VDD a_26757_16033# 0.07049f
C255 sg13cmos5l_buf_1_0.X sg13cmos5l_buf_1_10.X 0.13688f
C256 a_26565_13701# a_26122_13945# 0.02241f
C257 a_2630_15234# a_3204_15247# 0.18486f
C258 sg13cmos5l_and2_1_2.X sg13cmos5l_nand4_1_0.Y 0.01576f
C259 sg13cmos5l_dfrbpq_1_6.RESET_B a_21060_14488# 0.27212f
C260 VDD a_15870_15486# 0.09411f
C261 a_22030_15423# a_22145_15424# 0.3854f
C262 sg13cmos5l_dfrbpq_1_2.RESET_B sg13cmos5l_dfrbpq_1_2.D 0.3532f
C263 VDD a_5896_13854# 0.14015f
C264 sg13cmos5l_o21ai_1_2.B1 a_26638_15423# 0.10722f
C265 sg13cmos5l_nand3_1_0.Y clock_i 0.04233f
C266 a_10222_14751# a_10016_14570# 0.01604f
C267 sg13cmos5l_dfrbpq_1_3.D sg13cmos5l_dfrbpq_1_2.Q 0.01008f
C268 a_25390_16263# sg13cmos5l_o21ai_1_3.Y 0.01565f
C269 a_2890_15457# a_2630_15234# 0.45119f
C270 sg13cmos5l_dlygate4sd3_1_3.A a_2824_16082# 0.03948f
C271 sg13cmos5l_nor2_1_0.B a_16175_15238# 0.0301f
C272 sg13cmos5l_dfrbpq_1_6.RESET_B a_22319_14845# 0.10879f
C273 sg13cmos5l_or3_1_1.B sg13cmos5l_buf_8_2.X 0.1628f
C274 sg13cmos5l_dlygate4sd3_1_17.A sg13cmos5l_or3_1_1.A 0.15251f
C275 VDD a_10222_14751# 0.16191f
C276 a_4432_15454# a_4842_15532# 0.07015f
C277 VDD a_25390_16263# 0.16049f
C278 sg13cmos5l_tiehi_1.L_HI sg13cmos5l_dfrbpq_1_2.CLK 0.04608f
C279 a_8312_15238# sg13cmos5l_xnor2_1_0.Y 0.30653f
C280 sg13cmos5l_dlygate4sd3_1_0.X sg13cmos5l_dfrbpq_1_2.CLK 0.03779f
C281 sg13cmos5l_o21ai_1_2.B1 sg13cmos5l_or3_1_1.C 0.46973f
C282 a_5504_14570# sg13cmos5l_buf_1_10.X 0.02387f
C283 VDD sg13cmos5l_a21oi_1_1.Y 0.38748f
C284 VDD a_16042_13945# 0.09565f
C285 sg13cmos5l_or3_1_1.X a_24923_15996# 0.06735f
C286 VDD a_11370_15532# 0.27891f
C287 a_16042_13945# a_15782_13722# 0.45119f
C288 sg13cmos5l_a21oi_1_3.B1 sg13cmos5l_o21ai_1_2.B1 0.01704f
C289 a_23168_15366# sg13cmos5l_dfrbpq_1_2.Q 0.02676f
C290 a_37192_16082# counter_value_o[7] 0.02116f
C291 a_18586_15455# sg13cmos5l_dfrbpq_1_3.RESET_B 0.04249f
C292 a_22149_16033# a_22025_16334# 0.08186f
C293 a_2916_15552# a_3435_15356# 0.20773f
C294 a_26638_15423# a_26753_15424# 0.3854f
C295 a_3209_16334# a_3333_16033# 0.08186f
C296 a_3130_16237# a_3008_16082# 0.01854f
C297 a_16485_13701# a_16587_13844# 0.36168f
C298 a_23960_15242# sg13cmos5l_dfrbpq_1_6.Q 0.01412f
C299 a_25670_14922# sg13cmos5l_dfrbpq_1_7.RESET_B 0.07823f
C300 sg13cmos5l_dfrbpq_1_5.D sg13cmos5l_dfrbpq_1_5.RESET_B 0.09565f
C301 sg13cmos5l_dfrbpq_1_3.D sg13cmos5l_a21oi_1_3.B1 0.03309f
C302 a_16140_15424# sg13cmos5l_dfrbpq_1_2.Q 0.03116f
C303 sg13cmos5l_or3_1_1.X sg13cmos5l_o21ai_1_3.Y 0.04258f
C304 a_24824_14525# sg13cmos5l_buf_8_2.X 0.01711f
C305 VDD a_18665_15180# 0.0736f
C306 sg13cmos5l_dfrbpq_1_6.RESET_B a_21562_15960# 0.04463f
C307 VDD a_21946_16237# 0.09557f
C308 a_16485_13701# a_16356_13735# 0.01562f
C309 a_26148_14040# a_26667_13844# 0.20773f
C310 a_3435_15356# a_4175_15311# 0.17382f
C311 a_26638_15423# sg13cmos5l_dfrbpq_1_5.RESET_B 0.01351f
C312 VDD sg13cmos5l_or3_1_1.X 0.43882f
C313 sg13cmos5l_dfrbpq_1_3.Q a_19530_14484# 0.08004f
C314 sg13cmos5l_buf_1_0.X a_2490_14447# 0.09015f
C315 sg13cmos5l_buf_1_10.X a_1192_9948# 0.15509f
C316 a_17710_16263# a_17825_16262# 0.3854f
C317 a_15579_14854# clock_i 0.3255f
C318 a_21185_15424# a_21070_15423# 0.3854f
C319 a_9963_15356# VDD 0.20809f
C320 a_26148_14040# a_26436_13735# 0.24435f
C321 sg13cmos5l_a21oi_1_3.Y sg13cmos5l_dfrbpq_1_7.RESET_B 0.10426f
C322 sg13cmos5l_dlygate4sd3_1_4.X a_18665_15180# 0.04007f
C323 VDD a_17578_14452# 0.09602f
C324 a_5687_15549# sg13cmos5l_dfrbpq_1_1.RESET_B 0.01133f
C325 sg13cmos5l_xnor2_1_2.A sg13cmos5l_dlygate4sd3_1_0.A 0.09582f
C326 a_21281_16262# sg13cmos5l_dfrbpq_1_6.RESET_B 0.02115f
C327 sg13cmos5l_buf_8_2.A a_17578_14452# 0.01404f
C328 sg13cmos5l_dfrbpq_1_2.D a_15338_14484# 0.01367f
C329 a_6540_13238# sg13cmos5l_dlygate4sd3_1_0.A 0.12959f
C330 VDD a_18106_15960# 0.28888f
C331 sg13cmos5l_or3_1_1.C sg13cmos5l_a21oi_1_3.A2 0.14595f
C332 a_27407_13799# a_27313_13799# 0.16704f
C333 a_1192_9948# reset_n_i 0.19796f
C334 a_17604_14488# a_18123_14495# 0.20754f
C335 VDD a_3209_16334# 0.10631f
C336 VDD sg13cmos5l_buf_8_2.X 1.73258f
C337 sg13cmos5l_buf_8_2.A sg13cmos5l_buf_8_2.X 0.17028f
C338 sg13cmos5l_or3_1_2.B a_21060_14488# 0.01273f
C339 sg13cmos5l_dlygate4sd3_1_0.X a_6286_13911# 0.10725f
C340 a_17806_15423# sg13cmos5l_dfrbpq_1_3.RESET_B 0.05914f
C341 VDD a_22030_15423# 0.16094f
C342 sg13cmos5l_buf_8_2.X a_19120_14726# 0.01548f
C343 sg13cmos5l_or3_1_2.B sg13cmos5l_dfrbpq_1_6.Q 0.20181f
C344 sg13cmos5l_buf_1_10.X a_7888_14726# 0.01264f
C345 sg13cmos5l_dfrbpq_1_2.Q sg13cmos5l_or3_1_2.X 0.33145f
C346 a_9158_15234# a_9444_15552# 0.26205f
C347 sg13cmos5l_or3_1_1.A a_26638_15423# 0.01026f
C348 sg13cmos5l_dlygate4sd3_1_4.X a_18106_15960# 0.01488f
C349 a_3333_15213# sg13cmos5l_dfrbpq_1_0.RESET_B 0.03853f
C350 VDD a_19232_13854# 0.06399f
C351 sg13cmos5l_buf_8_2.A a_19232_13854# 0.0236f
C352 a_21185_15424# sg13cmos5l_or3_1_2.X 0.02913f
C353 VDD a_38536_10034# 0.1399f
C354 VDD a_2942_14484# 0.01096f
C355 sg13cmos5l_tiehi_1.L_HI a_10960_15454# 0.09962f
C356 sg13cmos5l_and2_1_2.X sg13cmos5l_dlygate4sd3_1_8.X 0.03283f
C357 sg13cmos5l_or3_1_1.A a_25094_15238# 0.04844f
C358 VDD a_25774_15423# 0.15949f
C359 sg13cmos5l_nor2_1_0.B sg13cmos5l_or3_1_2.B 0.03734f
C360 a_4432_15454# sg13cmos5l_dfrbpq_1_0.RESET_B 0.09976f
C361 sg13cmos5l_or3_1_1.C sg13cmos5l_or3_1_1.A 0.19409f
C362 sg13cmos5l_dfrbpq_1_6.D sg13cmos5l_o21ai_1_1.Y 0.09542f
C363 a_8694_15302# VDD 0.15959f
C364 a_25670_14922# a_26373_14495# 0.02431f
C365 sg13cmos5l_a21oi_1_3.B1 sg13cmos5l_or3_1_1.A 0.13946f
C366 a_17578_14452# a_18021_14495# 0.02241f
C367 sg13cmos5l_nand4_1_0.Y sg13cmos5l_or3_1_1.B 0.01086f
C368 sg13cmos5l_or3_1_2.C a_21579_14495# 0.01468f
C369 sg13cmos5l_xnor2_1_2.B a_6202_15238# 0.01843f
C370 a_2516_14484# a_2490_14447# 0.21976f
C371 VDD a_6346_14452# 0.09662f
C372 sg13cmos5l_o21ai_1_2.Y a_24169_14508# 0.05936f
C373 a_24824_15238# a_24824_14525# 0.01163f
C374 sg13cmos5l_a21oi_1_3.B1 sg13cmos5l_or3_1_2.X 0.02158f
C375 a_25956_14488# sg13cmos5l_buf_8_2.X 0.09542f
C376 sg13cmos5l_inv_1_0.A sg13cmos5l_dfrbpq_1_2.CLK 0.34455f
C377 a_18021_14495# sg13cmos5l_buf_8_2.X 0.20547f
C378 counter_value_o[5] a_27296_16082# 0.01377f
C379 VDD a_7631_14845# 0.17872f
C380 sg13cmos5l_or3_1_2.A sg13cmos5l_buf_8_2.X 0.58091f
C381 a_26475_14495# sg13cmos5l_buf_8_2.X 0.0491f
C382 sg13cmos5l_tiehi_1.L_HI a_9861_15213# 0.03738f
C383 a_22030_15423# sg13cmos5l_or3_1_2.A 0.10722f
C384 VDD a_12524_15960# 0.22898f
C385 VDD a_7680_15549# 0.1878f
C386 a_11370_15532# sg13cmos5l_dlygate4sd3_1_8.A 0.09118f
C387 sg13cmos5l_a21oi_1_3.B1 clock_i 0.02814f
C388 sg13cmos5l_o21ai_1_3.Y a_24824_15238# 0.03926f
C389 sg13cmos5l_dfrbpq_1_7.D sg13cmos5l_buf_8_2.X 0.01301f
C390 counter_value_o[2] a_12524_15960# 0.15504f
C391 sg13cmos5l_inv_1_0.Y a_15579_14854# 0.02441f
C392 VDD a_24824_15238# 0.26964f
C393 a_25862_13722# VDD 0.53201f
C394 a_6086_14922# a_6660_14909# 0.18486f
C395 sg13cmos5l_dfrbpq_1_5.Q a_27898_15202# 0.2865f
C396 sg13cmos5l_buf_1_0.X a_4081_15311# 0.0102f
C397 a_18863_14845# sg13cmos5l_dfrbpq_1_3.RESET_B 0.10879f
C398 sg13cmos5l_o21ai_1_2.B1 sg13cmos5l_dfrbpq_1_7.RESET_B 0.02543f
C399 a_20603_15532# sg13cmos5l_a21oi_1_3.B1 0.03672f
C400 a_5613_14832# sg13cmos5l_and2_1_1.X 0.08726f
C401 a_27664_13942# VDD 0.14131f
C402 sg13cmos5l_or3_1_2.C sg13cmos5l_or3_1_2.X 0.02676f
C403 sg13cmos5l_buf_1_0.X sg13cmos5l_and2_1_0.X 0.11175f
C404 a_25774_15423# sg13cmos5l_dfrbpq_1_7.D 0.10701f
C405 a_25206_14508# a_25094_14484# 0.3854f
C406 sg13cmos5l_dfrbpq_1_1.RESET_B a_5886_15486# 0.04267f
C407 a_21477_14495# a_22225_14845# 0.01058f
C408 a_20774_14922# a_21579_14495# 0.07916f
C409 sg13cmos5l_or3_1_1.C a_24841_13726# 0.14829f
C410 a_9963_15356# sg13cmos5l_dlygate4sd3_1_8.A 0.0308f
C411 VDD sg13cmos5l_nand4_1_0.Y 1.02388f
C412 a_38536_13854# VDD 0.13998f
C413 a_7829_15238# a_7680_15549# 0.19075f
C414 sg13cmos5l_nand4_1_0.Y sg13cmos5l_buf_8_2.A 0.03656f
C415 a_27898_15202# sg13cmos5l_dfrbpq_1_6.Q 0.012f
C416 VDD a_3435_15356# 0.20564f
C417 a_12010_15202# sg13cmos5l_dfrbpq_1_2.CLK 0.67763f
C418 a_21348_14909# a_21579_14495# 0.07823f
C419 a_21466_15202# sg13cmos5l_or3_1_2.B 0.05836f
C420 VDD a_2540_15960# 0.19767f
C421 sg13cmos5l_dfrbpq_1_2.Q a_18202_15202# 0.34354f
C422 a_27500_15960# sg13cmos5l_dfrbpq_1_6.Q 0.19565f
C423 sg13cmos5l_inv_1_0.Y a_16969_16020# 0.16895f
C424 a_20000_15366# sg13cmos5l_dfrbpq_1_2.Q 0.02435f
C425 sg13cmos5l_dfrbpq_1_3.Q a_22145_15424# 0.01469f
C426 sg13cmos5l_or3_1_1.B a_15579_14854# 0.05153f
C427 sg13cmos5l_xor2_1_0.B a_4078_14751# 0.11637f
C428 VDD a_37192_16082# 0.16744f
C429 sg13cmos5l_dfrbpq_1_2.Q sg13cmos5l_inv_1_0.Y 0.06528f
C430 sg13cmos5l_and2_1_2.X a_8685_14832# 0.07413f
C431 a_12010_15202# a_11752_15366# 0.01836f
C432 sg13cmos5l_dfrbpq_1_7.RESET_B sg13cmos5l_dfrbpq_1_5.RESET_B 0.12636f
C433 a_26170_16237# sg13cmos5l_dfrbpq_1_7.RESET_B 0.0434f
C434 sg13cmos5l_or3_1_1.B a_16587_13844# 0.03034f
C435 a_26565_13701# sg13cmos5l_buf_8_2.X 0.21461f
C436 VDD sg13cmos5l_nand3_1_0.Y 0.70369f
C437 a_6346_14452# a_6789_14495# 0.02241f
C438 a_26249_16334# sg13cmos5l_dfrbpq_1_5.RESET_B 0.01855f
C439 sg13cmos5l_or3_1_2.C a_21251_13690# 0.16807f
C440 a_26249_16334# a_26170_16237# 0.08889f
C441 VDD a_21034_14452# 0.09647f
C442 sg13cmos5l_or3_1_1.A a_24310_15230# 0.02324f
C443 VDD a_27034_15202# 0.25715f
C444 sg13cmos5l_dlygate4sd3_1_17.A a_24824_14525# 0.29888f
C445 VDD a_7240_16082# 0.1655f
C446 sg13cmos5l_or3_1_1.B a_16356_13735# 0.01005f
C447 sg13cmos5l_dfrbpq_1_3.Q counter_value_o[4] 0.01007f
C448 VDD a_27296_16082# 0.10061f
C449 sg13cmos5l_dfrbpq_1_7.Q sg13cmos5l_dfrbpq_1_7.RESET_B 0.0164f
C450 a_14344_14570# sg13cmos5l_buf_1_10.X 0.03427f
C451 a_2916_15552# a_3333_15213# 0.28324f
C452 VDD sg13cmos5l_o21ai_1_2.A2 0.55223f
C453 a_6660_14909# a_6891_14495# 0.07823f
C454 a_6286_13911# a_6080_13854# 0.01604f
C455 sg13cmos5l_dlygate4sd3_1_17.A a_24923_15996# 0.11419f
C456 a_20774_14922# sg13cmos5l_or3_1_2.X 0.02499f
C457 VDD a_22576_14726# 0.13981f
C458 sg13cmos5l_xor2_1_0.B a_2916_15552# 0.01285f
C459 sg13cmos5l_xor2_1_0.B a_6660_14909# 0.023f
C460 sg13cmos5l_xnor2_1_2.B a_6401_13912# 0.03894f
C461 a_9444_15552# a_9732_15247# 0.24435f
C462 sg13cmos5l_and2_1_0.X a_2516_14484# 0.03166f
C463 a_22145_15424# sg13cmos5l_dfrbpq_1_2.Q 0.01328f
C464 VDD a_26373_16033# 0.0659f
C465 a_7631_14845# a_7537_14845# 0.16704f
C466 a_25862_13722# a_26122_13945# 0.45119f
C467 a_6682_13690# sg13cmos5l_dlygate4sd3_1_0.A 0.31148f
C468 a_17318_14922# a_18123_14495# 0.07916f
C469 sg13cmos5l_or3_1_1.A a_25206_14508# 0.0186f
C470 VDD a_16856_15238# 0.28158f
C471 a_16856_15238# sg13cmos5l_a21oi_1_0.A1 0.067f
C472 sg13cmos5l_dfrbpq_1_6.D a_21060_14488# 0.03479f
C473 VDD a_7822_13911# 0.16525f
C474 VDD a_38720_14570# 0.08963f
C475 a_17238_15302# sg13cmos5l_dfrbpq_1_2.Q 0.01082f
C476 sg13cmos5l_or3_1_1.A sg13cmos5l_dfrbpq_1_7.RESET_B 0.02533f
C477 sg13cmos5l_o21ai_1_3.Y sg13cmos5l_dlygate4sd3_1_17.A 0.0459f
C478 VDD sg13cmos5l_xnor2_1_2.B 0.63659f
C479 sg13cmos5l_buf_1_10.X a_1856_14570# 0.02603f
C480 a_2540_15960# a_2824_16082# 0.01225f
C481 a_18769_14845# a_17604_14488# 0.25046f
C482 a_9418_15457# sg13cmos5l_nand4_1_0.Y 0.01592f
C483 a_16140_15424# a_16175_15238# 0.19075f
C484 sg13cmos5l_dfrbpq_1_6.RESET_B a_21579_14495# 0.27969f
C485 sg13cmos5l_or3_1_1.B sg13cmos5l_dfrbpq_1_2.Q 0.01742f
C486 a_12524_15960# sg13cmos5l_dlygate4sd3_1_8.A 0.1978f
C487 a_4175_15311# a_4432_15454# 0.23043f
C488 VDD a_9536_14570# 0.10026f
C489 VDD sg13cmos5l_dlygate4sd3_1_17.A 0.29477f
C490 sg13cmos5l_dfrbpq_1_2.RESET_B a_16485_13701# 0.0353f
C491 sg13cmos5l_dlygate4sd3_1_8.X a_9737_14822# 0.02198f
C492 VDD a_21166_16263# 0.15938f
C493 VDD a_10703_15311# 0.19385f
C494 sg13cmos5l_buf_1_10.X clock_i 0.01285f
C495 VDD a_15579_14854# 0.86798f
C496 sg13cmos5l_dfrbpq_1_2.D a_15680_13854# 0.03989f
C497 sg13cmos5l_and2_1_2.B sg13cmos5l_dfrbpq_1_2.CLK 0.03578f
C498 counter_value_o[1] a_7240_16082# 0.02116f
C499 sg13cmos5l_buf_8_2.A a_15579_14854# 0.68123f
C500 sg13cmos5l_or3_1_2.A a_21034_14452# 0.02529f
C501 sg13cmos5l_dlygate4sd3_1_8.X a_10016_14570# 0.01314f
C502 sg13cmos5l_dlygate4sd3_1_9.X a_21070_15423# 0.10667f
C503 sg13cmos5l_dfrbpq_1_6.RESET_B a_21070_15423# 0.05075f
C504 a_17921_15424# sg13cmos5l_dfrbpq_1_3.RESET_B 0.07437f
C505 a_18202_15202# a_18586_15455# 0.01303f
C506 a_21477_14495# sg13cmos5l_buf_8_2.X 0.21497f
C507 a_17318_14922# a_17604_14488# 0.26205f
C508 VDD a_16587_13844# 0.21312f
C509 a_6372_14488# sg13cmos5l_dfrbpq_1_2.CLK 0.08815f
C510 sg13cmos5l_dlygate4sd3_1_8.X VDD 0.35396f
C511 a_15782_13722# a_16587_13844# 0.07916f
C512 a_16068_14040# a_16485_13701# 0.28324f
C513 a_2540_15960# counter_value_o[0] 0.15504f
C514 a_26373_14495# sg13cmos5l_dfrbpq_1_5.RESET_B 0.01805f
C515 sg13cmos5l_o21ai_1_1.Y a_21060_14488# 0.0268f
C516 sg13cmos5l_or3_1_1.C sg13cmos5l_or3_1_1.B 0.12764f
C517 a_24169_14508# a_24365_14508# 0.01485f
C518 sg13cmos5l_or3_1_1.X a_25390_16263# 0.03003f
C519 VDD sg13cmos5l_dfrbpq_1_3.Q 1.10993f
C520 VDD a_19054_15423# 0.15932f
C521 counter_value_o[3] a_16969_16020# 0.08229f
C522 a_21946_16237# sg13cmos5l_a21oi_1_1.Y 0.03498f
C523 VDD a_20960_16082# 0.08507f
C524 sg13cmos5l_dfrbpq_1_2.RESET_B clock_i 0.18083f
C525 sg13cmos5l_o21ai_1_1.Y sg13cmos5l_dfrbpq_1_6.Q 0.01042f
C526 sg13cmos5l_a21oi_1_3.B1 sg13cmos5l_or3_1_1.B 0.03473f
C527 a_18863_14845# a_19530_14484# 0.09257f
C528 a_15782_13722# a_16356_13735# 0.18486f
C529 a_16587_13844# a_17584_13942# 0.03412f
C530 a_25862_13722# a_26565_13701# 0.02453f
C531 sg13cmos5l_dfrbpq_1_1.RESET_B VDD 1.16726f
C532 sg13cmos5l_dfrbpq_1_2.Q counter_value_o[3] 0.01238f
C533 sg13cmos5l_nand4_1_0.Y sg13cmos5l_dlygate4sd3_1_8.A 0.30072f
C534 sg13cmos5l_o21ai_1_2.B1 sg13cmos5l_or3_1_2.B 0.35664f
C535 sg13cmos5l_dfrbpq_1_7.Q a_26373_14495# 0.01321f
C536 sg13cmos5l_and2_1_2.X sg13cmos5l_buf_1_10.X 0.01634f
C537 sg13cmos5l_a21oi_1_3.B1 a_20278_14862# 0.01435f
C538 a_5613_14832# sg13cmos5l_buf_1_10.X 0.09367f
C539 a_8312_15238# sg13cmos5l_dfrbpq_1_2.CLK 0.01101f
C540 a_9444_15552# VDD 0.0722f
C541 a_26667_13844# a_27407_13799# 0.17382f
C542 a_26170_15202# sg13cmos5l_dfrbpq_1_7.RESET_B 0.03678f
C543 a_27215_14845# sg13cmos5l_dfrbpq_1_7.RESET_B 0.10879f
C544 sg13cmos5l_dlygate4sd3_1_4.X a_19054_15423# 0.10798f
C545 VDD a_6086_14922# 0.52224f
C546 sg13cmos5l_dfrbpq_1_7.Q a_27472_14726# 0.01873f
C547 sg13cmos5l_dlygate4sd3_1_9.X sg13cmos5l_or3_1_2.X 0.17041f
C548 sg13cmos5l_dfrbpq_1_3.Q a_19450_15202# 0.28632f
C549 sg13cmos5l_dfrbpq_1_6.RESET_B sg13cmos5l_or3_1_2.X 0.36966f
C550 a_22508_15960# sg13cmos5l_dfrbpq_1_3.Q 0.19275f
C551 VDD a_16969_16020# 0.24435f
C552 a_16969_16020# sg13cmos5l_a21oi_1_0.A1 0.01278f
C553 sg13cmos5l_xnor2_1_2.B a_6714_12972# 0.01001f
C554 a_7829_15238# sg13cmos5l_dlygate4sd3_1_8.X 0.02577f
C555 sg13cmos5l_dfrbpq_1_2.Q sg13cmos5l_a21oi_1_0.A1 0.1004f
C556 VDD sg13cmos5l_dfrbpq_1_2.Q 1.33086f
C557 a_6372_14488# sg13cmos5l_dlygate4sd3_1_1.A 0.03332f
C558 VDD sg13cmos5l_dfrbpq_1_5.D 0.42253f
C559 sg13cmos5l_buf_8_2.A sg13cmos5l_dfrbpq_1_2.Q 0.04399f
C560 a_17063_16020# a_16969_16020# 0.02103f
C561 sg13cmos5l_a21oi_1_3.B1 a_24923_15996# 0.01453f
C562 VDD a_21185_15424# 0.20696f
C563 a_17892_14909# a_18123_14495# 0.07823f
C564 sg13cmos5l_xnor2_1_2.A VDD 0.73342f
C565 VDD a_6540_13238# 0.19533f
C566 a_2630_15234# sg13cmos5l_dfrbpq_1_0.RESET_B 0.10309f
C567 sg13cmos5l_dlygate4sd3_1_4.X a_16969_16020# 0.2162f
C568 a_8298_14484# sg13cmos5l_dlygate4sd3_1_1.A 0.09568f
C569 sg13cmos5l_or3_1_1.A a_25889_15424# 0.01269f
C570 VDD a_26638_15423# 0.15952f
C571 sg13cmos5l_nand3_1_0.Y a_7923_15532# 0.01019f
C572 sg13cmos5l_or3_1_2.B a_23638_14862# 0.06579f
C573 sg13cmos5l_or3_1_2.B a_21579_14495# 0.01018f
C574 sg13cmos5l_or3_1_2.C sg13cmos5l_or3_1_1.B 0.09208f
C575 sg13cmos5l_dfrbpq_1_2.Q sg13cmos5l_dlygate4sd3_1_4.X 0.07532f
C576 sg13cmos5l_inv_1_0.A sg13cmos5l_dfrbpq_1_3.RESET_B 0.03151f
C577 sg13cmos5l_o21ai_1_3.Y sg13cmos5l_or3_1_1.C 0.05321f
C578 sg13cmos5l_dfrbpq_1_2.Q a_19450_15202# 0.02358f
C579 VDD sg13cmos5l_and2_1_1.X 0.27664f
C580 VDD a_38720_13058# 0.09066f
C581 VDD a_4474_14448# 0.29254f
C582 sg13cmos5l_or3_1_2.C a_20278_14862# 0.06102f
C583 VDD a_25094_15238# 0.20673f
C584 VDD a_24520_13854# 0.14054f
C585 a_16140_15424# sg13cmos5l_or3_1_2.B 0.23811f
C586 sg13cmos5l_a21oi_1_3.B1 sg13cmos5l_o21ai_1_3.Y 0.37884f
C587 VDD sg13cmos5l_or3_1_1.C 0.82343f
C588 a_22145_15424# a_22426_15202# 0.18796f
C589 a_28074_14020# sg13cmos5l_dfrbpq_1_5.Q 0.07823f
C590 a_16969_16020# sg13cmos5l_a21oi_1_0.A2 0.13879f
C591 sg13cmos5l_or3_1_1.X sg13cmos5l_buf_8_2.X 0.02628f
C592 a_20603_15532# sg13cmos5l_dlygate4sd3_1_9.X 0.06946f
C593 a_25670_14922# a_25930_14452# 0.45119f
C594 sg13cmos5l_a21oi_1_3.B1 sg13cmos5l_a21oi_1_0.A1 0.06245f
C595 VDD sg13cmos5l_a21oi_1_3.B1 1.64688f
C596 sg13cmos5l_or3_1_2.C a_20376_14464# 0.01238f
C597 sg13cmos5l_dfrbpq_1_2.Q sg13cmos5l_a21oi_1_0.A2 0.02237f
C598 sg13cmos5l_o21ai_1_2.Y sg13cmos5l_dfrbpq_1_6.Q 0.02669f
C599 sg13cmos5l_a21oi_1_3.B1 sg13cmos5l_buf_8_2.A 0.56082f
C600 sg13cmos5l_dlygate4sd3_1_3.A a_3435_15356# 0.0271f
C601 a_32200_16082# counter_value_o[6] 0.02116f
C602 sg13cmos5l_nand4_1_0.Y a_14261_15238# 0.23765f
C603 sg13cmos5l_dfrbpq_1_2.Q a_18021_14495# 0.02098f
C604 a_25670_14922# a_26244_14909# 0.18486f
C605 a_17604_14488# a_17892_14909# 0.24435f
C606 sg13cmos5l_or3_1_2.B a_18454_16374# 0.0782f
C607 sg13cmos5l_and2_1_0.X sg13cmos5l_dfrbpq_1_0.RESET_B 0.07063f
C608 sg13cmos5l_or3_1_2.A sg13cmos5l_dfrbpq_1_2.Q 0.09838f
C609 VDD a_3333_15213# 0.28955f
C610 a_26667_13844# sg13cmos5l_dfrbpq_1_5.RESET_B 0.28617f
C611 VDD a_6891_14495# 0.20627f
C612 a_2540_15960# sg13cmos5l_dlygate4sd3_1_3.A 0.19598f
C613 sg13cmos5l_a21oi_1_3.Y a_25930_14452# 0.0453f
C614 a_17126_15238# sg13cmos5l_dfrbpq_1_3.D 0.02016f
C615 sg13cmos5l_dlygate4sd3_1_8.X a_6789_14495# 0.01594f
C616 a_17238_15302# a_17806_15423# 0.01641f
C617 sg13cmos5l_xor2_1_0.B VDD 0.49614f
C618 a_9418_15457# a_9444_15552# 0.24169f
C619 sg13cmos5l_tiehi_1.L_HI a_9158_15234# 0.08086f
C620 a_21185_15424# sg13cmos5l_or3_1_2.A 0.01897f
C621 sg13cmos5l_dfrbpq_1_2.RESET_B sg13cmos5l_inv_1_0.Y 0.01813f
C622 a_10703_15311# sg13cmos5l_dlygate4sd3_1_8.A 0.05509f
C623 sg13cmos5l_dfrbpq_1_2.CLK sg13cmos5l_dlygate4sd3_1_1.A 0.27858f
C624 VDD a_8685_14832# 0.28623f
C625 a_16068_14040# a_17233_13799# 0.25046f
C626 VDD a_4432_15454# 0.13966f
C627 sg13cmos5l_dfrbpq_1_2.Q a_16168_15996# 0.01748f
C628 a_27472_14726# a_27215_14845# 0.23043f
C629 sg13cmos5l_dlygate4sd3_1_8.X a_7537_14845# 0.02247f
C630 sg13cmos5l_a21oi_1_3.Y a_26244_14909# 0.01169f
C631 a_25889_15424# a_26170_15202# 0.18796f
C632 sg13cmos5l_dfrbpq_1_3.D sg13cmos5l_inv_1_0.A 0.1171f
C633 sg13cmos5l_dfrbpq_1_7.D sg13cmos5l_dfrbpq_1_5.D 0.03838f
C634 sg13cmos5l_nand3_1_0.Y sg13cmos5l_dlygate4sd3_1_3.A 0.01196f
C635 sg13cmos5l_dfrbpq_1_1.RESET_B a_6789_14495# 0.03692f
C636 sg13cmos5l_or3_1_2.B sg13cmos5l_or3_1_2.X 0.03269f
C637 sg13cmos5l_a21oi_1_3.B1 sg13cmos5l_a21oi_1_0.A2 0.02675f
C638 sg13cmos5l_inv_1_0.Y a_17825_16262# 0.01405f
C639 a_21466_15202# sg13cmos5l_o21ai_1_1.Y 0.28384f
C640 VDD a_18586_15455# 0.09516f
C641 sg13cmos5l_dlygate4sd3_1_8.X a_7262_15242# 0.01812f
C642 sg13cmos5l_buf_1_0.X a_7160_15242# 0.01376f
C643 sg13cmos5l_o21ai_1_2.B1 a_24169_14508# 0.24209f
C644 sg13cmos5l_a21oi_1_3.B1 a_18021_14495# 0.01249f
C645 VDD sg13cmos5l_or3_1_2.C 0.6831f
C646 sg13cmos5l_nor2_1_0.B sg13cmos5l_dfrbpq_1_2.CLK 0.18311f
C647 a_6086_14922# a_6789_14495# 0.02431f
C648 sg13cmos5l_buf_1_0.X a_3204_15247# 0.01531f
C649 sg13cmos5l_or3_1_2.C a_20218_15238# 0.01849f
C650 a_18123_14495# sg13cmos5l_dfrbpq_1_3.RESET_B 0.28174f
C651 a_21251_13690# a_21549_14020# 0.02103f
C652 sg13cmos5l_dfrbpq_1_5.Q sg13cmos5l_dfrbpq_1_6.Q 0.01209f
C653 sg13cmos5l_or3_1_2.A sg13cmos5l_a21oi_1_3.B1 0.01884f
C654 a_17327_13799# sg13cmos5l_dfrbpq_1_3.RESET_B 0.01722f
C655 sg13cmos5l_a21oi_1_3.A1 sg13cmos5l_a21oi_1_3.Y 0.35f
C656 sg13cmos5l_inv_1_0.Y a_16175_15238# 0.01129f
C657 sg13cmos5l_tiehi_1.L_HI sg13cmos5l_and2_1_2.X 0.10137f
C658 a_21034_14452# a_21477_14495# 0.02241f
C659 a_9444_15552# sg13cmos5l_dlygate4sd3_1_8.A 0.02593f
C660 a_22986_14484# sg13cmos5l_dfrbpq_1_6.Q 0.08106f
C661 sg13cmos5l_dlygate4sd3_1_0.X a_5613_14832# 0.20961f
C662 a_4474_14448# a_4193_14750# 0.18796f
C663 sg13cmos5l_nand4_1_0.Y a_11370_15532# 0.01256f
C664 sg13cmos5l_a21oi_1_3.B1 sg13cmos5l_dfrbpq_1_7.D 0.26997f
C665 a_27502_15423# sg13cmos5l_dfrbpq_1_6.Q 0.0569f
C666 a_25206_15302# sg13cmos5l_a21oi_1_3.A1 0.11555f
C667 sg13cmos5l_xnor2_1_2.A a_6789_14495# 0.02956f
C668 a_16856_15238# sg13cmos5l_a21oi_1_0.Y 0.27231f
C669 a_16140_15424# sg13cmos5l_inv_1_0.A 0.01251f
C670 sg13cmos5l_xnor2_1_2.B sg13cmos5l_dlygate4sd3_1_3.A 0.11793f
C671 a_22986_14484# a_23368_14570# 0.01648f
C672 a_22319_14845# a_22986_14484# 0.09257f
C673 a_21060_14488# a_22319_14845# 0.01412f
C674 sg13cmos5l_xor2_1_0.B sg13cmos5l_xor2_1_0.X 0.07025f
C675 sg13cmos5l_dfrbpq_1_2.RESET_B sg13cmos5l_or3_1_1.B 0.15658f
C676 a_38536_3986# a_38720_3986# 0.05762f
C677 a_23368_14570# sg13cmos5l_dfrbpq_1_6.Q 0.0251f
C678 VDD a_22426_15202# 0.29669f
C679 sg13cmos5l_or3_1_2.B a_21251_13690# 0.15851f
C680 sg13cmos5l_buf_1_0.X sg13cmos5l_dfrbpq_1_2.CLK 0.05368f
C681 a_8582_15238# sg13cmos5l_and2_1_2.B 0.01938f
C682 a_17604_14488# sg13cmos5l_dfrbpq_1_3.RESET_B 0.30415f
C683 sg13cmos5l_dlygate4sd3_1_1.A a_7937_13912# 0.02056f
C684 VDD a_17806_15423# 0.1592f
C685 a_24169_14508# sg13cmos5l_a21oi_1_3.A2 0.12591f
C686 sg13cmos5l_a21oi_1_0.Y a_15579_14854# 0.03237f
C687 sg13cmos5l_or3_1_2.C sg13cmos5l_or3_1_2.A 0.72302f
C688 VDD enable_i 0.25464f
C689 sg13cmos5l_or3_1_1.B a_16068_14040# 0.03267f
C690 sg13cmos5l_xor2_1_0.B a_4193_14750# 0.01654f
C691 sg13cmos5l_o21ai_1_3.Y a_24310_15230# 0.06016f
C692 a_9963_15356# sg13cmos5l_nand4_1_0.Y 0.02274f
C693 VDD a_20774_14922# 0.52379f
C694 a_9861_15213# sg13cmos5l_dfrbpq_1_2.CLK 0.21068f
C695 sg13cmos5l_dfrbpq_1_7.Q a_27121_14845# 0.02056f
C696 sg13cmos5l_or3_1_1.B a_16175_15238# 0.02065f
C697 sg13cmos5l_or3_1_1.B a_17994_14020# 0.01534f
C698 a_2630_15234# a_2916_15552# 0.26205f
C699 a_8218_13690# sg13cmos5l_dlygate4sd3_1_1.A 0.30158f
C700 sg13cmos5l_dfrbpq_1_1.RESET_B sg13cmos5l_dlygate4sd3_1_3.A 0.14117f
C701 a_6789_14495# a_6891_14495# 0.3643f
C702 a_32492_15960# a_32200_16082# 0.01635f
C703 sg13cmos5l_inv_1_0.Y a_16552_15996# 0.01509f
C704 a_8582_15238# a_8312_15238# 0.18796f
C705 sg13cmos5l_o21ai_1_3.Y a_25505_16262# 0.02436f
C706 a_25786_15960# a_26170_16237# 0.01303f
C707 a_15671_15549# sg13cmos5l_dfrbpq_1_2.RESET_B 0.01966f
C708 VDD sg13cmos5l_buf_1_10.X 2.54445f
C709 VDD a_7532_15960# 0.22643f
C710 sg13cmos5l_buf_8_2.A sg13cmos5l_buf_1_10.X 0.38553f
C711 a_9737_14822# a_9658_14725# 0.08889f
C712 VDD a_25505_16262# 0.20709f
C713 a_7888_14726# a_8298_14484# 0.07015f
C714 a_6401_13912# a_6682_13690# 0.18796f
C715 sg13cmos5l_buf_1_0.X sg13cmos5l_dlygate4sd3_1_1.A 0.27666f
C716 VDD a_25206_14508# 0.16141f
C717 sg13cmos5l_nor2_1_0.B sg13cmos5l_dfrbpq_1_2.D 0.11174f
C718 a_8218_13690# a_7937_13912# 0.18796f
C719 VDD reset_n_i 0.14588f
C720 sg13cmos5l_o21ai_1_3.Y a_26249_16334# 0.01284f
C721 VDD sg13cmos5l_dfrbpq_1_7.RESET_B 1.10388f
C722 sg13cmos5l_buf_1_10.X a_1965_14832# 0.10177f
C723 sg13cmos5l_inv_1_0.A clock_i 0.04697f
C724 VDD a_32200_16082# 0.1695f
C725 a_2916_15552# a_4081_15311# 0.25046f
C726 VDD sg13cmos5l_dfrbpq_1_2.RESET_B 1.18089f
C727 VDD a_26249_16334# 0.07375f
C728 VDD a_9658_14725# 0.10119f
C729 sg13cmos5l_dfrbpq_1_2.RESET_B a_15782_13722# 0.11354f
C730 sg13cmos5l_dfrbpq_1_2.RESET_B sg13cmos5l_buf_8_2.A 0.08449f
C731 VDD a_6682_13690# 0.28405f
C732 sg13cmos5l_a21oi_1_0.Y sg13cmos5l_dfrbpq_1_2.Q 0.01608f
C733 a_21166_16263# sg13cmos5l_a21oi_1_1.Y 0.01491f
C734 VDD a_17825_16262# 0.20672f
C735 sg13cmos5l_a21oi_1_0.A1 a_17825_16262# 0.01004f
C736 sg13cmos5l_or3_1_2.B sg13cmos5l_inv_1_0.Y 0.96765f
C737 a_8694_15302# sg13cmos5l_nand4_1_0.Y 0.0137f
C738 a_4175_15311# a_4081_15311# 0.16704f
C739 VDD a_10337_14750# 0.20387f
C740 sg13cmos5l_dfrbpq_1_2.RESET_B a_17584_13942# 0.09962f
C741 sg13cmos5l_or3_1_1.B a_19323_13726# 0.05142f
C742 a_10703_15311# a_11370_15532# 0.09257f
C743 sg13cmos5l_or3_1_2.A a_20774_14922# 0.03212f
C744 sg13cmos5l_o21ai_1_2.B1 sg13cmos5l_a21oi_1_3.A1 0.02427f
C745 sg13cmos5l_dlygate4sd3_1_8.X a_10222_14751# 0.1126f
C746 sg13cmos5l_dfrbpq_1_6.D a_21070_15423# 0.03572f
C747 a_17921_15424# a_18202_15202# 0.18796f
C748 sg13cmos5l_dlygate4sd3_1_3.A a_4474_14448# 0.28823f
C749 VDD a_16068_14040# 0.08143f
C750 a_15782_13722# a_16068_14040# 0.26205f
C751 a_25930_14452# sg13cmos5l_dfrbpq_1_5.RESET_B 0.0148f
C752 counter_value_o[1] a_7532_15960# 0.15504f
C753 sg13cmos5l_dlygate4sd3_1_4.X a_17825_16262# 0.01299f
C754 sg13cmos5l_or3_1_2.A a_21348_14909# 0.01104f
C755 sg13cmos5l_o21ai_1_2.A2 sg13cmos5l_buf_8_2.X 0.05556f
C756 VDD a_18863_14845# 0.17376f
C757 a_19816_15366# a_20000_15366# 0.05762f
C758 sg13cmos5l_a21oi_1_2.A1 a_25025_16344# 0.01276f
C759 sg13cmos5l_or3_1_1.X sg13cmos5l_dlygate4sd3_1_17.A 0.05473f
C760 sg13cmos5l_buf_8_2.A a_18863_14845# 0.01736f
C761 sg13cmos5l_dfrbpq_1_3.Q sg13cmos5l_a21oi_1_1.Y 0.01499f
C762 sg13cmos5l_buf_1_10.X sg13cmos5l_xor2_1_0.X 0.14017f
C763 a_21281_16262# a_21562_15960# 0.18796f
C764 a_22576_14726# sg13cmos5l_buf_8_2.X 0.0155f
C765 a_17318_14922# a_17892_14909# 0.18486f
C766 a_15671_15315# clock_i 0.02493f
C767 a_3130_16237# sg13cmos5l_dfrbpq_1_0.RESET_B 0.05105f
C768 VDD a_17994_14020# 0.28402f
C769 a_1192_3900# enable_i 0.1951f
C770 a_19120_14726# a_18863_14845# 0.23043f
C771 sg13cmos5l_a21oi_1_3.Y sg13cmos5l_dfrbpq_1_6.Q 0.01464f
C772 a_5600_15366# VDD 0.09581f
C773 a_26244_14909# sg13cmos5l_dfrbpq_1_5.RESET_B 0.01674f
C774 VDD a_2490_14447# 0.19284f
C775 a_25956_14488# sg13cmos5l_dfrbpq_1_7.RESET_B 0.28972f
C776 sg13cmos5l_a21oi_1_0.Y sg13cmos5l_a21oi_1_3.B1 0.43231f
C777 sg13cmos5l_nand4_1_0.Y a_7680_15549# 0.03194f
C778 VDD sg13cmos5l_dlygate4sd3_1_9.X 0.18623f
C779 VDD sg13cmos5l_dfrbpq_1_6.RESET_B 1.15314f
C780 a_27215_14845# a_27121_14845# 0.16704f
C781 a_17584_13942# a_17994_14020# 0.07015f
C782 a_26148_14040# a_27407_13799# 0.01412f
C783 sg13cmos5l_dlygate4sd3_1_3.A a_3333_15213# 0.01794f
C784 a_26475_14495# sg13cmos5l_dfrbpq_1_7.RESET_B 0.27969f
C785 a_9963_15356# a_10703_15311# 0.17382f
C786 sg13cmos5l_dfrbpq_1_7.D a_25206_14508# 0.01672f
C787 a_5687_15315# a_5687_15549# 0.08186f
C788 sg13cmos5l_xor2_1_0.B sg13cmos5l_dlygate4sd3_1_3.A 0.05133f
C789 a_22149_16033# a_22304_16082# 0.03131f
C790 sg13cmos5l_dfrbpq_1_6.D sg13cmos5l_or3_1_2.X 0.04306f
C791 a_1965_14832# a_2490_14447# 0.01705f
C792 sg13cmos5l_dlygate4sd3_1_5.A a_18454_16374# 0.07345f
C793 sg13cmos5l_dlygate4sd3_1_17.A sg13cmos5l_buf_8_2.X 0.02847f
C794 sg13cmos5l_or3_1_1.B sg13cmos5l_or3_1_2.B 0.04606f
C795 a_27407_13799# a_28074_14020# 0.09257f
C796 a_26565_13701# a_27313_13799# 0.01058f
C797 counter_value_o[3] a_16552_15996# 0.1598f
C798 sg13cmos5l_xnor2_1_2.B a_6575_13342# 0.01242f
C799 sg13cmos5l_dfrbpq_1_7.D sg13cmos5l_dfrbpq_1_7.RESET_B 0.11217f
C800 sg13cmos5l_dlygate4sd3_1_3.A a_4432_15454# 0.05808f
C801 VDD a_26373_14495# 0.24869f
C802 sg13cmos5l_a21oi_1_3.A1 sg13cmos5l_a21oi_1_3.A2 0.17776f
C803 sg13cmos5l_o21ai_1_2.B1 sg13cmos5l_o21ai_1_2.Y 0.55898f
C804 sg13cmos5l_or3_1_2.B a_20278_14862# 0.08485f
C805 sg13cmos5l_buf_1_10.X a_6789_14495# 0.01284f
C806 a_7888_14726# sg13cmos5l_dlygate4sd3_1_1.A 0.01306f
C807 VDD a_25889_15424# 0.20712f
C808 VDD a_27472_14726# 0.13629f
C809 sg13cmos5l_tiehi_1.L_HI a_9737_14822# 0.01916f
C810 sg13cmos5l_nand3_1_0.Y a_7680_15549# 0.23616f
C811 VDD a_19323_13726# 0.94636f
C812 a_18552_15976# sg13cmos5l_dlygate4sd3_1_5.A 0.01087f
C813 sg13cmos5l_buf_8_2.A a_19323_13726# 0.35369f
C814 sg13cmos5l_dfrbpq_1_2.Q a_18665_15180# 0.02237f
C815 a_9444_15552# a_9963_15356# 0.20773f
C816 sg13cmos5l_o21ai_1_1.Y a_21824_15366# 0.03907f
C817 sg13cmos5l_dfrbpq_1_3.Q sg13cmos5l_buf_8_2.X 0.02606f
C818 VDD a_16552_15996# 0.18144f
C819 sg13cmos5l_inv_1_0.A sg13cmos5l_inv_1_0.Y 0.12555f
C820 sg13cmos5l_xnor2_1_2.B a_6346_14452# 0.01548f
C821 sg13cmos5l_xor2_1_0.X a_2490_14447# 0.14671f
C822 sg13cmos5l_buf_1_10.X sg13cmos5l_dlygate4sd3_1_8.A 0.03261f
C823 sg13cmos5l_o21ai_1_1.Y sg13cmos5l_or3_1_2.X 0.05673f
C824 sg13cmos5l_dfrbpq_1_6.RESET_B sg13cmos5l_or3_1_2.A 0.02401f
C825 sg13cmos5l_tiehi_1.L_HI VDD 1.09488f
C826 sg13cmos5l_or3_1_2.B counter_value_o[3] 0.48267f
C827 VDD a_38536_3986# 0.1399f
C828 sg13cmos5l_a21oi_1_3.B1 sg13cmos5l_a21oi_1_1.Y 0.23211f
C829 VDD sg13cmos5l_dlygate4sd3_1_0.X 0.44473f
C830 sg13cmos5l_or3_1_1.A sg13cmos5l_a21oi_1_3.A1 0.08765f
C831 a_20968_13854# sg13cmos5l_or3_1_2.X 0.02112f
C832 sg13cmos5l_buf_1_0.X a_2516_14484# 0.01414f
C833 sg13cmos5l_o21ai_1_2.Y a_23638_14862# 0.06016f
C834 a_17318_14922# sg13cmos5l_dfrbpq_1_3.RESET_B 0.10741f
C835 sg13cmos5l_dfrbpq_1_2.Q a_17578_14452# 0.01204f
C836 a_25956_14488# a_26373_14495# 0.28418f
C837 a_10609_15311# sg13cmos5l_dfrbpq_1_2.CLK 0.0137f
C838 a_2890_15457# sg13cmos5l_dfrbpq_1_0.RESET_B 0.20779f
C839 sg13cmos5l_nand3_1_0.Y sg13cmos5l_nand4_1_0.Y 0.14351f
C840 VDD a_2630_15234# 0.54684f
C841 a_26148_14040# sg13cmos5l_dfrbpq_1_5.RESET_B 0.28728f
C842 sg13cmos5l_o21ai_1_3.Y sg13cmos5l_or3_1_2.B 0.05035f
C843 sg13cmos5l_o21ai_1_2.Y sg13cmos5l_a21oi_1_3.A2 0.04308f
C844 sg13cmos5l_or3_1_1.X a_25094_15238# 0.04107f
C845 sg13cmos5l_dfrbpq_1_2.Q sg13cmos5l_buf_8_2.X 0.04395f
C846 a_17126_15238# a_17238_15302# 0.3854f
C847 a_26373_14495# a_26475_14495# 0.3643f
C848 sg13cmos5l_a21oi_1_3.Y a_25670_14922# 0.04949f
C849 sg13cmos5l_dfrbpq_1_5.D sg13cmos5l_buf_8_2.X 0.07404f
C850 VDD sg13cmos5l_or3_1_2.B 2.19079f
C851 a_22030_15423# sg13cmos5l_dfrbpq_1_2.Q 0.01335f
C852 sg13cmos5l_a21oi_1_3.B1 sg13cmos5l_or3_1_1.X 0.09969f
C853 a_37484_15960# sg13cmos5l_dfrbpq_1_5.Q 0.19611f
C854 a_26475_14495# a_27472_14726# 0.03546f
C855 sg13cmos5l_dlygate4sd3_1_17.A a_24824_15238# 0.06549f
C856 a_17238_15302# sg13cmos5l_inv_1_0.A 0.01275f
C857 sg13cmos5l_dfrbpq_1_1.RESET_B a_6346_14452# 0.18209f
C858 sg13cmos5l_and2_1_2.B a_9158_15234# 0.02349f
C859 counter_value_o[5] a_27500_15960# 0.15495f
C860 sg13cmos5l_o21ai_1_2.B1 sg13cmos5l_dfrbpq_1_6.Q 1.63709f
C861 sg13cmos5l_inv_1_0.A sg13cmos5l_or3_1_1.B 0.44688f
C862 VDD sg13cmos5l_xnor2_1_0.Y 0.31635f
C863 sg13cmos5l_xnor2_1_2.A a_6575_13342# 0.01681f
C864 VDD a_17921_15424# 0.20695f
C865 a_17327_13799# a_17233_13799# 0.16704f
C866 a_6540_13238# a_6575_13342# 0.19075f
C867 sg13cmos5l_or3_1_2.B sg13cmos5l_dlygate4sd3_1_4.X 0.18148f
C868 sg13cmos5l_dlygate4sd3_1_8.X a_7680_15549# 0.10198f
C869 sg13cmos5l_a21oi_1_3.B1 a_17578_14452# 0.01016f
C870 VDD a_19816_15366# 0.12937f
C871 sg13cmos5l_dfrbpq_1_1.RESET_B a_7631_14845# 0.10879f
C872 a_6086_14922# a_6346_14452# 0.45119f
C873 sg13cmos5l_buf_1_0.X a_4842_15532# 0.01204f
C874 sg13cmos5l_or3_1_1.C sg13cmos5l_buf_8_2.X 0.01896f
C875 a_21251_13690# a_20968_13854# 0.01625f
C876 sg13cmos5l_or3_1_1.A sg13cmos5l_o21ai_1_2.Y 0.04759f
C877 VDD sg13cmos5l_and2_1_0.X 0.30117f
C878 sg13cmos5l_dlygate4sd3_1_3.A sg13cmos5l_buf_1_10.X 0.02697f
C879 a_26667_13844# VDD 0.20664f
C880 sg13cmos5l_a21oi_1_3.B1 sg13cmos5l_buf_8_2.X 0.47568f
C881 sg13cmos5l_dfrbpq_1_3.D a_17318_14922# 0.17256f
C882 a_5687_15315# a_5886_15486# 0.02453f
C883 a_20774_14922# a_21477_14495# 0.02431f
C884 a_18586_15455# a_18665_15180# 0.08889f
C885 a_4078_14751# a_3872_14570# 0.01604f
C886 sg13cmos5l_a21oi_1_3.A1 a_25109_12972# 0.02752f
C887 sg13cmos5l_nand4_1_0.Y a_10703_15311# 0.01618f
C888 a_26753_15424# sg13cmos5l_dfrbpq_1_6.Q 0.01045f
C889 sg13cmos5l_and2_1_0.X a_1965_14832# 0.07702f
C890 sg13cmos5l_a21oi_1_3.A1 a_24841_13726# 0.05315f
C891 a_24841_13726# a_25037_14020# 0.01485f
C892 sg13cmos5l_and2_1_2.B sg13cmos5l_and2_1_2.X 0.13511f
C893 a_9418_15457# sg13cmos5l_tiehi_1.L_HI 0.17464f
C894 a_21477_14495# a_21348_14909# 0.01562f
C895 a_21060_14488# a_21579_14495# 0.20754f
C896 sg13cmos5l_or3_1_2.A sg13cmos5l_or3_1_2.B 0.76615f
C897 a_7829_15238# sg13cmos5l_xnor2_1_0.Y 0.02386f
C898 sg13cmos5l_dfrbpq_1_7.Q sg13cmos5l_dfrbpq_1_5.Q 0.45875f
C899 sg13cmos5l_a21oi_1_3.B1 a_25774_15423# 0.01368f
C900 sg13cmos5l_dlygate4sd3_1_8.X sg13cmos5l_nand4_1_0.Y 0.20079f
C901 a_16485_13701# sg13cmos5l_dfrbpq_1_2.CLK 0.22095f
C902 a_15671_15549# sg13cmos5l_inv_1_0.A 0.01207f
C903 a_21579_14495# a_22319_14845# 0.17382f
C904 sg13cmos5l_dfrbpq_1_5.RESET_B sg13cmos5l_dfrbpq_1_6.Q 0.03307f
C905 counter_value_o[4] a_22025_16334# 0.0192f
C906 VDD a_17126_15238# 0.20971f
C907 a_17126_15238# sg13cmos5l_a21oi_1_0.A1 0.02337f
C908 sg13cmos5l_or3_1_2.B a_16168_15996# 0.15767f
C909 sg13cmos5l_dfrbpq_1_7.Q a_27502_15423# 0.01894f
C910 sg13cmos5l_o21ai_1_2.Y a_23736_14464# 0.01095f
C911 sg13cmos5l_inv_1_0.Y sg13cmos5l_dlygate4sd3_1_5.A 0.2384f
C912 a_26554_16237# sg13cmos5l_dfrbpq_1_5.RESET_B 0.0434f
C913 a_17892_14909# sg13cmos5l_dfrbpq_1_3.RESET_B 0.0197f
C914 sg13cmos5l_dfrbpq_1_7.Q sg13cmos5l_dfrbpq_1_6.Q 0.04426f
C915 a_25862_13722# sg13cmos5l_dfrbpq_1_5.D 0.17436f
C916 sg13cmos5l_or3_1_2.C sg13cmos5l_buf_8_2.X 0.15474f
C917 a_9444_15552# sg13cmos5l_nand4_1_0.Y 0.02334f
C918 VDD sg13cmos5l_inv_1_0.A 0.2568f
C919 sg13cmos5l_inv_1_0.A sg13cmos5l_a21oi_1_0.A1 0.01808f
C920 sg13cmos5l_and2_1_0.X sg13cmos5l_xor2_1_0.X 0.28573f
C921 a_16140_15424# sg13cmos5l_nor2_1_0.B 0.1273f
C922 a_9158_15234# sg13cmos5l_dfrbpq_1_2.CLK 0.01121f
C923 sg13cmos5l_or3_1_1.B a_17327_13799# 0.01909f
C924 a_10222_14751# sg13cmos5l_buf_1_10.X 0.01427f
C925 sg13cmos5l_tiehi_1.L_HI sg13cmos5l_dlygate4sd3_1_8.A 0.02474f
C926 a_6372_14488# a_6660_14909# 0.24435f
C927 clock_i sg13cmos5l_dfrbpq_1_2.CLK 0.03525f
C928 sg13cmos5l_dlygate4sd3_1_8.X sg13cmos5l_nand3_1_0.Y 0.28523f
C929 a_26633_16334# a_26554_16237# 0.08889f
C930 a_25390_16263# a_25505_16262# 0.3854f
C931 a_15671_15315# a_15671_15549# 0.08186f
C932 a_15870_15486# sg13cmos5l_dfrbpq_1_2.RESET_B 0.06273f
C933 sg13cmos5l_or3_1_1.A a_27502_15423# 0.12348f
C934 VDD a_27898_15202# 0.2847f
C935 a_24824_15238# a_25094_15238# 0.18796f
C936 VDD a_3008_16082# 0.06559f
C937 sg13cmos5l_or3_1_1.A sg13cmos5l_dfrbpq_1_6.Q 1.7649f
C938 a_22149_16033# counter_value_o[4] 0.0172f
C939 a_6891_14495# a_7631_14845# 0.17382f
C940 a_16955_14484# sg13cmos5l_dfrbpq_1_2.CLK 0.02772f
C941 a_6286_13911# sg13cmos5l_dlygate4sd3_1_0.A 0.02097f
C942 sg13cmos5l_xnor2_1_2.A sg13cmos5l_nand4_1_0.Y 0.05029f
C943 a_21060_14488# sg13cmos5l_or3_1_2.X 0.04034f
C944 VDD a_24169_14508# 0.25699f
C945 a_17126_15238# sg13cmos5l_a21oi_1_0.A2 0.0707f
C946 sg13cmos5l_dfrbpq_1_1.RESET_B sg13cmos5l_nand3_1_0.Y 0.01467f
C947 a_9861_15213# a_10609_15311# 0.01058f
C948 VDD a_27500_15960# 0.22496f
C949 sg13cmos5l_dfrbpq_1_3.Q sg13cmos5l_o21ai_1_2.A2 0.12945f
C950 sg13cmos5l_buf_1_0.X sg13cmos5l_dfrbpq_1_0.RESET_B 0.05907f
C951 a_2916_15552# a_3204_15247# 0.24435f
C952 sg13cmos5l_inv_1_0.A sg13cmos5l_a21oi_1_0.A2 0.0306f
C953 sg13cmos5l_dfrbpq_1_6.RESET_B a_21477_14495# 0.03611f
C954 VDD a_15671_15315# 0.06777f
C955 sg13cmos5l_dfrbpq_1_2.RESET_B a_16042_13945# 0.19612f
C956 VDD a_6080_13854# 0.07075f
C957 sg13cmos5l_and2_1_2.X sg13cmos5l_dfrbpq_1_2.CLK 0.02931f
C958 sg13cmos5l_o21ai_1_2.B1 sg13cmos5l_a21oi_1_3.Y 0.05014f
C959 a_10222_14751# a_10337_14750# 0.3854f
C960 a_5613_14832# sg13cmos5l_dfrbpq_1_2.CLK 0.01227f
C961 a_4078_14751# sg13cmos5l_dfrbpq_1_2.CLK 0.01392f
C962 a_25786_15960# sg13cmos5l_o21ai_1_3.Y 0.29053f
C963 a_2890_15457# a_2916_15552# 0.24169f
C964 VDD a_22025_16334# 0.07626f
C965 sg13cmos5l_or3_1_1.X a_25505_16262# 0.01201f
C966 VDD a_10618_14448# 0.28771f
C967 VDD a_25786_15960# 0.26183f
C968 clock_i sg13cmos5l_dlygate4sd3_1_1.A 0.01208f
C969 sg13cmos5l_or3_1_1.X a_25206_14508# 0.04711f
C970 a_20774_14922# sg13cmos5l_buf_8_2.X 0.01038f
C971 VDD a_15680_13854# 0.10463f
C972 sg13cmos5l_or3_1_1.X sg13cmos5l_dfrbpq_1_7.RESET_B 0.01339f
C973 sg13cmos5l_dfrbpq_1_1.RESET_B sg13cmos5l_xnor2_1_2.B 0.15083f
C974 VDD a_12010_15202# 1.01037f
C975 a_16042_13945# a_16068_14040# 0.24169f
C976 a_25670_14922# sg13cmos5l_dfrbpq_1_5.RESET_B 0.04146f
C977 sg13cmos5l_o21ai_1_2.A2 sg13cmos5l_dfrbpq_1_2.Q 0.02634f
C978 a_12010_15202# sg13cmos5l_buf_8_2.A 0.34017f
C979 sg13cmos5l_o21ai_1_1.Y a_20278_14862# 0.06702f
C980 VDD a_18123_14495# 0.20905f
C981 sg13cmos5l_dfrbpq_1_5.Q counter_value_o[7] 0.01279f
C982 sg13cmos5l_buf_8_2.A a_18123_14495# 0.02096f
C983 sg13cmos5l_nor2_1_0.B clock_i 0.09977f
C984 a_20960_16082# a_21166_16263# 0.01604f
C985 VDD a_17327_13799# 0.18096f
C986 a_2824_16082# a_3008_16082# 0.05762f
C987 a_2916_15552# sg13cmos5l_dfrbpq_1_2.CLK 0.07118f
C988 a_3130_16237# a_3333_16033# 0.02453f
C989 a_3333_15213# a_3435_15356# 0.36168f
C990 a_25956_14488# a_27121_14845# 0.25046f
C991 sg13cmos5l_or3_1_1.B sg13cmos5l_a21oi_1_3.A1 0.01717f
C992 a_18123_14495# a_19120_14726# 0.03546f
C993 sg13cmos5l_xnor2_1_2.B a_6086_14922# 0.05954f
C994 a_5687_15315# VDD 0.07168f
C995 sg13cmos5l_o21ai_1_1.Y a_20376_14464# 0.01087f
C996 a_16856_15238# sg13cmos5l_dfrbpq_1_2.Q 0.01361f
C997 sg13cmos5l_a21oi_1_1.Y sg13cmos5l_dlygate4sd3_1_9.X 0.07532f
C998 a_25206_14508# sg13cmos5l_buf_8_2.X 0.01098f
C999 VDD a_19169_15424# 0.21183f
C1000 a_2528_15366# sg13cmos5l_and2_1_0.X 0.03662f
C1001 sg13cmos5l_dfrbpq_1_6.RESET_B sg13cmos5l_a21oi_1_1.Y 0.15755f
C1002 VDD a_22149_16033# 0.06428f
C1003 VDD sg13cmos5l_dfrbpq_1_6.D 0.33298f
C1004 a_27472_14726# a_27882_14484# 0.07015f
C1005 a_16587_13844# a_16356_13735# 0.07823f
C1006 a_17327_13799# a_17584_13942# 0.23043f
C1007 a_26565_13701# a_26667_13844# 0.36168f
C1008 sg13cmos5l_a21oi_1_3.Y sg13cmos5l_dfrbpq_1_5.RESET_B 0.50817f
C1009 a_3435_15356# a_4432_15454# 0.03412f
C1010 sg13cmos5l_dlygate4sd3_1_3.A a_2630_15234# 0.03756f
C1011 sg13cmos5l_buf_8_2.X sg13cmos5l_dfrbpq_1_7.RESET_B 0.0607f
C1012 a_9444_15552# a_10703_15311# 0.01412f
C1013 sg13cmos5l_xnor2_1_2.A a_7822_13911# 0.11116f
C1014 sg13cmos5l_dfrbpq_1_2.D clock_i 0.02532f
C1015 a_18106_15960# a_17825_16262# 0.18796f
C1016 sg13cmos5l_xnor2_1_2.A sg13cmos5l_xnor2_1_2.B 0.34537f
C1017 a_26565_13701# a_26436_13735# 0.01562f
C1018 sg13cmos5l_xnor2_1_2.B a_6540_13238# 0.25625f
C1019 VDD a_25930_14452# 0.0966f
C1020 a_19169_15424# a_19450_15202# 0.18796f
C1021 VDD a_17604_14488# 0.07286f
C1022 sg13cmos5l_inv_1_0.Y sg13cmos5l_dfrbpq_1_2.CLK 0.01047f
C1023 sg13cmos5l_a21oi_1_0.Y sg13cmos5l_or3_1_2.B 0.01754f
C1024 a_21946_16237# sg13cmos5l_dfrbpq_1_6.RESET_B 0.04633f
C1025 sg13cmos5l_buf_8_2.A a_17604_14488# 0.01462f
C1026 a_6280_13058# sg13cmos5l_dlygate4sd3_1_0.A 0.01639f
C1027 VDD sg13cmos5l_dlygate4sd3_1_5.A 0.30993f
C1028 a_18021_14495# a_18123_14495# 0.3643f
C1029 sg13cmos5l_xnor2_1_2.B sg13cmos5l_and2_1_1.X 0.04672f
C1030 VDD a_3130_16237# 0.10639f
C1031 a_25774_15423# sg13cmos5l_dfrbpq_1_7.RESET_B 0.02935f
C1032 sg13cmos5l_dfrbpq_1_1.RESET_B a_6086_14922# 0.07767f
C1033 sg13cmos5l_or3_1_2.B a_21477_14495# 0.01108f
C1034 sg13cmos5l_dlygate4sd3_1_0.X a_5896_13854# 0.01652f
C1035 sg13cmos5l_dlygate4sd3_1_17.A a_25094_15238# 0.01415f
C1036 sg13cmos5l_dfrbpq_1_3.D sg13cmos5l_dfrbpq_1_3.RESET_B 0.09733f
C1037 VDD sg13cmos5l_o21ai_1_1.Y 0.29617f
C1038 sg13cmos5l_buf_8_2.X a_18863_14845# 0.02216f
C1039 sg13cmos5l_buf_1_10.X a_7631_14845# 0.02226f
C1040 a_9158_15234# a_9861_15213# 0.02453f
C1041 sg13cmos5l_dlygate4sd3_1_3.A sg13cmos5l_and2_1_0.X 0.01628f
C1042 sg13cmos5l_dfrbpq_1_3.Q sg13cmos5l_dfrbpq_1_2.Q 2.85025f
C1043 sg13cmos5l_dfrbpq_1_2.Q a_19054_15423# 0.01821f
C1044 sg13cmos5l_o21ai_1_2.Y sg13cmos5l_or3_1_1.B 0.01359f
C1045 sg13cmos5l_dlygate4sd3_1_4.X sg13cmos5l_dlygate4sd3_1_5.A 0.24548f
C1046 sg13cmos5l_or3_1_1.A sg13cmos5l_a21oi_1_3.Y 0.01853f
C1047 sg13cmos5l_xnor2_1_2.A sg13cmos5l_dlygate4sd3_1_8.X 0.06752f
C1048 sg13cmos5l_or3_1_2.B a_23552_14570# 0.0358f
C1049 VDD a_20968_13854# 0.1724f
C1050 sg13cmos5l_a21oi_1_3.B1 sg13cmos5l_dlygate4sd3_1_17.A 0.24924f
C1051 sg13cmos5l_dfrbpq_1_6.D sg13cmos5l_or3_1_2.A 0.02907f
C1052 VDD a_38720_10034# 0.0583f
C1053 VDD a_3872_14570# 0.08604f
C1054 sg13cmos5l_dfrbpq_1_6.RESET_B sg13cmos5l_buf_8_2.X 0.0379f
C1055 VDD sg13cmos5l_a21oi_1_3.A1 0.28007f
C1056 sg13cmos5l_or3_1_1.A a_25206_15302# 0.01524f
C1057 sg13cmos5l_or3_1_2.C a_21034_14452# 0.01367f
C1058 sg13cmos5l_dfrbpq_1_1.RESET_B sg13cmos5l_xnor2_1_2.A 0.04487f
C1059 sg13cmos5l_a21oi_1_3.B1 a_15579_14854# 0.06371f
C1060 sg13cmos5l_xor2_1_0.B sg13cmos5l_xnor2_1_2.B 0.02186f
C1061 sg13cmos5l_and2_1_2.B VDD 0.23394f
C1062 a_25930_14452# a_25956_14488# 0.24169f
C1063 a_9732_15247# sg13cmos5l_dfrbpq_1_2.CLK 0.01421f
C1064 a_17604_14488# a_18021_14495# 0.28418f
C1065 sg13cmos5l_xnor2_1_2.A a_6086_14922# 0.01661f
C1066 sg13cmos5l_or3_1_1.B sg13cmos5l_dfrbpq_1_2.CLK 0.21155f
C1067 sg13cmos5l_dfrbpq_1_3.Q sg13cmos5l_or3_1_1.C 0.09624f
C1068 sg13cmos5l_dfrbpq_1_1.RESET_B sg13cmos5l_and2_1_1.X 0.07099f
C1069 VDD a_6372_14488# 0.07271f
C1070 sg13cmos5l_o21ai_1_2.Y a_24824_14525# 0.01349f
C1071 a_25956_14488# a_26244_14909# 0.24435f
C1072 a_26373_14495# sg13cmos5l_buf_8_2.X 0.23747f
C1073 sg13cmos5l_dfrbpq_1_3.Q sg13cmos5l_a21oi_1_3.B1 0.86219f
C1074 counter_value_o[5] sg13cmos5l_dfrbpq_1_6.Q 0.01034f
C1075 sg13cmos5l_or3_1_2.B sg13cmos5l_a21oi_1_1.Y 0.39227f
C1076 sg13cmos5l_nor2_1_0.B sg13cmos5l_inv_1_0.Y 0.02795f
C1077 a_27407_13799# sg13cmos5l_dfrbpq_1_5.RESET_B 0.10868f
C1078 VDD a_8298_14484# 0.27815f
C1079 a_10618_14448# sg13cmos5l_dlygate4sd3_1_8.A 0.28818f
C1080 sg13cmos5l_and2_1_1.X a_6086_14922# 0.18067f
C1081 a_26244_14909# a_26475_14495# 0.07823f
C1082 sg13cmos5l_dlygate4sd3_1_8.X a_6891_14495# 0.01277f
C1083 sg13cmos5l_buf_1_0.X a_2916_15552# 0.0434f
C1084 sg13cmos5l_tiehi_1.L_HI a_9963_15356# 0.28158f
C1085 sg13cmos5l_o21ai_1_1.Y sg13cmos5l_or3_1_2.A 0.23707f
C1086 sg13cmos5l_buf_8_2.X a_19323_13726# 0.66336f
C1087 VDD a_12232_16082# 0.16754f
C1088 VDD a_8312_15238# 0.27567f
C1089 a_12010_15202# sg13cmos5l_dlygate4sd3_1_8.A 0.02872f
C1090 sg13cmos5l_xnor2_1_2.A a_6540_13238# 0.12802f
C1091 sg13cmos5l_o21ai_1_2.B1 a_23638_14862# 0.02318f
C1092 a_26170_15202# sg13cmos5l_a21oi_1_3.Y 0.28819f
C1093 sg13cmos5l_o21ai_1_3.Y sg13cmos5l_o21ai_1_2.Y 0.07365f
C1094 sg13cmos5l_a21oi_1_0.Y sg13cmos5l_inv_1_0.A 0.03371f
C1095 sg13cmos5l_dfrbpq_1_1.RESET_B a_6891_14495# 0.28013f
C1096 counter_value_o[2] a_12232_16082# 0.02116f
C1097 sg13cmos5l_buf_1_0.X a_4175_15311# 0.0138f
C1098 sg13cmos5l_o21ai_1_2.B1 sg13cmos5l_dfrbpq_1_5.RESET_B 0.12304f
C1099 sg13cmos5l_dfrbpq_1_1.RESET_B sg13cmos5l_xor2_1_0.B 0.04436f
C1100 VDD sg13cmos5l_o21ai_1_2.Y 0.33363f
C1101 VDD a_2890_15457# 0.10858f
C1102 sg13cmos5l_a21oi_1_3.B1 sg13cmos5l_dfrbpq_1_2.Q 0.27687f
C1103 sg13cmos5l_a21oi_1_3.Y a_25109_12972# 0.10082f
C1104 a_26148_14040# VDD 0.08291f
C1105 sg13cmos5l_a21oi_1_3.B1 sg13cmos5l_dfrbpq_1_5.D 0.19488f
C1106 a_25774_15423# a_25889_15424# 0.3854f
C1107 a_6086_14922# a_6891_14495# 0.07916f
C1108 a_20774_14922# a_21034_14452# 0.45119f
C1109 a_28074_14020# VDD 0.28333f
C1110 sg13cmos5l_dfrbpq_1_3.Q sg13cmos5l_or3_1_2.C 0.20063f
C1111 sg13cmos5l_a21oi_1_3.A1 sg13cmos5l_dfrbpq_1_7.D 0.09285f
C1112 sg13cmos5l_or3_1_2.B a_18106_15960# 0.01302f
C1113 sg13cmos5l_or3_1_1.C a_24520_13854# 0.0191f
C1114 sg13cmos5l_nor2_1_0.B sg13cmos5l_or3_1_1.B 0.1517f
C1115 a_27617_15424# a_27898_15202# 0.18796f
C1116 sg13cmos5l_a21oi_1_0.A1 sg13cmos5l_dfrbpq_1_2.CLK 0.27031f
C1117 VDD sg13cmos5l_dfrbpq_1_2.CLK 1.58512f
C1118 sg13cmos5l_xnor2_1_2.A a_6891_14495# 0.06395f
C1119 sg13cmos5l_or3_1_2.B sg13cmos5l_buf_8_2.X 0.10287f
C1120 a_7532_15960# a_7240_16082# 0.01635f
C1121 a_26753_15424# sg13cmos5l_dfrbpq_1_5.RESET_B 0.01144f
C1122 sg13cmos5l_a21oi_1_3.B1 sg13cmos5l_or3_1_1.C 0.10968f
C1123 sg13cmos5l_buf_8_2.A sg13cmos5l_dfrbpq_1_2.CLK 0.3488f
C1124 sg13cmos5l_xor2_1_0.B sg13cmos5l_xnor2_1_2.A 0.34223f
C1125 sg13cmos5l_o21ai_1_2.B1 sg13cmos5l_or3_1_1.A 0.03039f
C1126 VDD a_2248_16082# 0.16554f
C1127 sg13cmos5l_dfrbpq_1_2.Q a_18586_15455# 0.04669f
C1128 sg13cmos5l_xor2_1_0.B sg13cmos5l_and2_1_1.X 0.01253f
C1129 sg13cmos5l_or3_1_2.C sg13cmos5l_dfrbpq_1_2.Q 0.11689f
C1130 sg13cmos5l_dfrbpq_1_3.Q a_22426_15202# 0.03081f
C1131 VDD sg13cmos5l_dfrbpq_1_5.Q 2.16343f
C1132 sg13cmos5l_or3_1_1.A a_25094_14484# 0.0598f
C1133 VDD a_11752_15366# 0.15245f
C1134 sg13cmos5l_xnor2_1_2.B sg13cmos5l_buf_1_10.X 0.01762f
C1135 sg13cmos5l_dfrbpq_1_7.Q sg13cmos5l_dfrbpq_1_5.RESET_B 0.02776f
C1136 a_26667_13844# sg13cmos5l_buf_8_2.X 0.04348f
C1137 a_6372_14488# a_6789_14495# 0.28418f
C1138 a_26633_16334# sg13cmos5l_dfrbpq_1_5.RESET_B 0.01098f
C1139 a_26249_16334# a_26373_16033# 0.08186f
C1140 VDD a_22986_14484# 0.30036f
C1141 VDD a_21060_14488# 0.07667f
C1142 sg13cmos5l_or3_1_1.A a_26753_15424# 0.01592f
C1143 a_15870_15486# a_15671_15315# 0.02453f
C1144 VDD a_27502_15423# 0.16013f
C1145 VDD sg13cmos5l_dlygate4sd3_1_1.A 0.97447f
C1146 VDD sg13cmos5l_dfrbpq_1_6.Q 0.92075f
C1147 a_6372_14488# a_7537_14845# 0.25046f
C1148 a_6286_13911# a_6401_13912# 0.3854f
C1149 a_5896_13854# a_6080_13854# 0.05762f
C1150 VDD a_23368_14570# 0.13204f
C1151 VDD a_22319_14845# 0.19988f
C1152 VDD a_17318_14922# 0.52408f
C1153 sg13cmos5l_xnor2_1_2.B a_6682_13690# 0.01246f
C1154 a_9861_15213# a_9732_15247# 0.01562f
C1155 sg13cmos5l_buf_8_2.A a_17318_14922# 0.02999f
C1156 a_22426_15202# sg13cmos5l_dfrbpq_1_2.Q 0.01343f
C1157 sg13cmos5l_or3_1_1.A sg13cmos5l_dfrbpq_1_5.RESET_B 0.02336f
C1158 a_9737_14822# a_9861_14521# 0.08186f
C1159 a_9658_14725# a_9536_14570# 0.01854f
C1160 sg13cmos5l_or3_1_2.C sg13cmos5l_a21oi_1_3.B1 0.03201f
C1161 sg13cmos5l_dlygate4sd3_1_8.X sg13cmos5l_buf_1_10.X 1.2223f
C1162 VDD a_26554_16237# 0.09431f
C1163 a_26148_14040# a_26122_13945# 0.24169f
C1164 sg13cmos5l_or3_1_1.A sg13cmos5l_a21oi_1_3.A2 0.11755f
C1165 VDD sg13cmos5l_nor2_1_0.B 0.25674f
C1166 sg13cmos5l_dfrbpq_1_6.RESET_B a_21034_14452# 0.17208f
C1167 sg13cmos5l_nor2_1_0.B sg13cmos5l_buf_8_2.A 0.19122f
C1168 VDD a_7937_13912# 0.21568f
C1169 VDD a_6286_13911# 0.15952f
C1170 sg13cmos5l_dfrbpq_1_2.RESET_B a_15579_14854# 0.11274f
C1171 sg13cmos5l_o21ai_1_2.B1 a_26170_15202# 0.05397f
C1172 a_17806_15423# sg13cmos5l_dfrbpq_1_2.Q 0.01441f
C1173 a_9861_14521# a_10016_14570# 0.03131f
C1174 sg13cmos5l_dfrbpq_1_1.RESET_B sg13cmos5l_buf_1_10.X 0.02402f
C1175 sg13cmos5l_a21oi_1_1.Y a_22025_16334# 0.01284f
C1176 sg13cmos5l_or3_1_1.A sg13cmos5l_dfrbpq_1_7.Q 0.08495f
C1177 sg13cmos5l_tiehi_1.L_HI sg13cmos5l_nand4_1_0.Y 0.03669f
C1178 a_18769_14845# a_18021_14495# 0.01058f
C1179 sg13cmos5l_dfrbpq_1_6.RESET_B a_22576_14726# 0.09622f
C1180 a_4175_15311# a_4842_15532# 0.09257f
C1181 VDD a_9861_14521# 0.06515f
C1182 sg13cmos5l_dfrbpq_1_2.RESET_B a_16587_13844# 0.27963f
C1183 a_7680_15549# sg13cmos5l_xnor2_1_0.Y 0.14663f
C1184 sg13cmos5l_or3_1_2.X a_21070_15423# 0.04119f
C1185 a_4193_14750# sg13cmos5l_dfrbpq_1_2.CLK 0.01906f
C1186 VDD a_21562_15960# 0.26426f
C1187 VDD a_8218_13690# 0.29954f
C1188 VDD a_10960_15454# 0.13649f
C1189 VDD sg13cmos5l_dfrbpq_1_2.D 0.43023f
C1190 sg13cmos5l_dfrbpq_1_2.D a_15782_13722# 0.16401f
C1191 sg13cmos5l_or3_1_2.A a_21060_14488# 0.03179f
C1192 sg13cmos5l_dlygate4sd3_1_8.X a_10337_14750# 0.01066f
C1193 a_37484_15960# counter_value_o[7] 0.15504f
C1194 sg13cmos5l_dfrbpq_1_1.RESET_B a_6682_13690# 0.01306f
C1195 a_21946_16237# a_22025_16334# 0.08889f
C1196 a_18202_15202# sg13cmos5l_dfrbpq_1_3.RESET_B 0.06264f
C1197 a_17318_14922# a_18021_14495# 0.02431f
C1198 a_2630_15234# a_3435_15356# 0.07916f
C1199 a_6789_14495# sg13cmos5l_dfrbpq_1_2.CLK 0.2273f
C1200 sg13cmos5l_a21oi_1_2.A1 a_24923_15996# 0.0686f
C1201 a_16068_14040# a_16587_13844# 0.20773f
C1202 sg13cmos5l_buf_1_0.X VDD 3.99477f
C1203 a_2248_16082# counter_value_o[0] 0.02116f
C1204 sg13cmos5l_xnor2_1_2.A sg13cmos5l_buf_1_10.X 0.03534f
C1205 VDD a_18789_15277# 0.06795f
C1206 sg13cmos5l_dfrbpq_1_6.RESET_B a_21166_16263# 0.02119f
C1207 a_25206_14508# sg13cmos5l_dfrbpq_1_5.D 0.10738f
C1208 VDD a_21281_16262# 0.2072f
C1209 sg13cmos5l_dfrbpq_1_6.D sg13cmos5l_a21oi_1_1.Y 0.02843f
C1210 a_16068_14040# a_16356_13735# 0.24435f
C1211 a_26148_14040# a_26565_13701# 0.28324f
C1212 a_25862_13722# a_26667_13844# 0.07916f
C1213 a_26170_15202# sg13cmos5l_dfrbpq_1_5.RESET_B 0.02237f
C1214 sg13cmos5l_or3_1_1.C a_24310_15230# 0.11145f
C1215 sg13cmos5l_nand4_1_0.Y sg13cmos5l_xnor2_1_0.Y 0.04658f
C1216 sg13cmos5l_dfrbpq_1_2.CLK sg13cmos5l_dlygate4sd3_1_8.A 0.11676f
C1217 sg13cmos5l_a21oi_1_2.A1 sg13cmos5l_o21ai_1_3.Y 0.03141f
C1218 sg13cmos5l_and2_1_1.X sg13cmos5l_buf_1_10.X 0.04042f
C1219 a_9861_15213# VDD 0.24352f
C1220 a_25862_13722# a_26436_13735# 0.18486f
C1221 a_26667_13844# a_27664_13942# 0.03412f
C1222 sg13cmos5l_dlygate4sd3_1_4.X a_18789_15277# 0.03893f
C1223 VDD sg13cmos5l_a21oi_1_2.A1 0.17436f
C1224 VDD a_5504_14570# 0.08633f
C1225 sg13cmos5l_dfrbpq_1_7.Q a_27215_14845# 0.0476f
C1226 a_25109_12972# sg13cmos5l_a21oi_1_3.A2 0.05791f
C1227 VDD a_25670_14922# 0.52312f
C1228 sg13cmos5l_xnor2_1_2.A a_6682_13690# 0.03858f
C1229 sg13cmos5l_dfrbpq_1_3.Q sg13cmos5l_dlygate4sd3_1_9.X 0.01028f
C1230 sg13cmos5l_dfrbpq_1_6.RESET_B sg13cmos5l_dfrbpq_1_3.Q 0.02561f
C1231 a_21946_16237# a_22149_16033# 0.02453f
C1232 sg13cmos5l_a21oi_1_3.A2 a_24841_13726# 0.06354f
C1233 sg13cmos5l_a21oi_1_3.B1 sg13cmos5l_buf_1_10.X 0.10047f
C1234 VDD a_17710_16263# 0.16005f
C1235 a_17710_16263# sg13cmos5l_a21oi_1_0.A1 0.10824f
C1236 a_6789_14495# sg13cmos5l_dlygate4sd3_1_1.A 0.01319f
C1237 a_11752_15366# sg13cmos5l_dlygate4sd3_1_8.A 0.03099f
C1238 sg13cmos5l_or3_1_2.B a_21034_14452# 0.03049f
C1239 a_17165_16020# a_16969_16020# 0.01485f
C1240 sg13cmos5l_a21oi_1_3.B1 sg13cmos5l_dfrbpq_1_7.RESET_B 0.04148f
C1241 VDD a_21466_15202# 0.265f
C1242 sg13cmos5l_buf_8_2.X a_18123_14495# 0.02452f
C1243 sg13cmos5l_xnor2_1_2.B sg13cmos5l_dlygate4sd3_1_0.X 0.10767f
C1244 sg13cmos5l_dlygate4sd3_1_3.A a_2890_15457# 0.01478f
C1245 sg13cmos5l_o21ai_1_2.A2 sg13cmos5l_or3_1_2.B 0.55335f
C1246 a_7537_14845# sg13cmos5l_dlygate4sd3_1_1.A 0.01546f
C1247 sg13cmos5l_or3_1_1.A a_26170_15202# 0.01215f
C1248 VDD a_6280_13058# 0.16648f
C1249 a_2916_15552# sg13cmos5l_dfrbpq_1_0.RESET_B 0.28678f
C1250 VDD sg13cmos5l_a21oi_1_3.Y 0.39493f
C1251 sg13cmos5l_dlygate4sd3_1_4.X a_17710_16263# 0.01296f
C1252 sg13cmos5l_tiehi_1.L_HI a_9536_14570# 0.01076f
C1253 sg13cmos5l_dfrbpq_1_2.Q a_17994_14020# 0.0782f
C1254 sg13cmos5l_nand3_1_0.Y sg13cmos5l_xnor2_1_0.Y 0.05205f
C1255 sg13cmos5l_dfrbpq_1_2.RESET_B sg13cmos5l_a21oi_1_3.B1 0.03328f
C1256 sg13cmos5l_xor2_1_0.B sg13cmos5l_buf_1_10.X 2.58844f
C1257 VDD a_19048_13854# 0.14253f
C1258 a_20603_15532# sg13cmos5l_or3_1_2.X 0.06091f
C1259 sg13cmos5l_buf_1_10.X a_8685_14832# 0.108f
C1260 sg13cmos5l_dfrbpq_1_2.Q sg13cmos5l_dlygate4sd3_1_9.X 0.01954f
C1261 VDD a_1192_9948# 0.18614f
C1262 sg13cmos5l_dfrbpq_1_6.RESET_B sg13cmos5l_dfrbpq_1_2.Q 0.01328f
C1263 sg13cmos5l_tiehi_1.L_HI a_10703_15311# 0.1087f
C1264 VDD a_2516_14484# 0.14128f
C1265 sg13cmos5l_or3_1_2.C a_20774_14922# 0.03077f
C1266 VDD a_25206_15302# 0.16099f
C1267 a_21251_13690# sg13cmos5l_or3_1_2.X 0.13427f
C1268 sg13cmos5l_dfrbpq_1_6.D sg13cmos5l_buf_8_2.X 0.02715f
C1269 sg13cmos5l_or3_1_1.A a_24841_13726# 0.20349f
C1270 VDD a_24704_13854# 0.06781f
C1271 a_4175_15311# sg13cmos5l_dfrbpq_1_0.RESET_B 0.10904f
C1272 sg13cmos5l_dfrbpq_1_6.RESET_B a_21185_15424# 0.04526f
C1273 a_8582_15238# VDD 0.21098f
C1274 a_25670_14922# a_25956_14488# 0.26205f
C1275 a_17578_14452# a_17604_14488# 0.24169f
C1276 sg13cmos5l_tiehi_1.L_HI sg13cmos5l_dlygate4sd3_1_8.X 0.04348f
C1277 sg13cmos5l_dlygate4sd3_1_3.A sg13cmos5l_dfrbpq_1_2.CLK 0.05316f
C1278 sg13cmos5l_buf_1_0.X a_1192_3900# 0.15903f
C1279 a_18106_15960# sg13cmos5l_dlygate4sd3_1_5.A 0.28314f
C1280 a_25670_14922# a_26475_14495# 0.07916f
C1281 a_14261_15238# sg13cmos5l_dfrbpq_1_2.CLK 0.01831f
C1282 sg13cmos5l_a21oi_1_0.Y sg13cmos5l_dfrbpq_1_2.CLK 0.1806f
C1283 a_25930_14452# sg13cmos5l_buf_8_2.X 0.01411f
C1284 a_17604_14488# sg13cmos5l_buf_8_2.X 0.05299f
C1285 a_18021_14495# a_17892_14909# 0.01562f
C1286 sg13cmos5l_and2_1_2.X a_9158_15234# 0.16719f
C1287 sg13cmos5l_o21ai_1_2.B1 sg13cmos5l_or3_1_1.B 0.03172f
C1288 a_16140_15424# sg13cmos5l_inv_1_0.Y 0.08646f
C1289 a_3209_16334# a_3130_16237# 0.08889f
C1290 VDD a_7888_14726# 0.13652f
C1291 sg13cmos5l_or3_1_1.X sg13cmos5l_a21oi_1_3.A1 0.59456f
C1292 a_17238_15302# sg13cmos5l_dfrbpq_1_3.D 0.12541f
C1293 sg13cmos5l_a21oi_1_3.Y a_25956_14488# 0.02684f
C1294 sg13cmos5l_a21oi_1_3.B1 sg13cmos5l_dlygate4sd3_1_9.X 0.10511f
C1295 sg13cmos5l_dfrbpq_1_7.D a_25670_14922# 0.16976f
C1296 sg13cmos5l_dfrbpq_1_6.RESET_B sg13cmos5l_a21oi_1_3.B1 0.0175f
C1297 sg13cmos5l_tiehi_1.L_HI a_9444_15552# 0.29159f
C1298 a_9418_15457# a_9861_15213# 0.02241f
C1299 a_21466_15202# sg13cmos5l_or3_1_2.A 0.03705f
C1300 sg13cmos5l_o21ai_1_2.B1 a_24062_15242# 0.01812f
C1301 a_10960_15454# sg13cmos5l_dlygate4sd3_1_8.A 0.01793f
C1302 sg13cmos5l_o21ai_1_1.Y sg13cmos5l_buf_8_2.X 0.26217f
C1303 a_16485_13701# a_17233_13799# 0.01058f
C1304 VDD a_4842_15532# 0.28434f
C1305 sg13cmos5l_dfrbpq_1_2.Q a_16552_15996# 0.19543f
C1306 sg13cmos5l_o21ai_1_3.Y a_24408_15552# 0.01291f
C1307 sg13cmos5l_inv_1_0.Y a_18454_16374# 0.05732f
C1308 sg13cmos5l_dfrbpq_1_3.Q sg13cmos5l_or3_1_2.B 0.36223f
C1309 sg13cmos5l_xor2_1_0.B a_2490_14447# 0.22356f
C1310 VDD a_24408_15552# 0.01784f
C1311 VDD sg13cmos5l_dfrbpq_1_3.RESET_B 1.16418f
C1312 a_2516_14484# sg13cmos5l_xor2_1_0.X 0.06124f
C1313 sg13cmos5l_dlygate4sd3_1_8.X sg13cmos5l_xnor2_1_0.Y 0.01362f
C1314 sg13cmos5l_dlygate4sd3_1_3.A sg13cmos5l_dlygate4sd3_1_1.A 0.1901f
C1315 sg13cmos5l_buf_8_2.A sg13cmos5l_dfrbpq_1_3.RESET_B 0.03701f
C1316 sg13cmos5l_a21oi_1_3.A1 sg13cmos5l_buf_8_2.X 0.02668f
C1317 a_19120_14726# sg13cmos5l_dfrbpq_1_3.RESET_B 0.09622f
C1318 a_27407_13799# VDD 0.18933f
C1319 sg13cmos5l_dfrbpq_1_3.Q a_19816_15366# 0.05363f
C1320 a_24824_14525# a_25094_14484# 0.18796f
C1321 a_16856_15238# a_17126_15238# 0.18796f
C1322 sg13cmos5l_dlygate4sd3_1_4.X sg13cmos5l_dfrbpq_1_3.RESET_B 0.01938f
C1323 a_5687_15549# a_5886_15486# 0.08889f
C1324 sg13cmos5l_dfrbpq_1_5.Q a_27882_14484# 0.01003f
C1325 a_21060_14488# a_22225_14845# 0.25046f
C1326 a_20774_14922# a_21348_14909# 0.18486f
C1327 a_21060_14488# a_21477_14495# 0.28418f
C1328 sg13cmos5l_or3_1_2.B a_16969_16020# 0.17174f
C1329 sg13cmos5l_or3_1_1.B sg13cmos5l_a21oi_1_3.A2 0.10458f
C1330 a_16140_15424# sg13cmos5l_or3_1_1.B 0.03017f
C1331 a_9861_15213# sg13cmos5l_dlygate4sd3_1_8.A 0.01043f
C1332 a_38536_10034# a_38720_10034# 0.05762f
C1333 sg13cmos5l_dlygate4sd3_1_0.X sg13cmos5l_and2_1_1.X 0.05101f
C1334 a_27502_15423# a_27617_15424# 0.3854f
C1335 sg13cmos5l_nand4_1_0.Y a_12010_15202# 0.04366f
C1336 sg13cmos5l_or3_1_2.B sg13cmos5l_dfrbpq_1_2.Q 0.38942f
C1337 a_27617_15424# sg13cmos5l_dfrbpq_1_6.Q 0.04727f
C1338 sg13cmos5l_dfrbpq_1_6.RESET_B sg13cmos5l_or3_1_2.C 0.02463f
C1339 a_22319_14845# a_22225_14845# 0.16704f
C1340 a_21185_15424# sg13cmos5l_or3_1_2.B 0.03542f
C1341 VDD sg13cmos5l_o21ai_1_2.B1 0.449f
C1342 sg13cmos5l_a21oi_1_0.A2 sg13cmos5l_dfrbpq_1_3.RESET_B 0.01456f
C1343 sg13cmos5l_o21ai_1_2.A2 a_24169_14508# 0.15962f
C1344 sg13cmos5l_inv_1_0.Y clock_i 0.06063f
C1345 a_23368_14570# a_23552_14570# 0.05762f
C1346 sg13cmos5l_dfrbpq_1_2.Q a_17921_15424# 0.03888f
C1347 a_27500_15960# a_27296_16082# 0.01689f
C1348 a_8694_15302# sg13cmos5l_and2_1_2.B 0.12545f
C1349 a_18021_14495# sg13cmos5l_dfrbpq_1_3.RESET_B 0.04294f
C1350 VDD a_37484_15960# 0.22428f
C1351 VDD sg13cmos5l_dfrbpq_1_3.D 0.20543f
C1352 VDD a_25094_14484# 0.20607f
C1353 sg13cmos5l_buf_1_10.X reset_n_i 0.01015f
C1354 a_24824_14525# sg13cmos5l_a21oi_1_3.A2 0.06269f
C1355 a_11370_15532# a_11752_15366# 0.01648f
C1356 sg13cmos5l_or3_1_1.C sg13cmos5l_or3_1_2.B 0.39924f
C1357 sg13cmos5l_or3_1_1.A sg13cmos5l_or3_1_1.B 0.12822f
C1358 sg13cmos5l_o21ai_1_2.Y sg13cmos5l_buf_8_2.X 0.51052f
C1359 a_26554_16237# a_26757_16033# 0.02453f
C1360 sg13cmos5l_or3_1_1.B a_16485_13701# 0.02104f
C1361 a_26148_14040# sg13cmos5l_buf_8_2.X 0.04861f
C1362 sg13cmos5l_buf_1_0.X sg13cmos5l_dlygate4sd3_1_3.A 0.67869f
C1363 a_6346_14452# a_6372_14488# 0.24169f
C1364 sg13cmos5l_a21oi_1_3.B1 sg13cmos5l_or3_1_2.B 1.50917f
C1365 a_9963_15356# sg13cmos5l_dfrbpq_1_2.CLK 0.02366f
C1366 a_15870_15486# sg13cmos5l_nor2_1_0.B 0.0389f
C1367 sg13cmos5l_or3_1_1.B sg13cmos5l_or3_1_2.X 0.01428f
C1368 VDD a_26753_15424# 0.20784f
C1369 sg13cmos5l_dlygate4sd3_1_17.A a_24169_14508# 0.01646f
C1370 a_22304_16082# counter_value_o[4] 0.01136f
C1371 a_10337_14750# sg13cmos5l_buf_1_10.X 0.01927f
C1372 a_2630_15234# a_3333_15213# 0.02453f
C1373 VDD a_23168_15366# 0.10558f
C1374 a_6372_14488# a_7631_14845# 0.01412f
C1375 a_32492_15960# sg13cmos5l_dfrbpq_1_7.Q 0.1927f
C1376 a_26249_16334# sg13cmos5l_dfrbpq_1_7.RESET_B 0.01098f
C1377 sg13cmos5l_o21ai_1_3.Y a_26170_16237# 0.03498f
C1378 VDD a_21579_14495# 0.21266f
C1379 a_9158_15234# a_9732_15247# 0.18486f
C1380 VDD sg13cmos5l_dfrbpq_1_0.RESET_B 1.2525f
C1381 VDD sg13cmos5l_dfrbpq_1_5.RESET_B 1.27461f
C1382 VDD a_26170_16237# 0.09144f
C1383 a_7631_14845# a_8298_14484# 0.09257f
C1384 a_6401_13912# sg13cmos5l_dlygate4sd3_1_0.A 0.04884f
C1385 a_2916_15552# a_4175_15311# 0.01412f
C1386 sg13cmos5l_or3_1_1.A a_24824_14525# 0.0282f
C1387 VDD sg13cmos5l_a21oi_1_3.A2 0.40843f
C1388 sg13cmos5l_dfrbpq_1_3.D sg13cmos5l_a21oi_1_0.A2 0.13532f
C1389 VDD a_16140_15424# 0.18406f
C1390 sg13cmos5l_dfrbpq_1_6.RESET_B a_20774_14922# 0.07398f
C1391 sg13cmos5l_or3_1_1.B clock_i 0.07955f
C1392 VDD a_21070_15423# 0.15921f
C1393 sg13cmos5l_buf_1_10.X a_2490_14447# 0.01712f
C1394 VDD sg13cmos5l_dfrbpq_1_7.Q 1.33022f
C1395 a_3333_15213# a_4081_15311# 0.01058f
C1396 sg13cmos5l_or3_1_1.X sg13cmos5l_dfrbpq_1_6.Q 0.01503f
C1397 a_12524_15960# a_12232_16082# 0.01635f
C1398 sg13cmos5l_dfrbpq_1_2.RESET_B a_16068_14040# 0.30414f
C1399 VDD a_26633_16334# 0.10189f
C1400 VDD sg13cmos5l_dlygate4sd3_1_0.A 0.32455f
C1401 sg13cmos5l_o21ai_1_2.B1 sg13cmos5l_dfrbpq_1_7.D 0.02262f
C1402 sg13cmos5l_inv_1_0.A sg13cmos5l_dfrbpq_1_2.Q 0.70863f
C1403 sg13cmos5l_or3_1_2.C sg13cmos5l_or3_1_2.B 0.64121f
C1404 a_21562_15960# sg13cmos5l_a21oi_1_1.Y 0.28648f
C1405 sg13cmos5l_and2_1_2.B sg13cmos5l_nand4_1_0.Y 0.01346f
C1406 sg13cmos5l_xor2_1_0.B sg13cmos5l_and2_1_0.X 0.16893f
C1407 VDD a_14344_14570# 0.15065f
C1408 sg13cmos5l_o21ai_1_3.Y sg13cmos5l_or3_1_1.A 0.21954f
C1409 sg13cmos5l_or3_1_1.B a_21251_13690# 0.02075f
C1410 a_10960_15454# a_11370_15532# 0.07015f
C1411 VDD sg13cmos5l_or3_1_1.A 0.48327f
C1412 a_22986_14484# sg13cmos5l_buf_8_2.X 0.01572f
C1413 a_21060_14488# sg13cmos5l_buf_8_2.X 0.06778f
C1414 a_17318_14922# a_17578_14452# 0.45119f
C1415 VDD a_16485_13701# 0.27675f
C1416 VDD a_21824_15366# 0.07818f
C1417 a_6346_14452# sg13cmos5l_dfrbpq_1_2.CLK 0.01513f
C1418 a_15782_13722# a_16485_13701# 0.02453f
C1419 sg13cmos5l_or3_1_1.B a_24841_13726# 0.16221f
C1420 sg13cmos5l_buf_8_2.X sg13cmos5l_dfrbpq_1_6.Q 0.11448f
C1421 a_25956_14488# sg13cmos5l_dfrbpq_1_5.RESET_B 0.01473f
C1422 sg13cmos5l_o21ai_1_2.A2 a_23480_15242# 0.01468f
C1423 sg13cmos5l_dlygate4sd3_1_4.X a_18454_16374# 0.02479f
C1424 a_21466_15202# a_21477_14495# 0.01088f
C1425 VDD a_19530_14484# 0.28068f
C1426 a_24824_15238# sg13cmos5l_o21ai_1_2.Y 0.27487f
C1427 a_24169_14508# a_24263_14508# 0.02103f
C1428 VDD sg13cmos5l_or3_1_2.X 0.34653f
C1429 a_22319_14845# sg13cmos5l_buf_8_2.X 0.02057f
C1430 VDD a_22304_16082# 0.07521f
C1431 a_21281_16262# sg13cmos5l_a21oi_1_1.Y 0.02116f
C1432 a_21946_16237# a_21562_15960# 0.01303f
C1433 VDD a_18552_15976# 0.01784f
C1434 a_15671_15549# clock_i 0.03769f
C1435 sg13cmos5l_dfrbpq_1_6.D a_21166_16263# 0.10665f
C1436 a_19120_14726# a_19530_14484# 0.07015f
C1437 a_16587_13844# a_17327_13799# 0.17382f
C1438 a_25862_13722# a_26148_14040# 0.26205f
C1439 a_26475_14495# sg13cmos5l_dfrbpq_1_5.RESET_B 0.02481f
C1440 a_5687_15549# VDD 0.09536f
C1441 VDD a_1856_14570# 0.08533f
C1442 a_26373_14495# sg13cmos5l_dfrbpq_1_7.RESET_B 0.03634f
C1443 sg13cmos5l_a21oi_1_3.B1 sg13cmos5l_inv_1_0.A 0.05318f
C1444 sg13cmos5l_nand4_1_0.Y a_8312_15238# 0.0158f
C1445 sg13cmos5l_dfrbpq_1_7.Q a_25956_14488# 0.03198f
C1446 sg13cmos5l_a21oi_1_2.A1 a_25390_16263# 0.10831f
C1447 a_20705_15260# sg13cmos5l_dlygate4sd3_1_9.X 0.01276f
C1448 a_9158_15234# VDD 0.52421f
C1449 a_3435_15356# a_3204_15247# 0.07823f
C1450 a_27472_14726# sg13cmos5l_dfrbpq_1_7.RESET_B 0.09622f
C1451 a_25889_15424# sg13cmos5l_dfrbpq_1_7.RESET_B 0.08041f
C1452 a_9963_15356# a_10960_15454# 0.03412f
C1453 sg13cmos5l_dfrbpq_1_7.Q a_26475_14495# 0.03274f
C1454 sg13cmos5l_tiehi_1.L_HI sg13cmos5l_buf_1_10.X 0.03277f
C1455 VDD clock_i 1.62643f
C1456 a_19054_15423# a_19169_15424# 0.3854f
C1457 a_18789_15277# a_18665_15180# 0.08186f
C1458 a_22508_15960# a_22304_16082# 0.01689f
C1459 sg13cmos5l_dfrbpq_1_6.D sg13cmos5l_dfrbpq_1_3.Q 0.01666f
C1460 sg13cmos5l_dfrbpq_1_6.D a_20960_16082# 0.01243f
C1461 sg13cmos5l_buf_8_2.A clock_i 0.02615f
C1462 sg13cmos5l_dlygate4sd3_1_0.X sg13cmos5l_buf_1_10.X 0.06585f
C1463 sg13cmos5l_or3_1_1.C a_24169_14508# 0.03594f
C1464 a_27664_13942# a_28074_14020# 0.07015f
C1465 a_26122_13945# sg13cmos5l_dfrbpq_1_5.RESET_B 0.20792f
C1466 counter_value_o[2] clock_i 0.0407f
C1467 VDD a_23736_14464# 0.01784f
C1468 sg13cmos5l_dlygate4sd3_1_3.A a_4842_15532# 0.12425f
C1469 VDD a_16955_14484# 0.20174f
C1470 sg13cmos5l_a21oi_1_0.A1 a_16955_14484# 0.02731f
C1471 a_10609_15311# sg13cmos5l_dlygate4sd3_1_8.A 0.0173f
C1472 sg13cmos5l_or3_1_2.B a_20774_14922# 0.04313f
C1473 a_17806_15423# a_17921_15424# 0.3854f
C1474 sg13cmos5l_or3_1_2.B a_24310_15230# 0.07683f
C1475 sg13cmos5l_dfrbpq_1_2.Q a_18123_14495# 0.04207f
C1476 VDD a_20603_15532# 0.16158f
C1477 sg13cmos5l_or3_1_2.A a_21824_15366# 0.01319f
C1478 VDD a_38720_13854# 0.05657f
C1479 VDD a_27215_14845# 0.17631f
C1480 VDD a_26170_15202# 0.25937f
C1481 a_7631_14845# sg13cmos5l_dlygate4sd3_1_1.A 0.04295f
C1482 sg13cmos5l_tiehi_1.L_HI a_9658_14725# 0.06039f
C1483 sg13cmos5l_or3_1_2.B a_21348_14909# 0.01476f
C1484 sg13cmos5l_a21oi_1_2.A1 sg13cmos5l_or3_1_1.X 0.23534f
C1485 VDD a_21251_13690# 0.28201f
C1486 sg13cmos5l_nand4_1_0.Y sg13cmos5l_dfrbpq_1_2.CLK 1.61147f
C1487 sg13cmos5l_or3_1_2.A sg13cmos5l_or3_1_2.X 0.55116f
C1488 sg13cmos5l_or3_1_1.B sg13cmos5l_inv_1_0.Y 0.86348f
C1489 sg13cmos5l_and2_1_2.X VDD 0.32197f
C1490 a_3435_15356# sg13cmos5l_dfrbpq_1_2.CLK 0.01756f
C1491 a_9861_15213# a_9963_15356# 0.36168f
C1492 sg13cmos5l_dfrbpq_1_2.Q a_19169_15424# 0.0208f
C1493 VDD a_25109_12972# 0.21318f
C1494 a_7680_15549# sg13cmos5l_dlygate4sd3_1_1.A 0.05742f
C1495 VDD a_5613_14832# 0.30068f
C1496 VDD a_4078_14751# 0.15946f
C1497 sg13cmos5l_dfrbpq_1_6.D sg13cmos5l_dfrbpq_1_2.Q 0.01319f
C1498 VDD counter_value_o[7] 0.1164f
C1499 VDD a_24841_13726# 0.26704f
C1500 sg13cmos5l_xnor2_1_2.B a_6372_14488# 0.03099f
C1501 VDD a_38720_3986# 0.0582f
C1502 counter_value_o[1] clock_i 0.0407f
C1503 sg13cmos5l_a21oi_1_0.A2 a_16955_14484# 0.05566f
C1504 a_32492_15960# counter_value_o[6] 0.15504f
C1505 sg13cmos5l_o21ai_1_2.A2 sg13cmos5l_o21ai_1_2.Y 0.08237f
C1506 sg13cmos5l_or3_1_1.X sg13cmos5l_a21oi_1_3.Y 0.01332f
C1507 sg13cmos5l_a21oi_1_3.B1 a_18123_14495# 0.01374f
C1508 sg13cmos5l_dfrbpq_1_2.Q a_17604_14488# 0.02704f
C1509 a_25670_14922# sg13cmos5l_buf_8_2.X 0.01876f
C1510 sg13cmos5l_and2_1_0.X sg13cmos5l_buf_1_10.X 0.04444f
C1511 sg13cmos5l_and2_1_2.B sg13cmos5l_dlygate4sd3_1_8.X 0.03311f
C1512 a_26565_13701# sg13cmos5l_dfrbpq_1_5.RESET_B 0.03932f
C1513 VDD a_2916_15552# 0.09493f
C1514 a_2540_15960# a_2248_16082# 0.01635f
C1515 sg13cmos5l_or3_1_1.X a_25206_15302# 0.05682f
C1516 a_25956_14488# a_27215_14845# 0.01412f
C1517 sg13cmos5l_dlygate4sd3_1_8.X a_6372_14488# 0.02859f
C1518 sg13cmos5l_inv_1_0.Y counter_value_o[3] 0.15994f
C1519 sg13cmos5l_nand4_1_0.Y sg13cmos5l_dlygate4sd3_1_1.A 0.27454f
C1520 sg13cmos5l_dfrbpq_1_6.D sg13cmos5l_a21oi_1_3.B1 0.04716f
C1521 a_9418_15457# a_9158_15234# 0.45119f
C1522 a_15671_15549# sg13cmos5l_inv_1_0.Y 0.01387f
C1523 VDD counter_value_o[6] 0.12121f
C1524 sg13cmos5l_o21ai_1_1.Y sg13cmos5l_dfrbpq_1_2.Q 0.02544f
C1525 sg13cmos5l_or3_1_2.A a_21251_13690# 0.20657f
C1526 VDD a_4175_15311# 0.17883f
C1527 sg13cmos5l_dlygate4sd3_1_17.A sg13cmos5l_o21ai_1_2.Y 0.21213f
C1528 a_26475_14495# a_27215_14845# 0.17382f
C1529 sg13cmos5l_a21oi_1_3.Y sg13cmos5l_buf_8_2.X 0.07372f
C1530 a_17806_15423# sg13cmos5l_inv_1_0.A 0.12443f
C1531 sg13cmos5l_dfrbpq_1_1.RESET_B a_6372_14488# 0.29766f
C1532 counter_value_o[0] clock_i 0.04197f
C1533 VDD a_18202_15202# 0.26193f
C1534 VDD a_5886_15486# 0.09482f
C1535 sg13cmos5l_a21oi_1_3.B1 a_17604_14488# 0.03688f
C1536 VDD a_20000_15366# 0.07202f
C1537 sg13cmos5l_a21oi_1_3.A1 sg13cmos5l_dfrbpq_1_5.D 0.10222f
C1538 a_16856_15238# sg13cmos5l_dfrbpq_1_2.CLK 0.01408f
C1539 a_6086_14922# a_6372_14488# 0.26205f
C1540 VDD sg13cmos5l_inv_1_0.Y 0.76193f
C1541 sg13cmos5l_inv_1_0.Y sg13cmos5l_a21oi_1_0.A1 0.05298f
C1542 sg13cmos5l_dfrbpq_1_6.RESET_B sg13cmos5l_or3_1_2.B 0.24505f
C1543 a_21251_13690# a_21460_14020# 0.01485f
C1544 a_19048_13854# a_19232_13854# 0.05762f
C1545 sg13cmos5l_xnor2_1_2.B sg13cmos5l_dfrbpq_1_2.CLK 0.02511f
C1546 sg13cmos5l_dlygate4sd3_1_3.A sg13cmos5l_dfrbpq_1_0.RESET_B 0.11811f
C1547 sg13cmos5l_nand3_1_0.Y sg13cmos5l_dlygate4sd3_1_1.A 0.37433f
C1548 a_21034_14452# a_21060_14488# 0.24169f
C1549 sg13cmos5l_o21ai_1_1.Y sg13cmos5l_a21oi_1_3.B1 0.03114f
C1550 VDD counter_value_o[5] 0.13222f
C1551 sg13cmos5l_dfrbpq_1_3.RESET_B a_18665_15180# 0.01111f
C1552 sg13cmos5l_inv_1_0.Y sg13cmos5l_dlygate4sd3_1_4.X 0.90342f
C1553 a_4078_14751# a_4193_14750# 0.3854f
C1554 sg13cmos5l_nand4_1_0.Y a_10960_15454# 0.0126f
C1555 a_27034_15202# sg13cmos5l_dfrbpq_1_6.Q 0.01446f
C1556 sg13cmos5l_xnor2_1_2.A a_6372_14488# 0.01799f
C1557 a_25206_15302# a_25774_15423# 0.01641f
C1558 sg13cmos5l_and2_1_0.X a_2490_14447# 0.05334f
C1559 a_16140_15424# sg13cmos5l_a21oi_1_0.Y 0.03336f
C1560 clock_i sg13cmos5l_dlygate4sd3_1_8.A 0.08616f
C1561 a_10703_15311# sg13cmos5l_dfrbpq_1_2.CLK 0.01174f
C1562 a_22576_14726# a_22986_14484# 0.07015f
C1563 a_21477_14495# a_21579_14495# 0.3643f
C1564 sg13cmos5l_o21ai_1_2.A2 sg13cmos5l_dfrbpq_1_6.Q 0.19177f
C1565 VDD a_22145_15424# 0.21275f
C1566 sg13cmos5l_a21oi_1_3.B1 sg13cmos5l_a21oi_1_3.A1 0.26386f
C1567 sg13cmos5l_buf_1_0.X sg13cmos5l_nand4_1_0.Y 0.0546f
C1568 a_16587_13844# sg13cmos5l_dfrbpq_1_2.CLK 0.04306f
C1569 sg13cmos5l_dfrbpq_1_2.RESET_B sg13cmos5l_inv_1_0.A 0.01762f
C1570 a_22576_14726# a_22319_14845# 0.23043f
C1571 sg13cmos5l_dlygate4sd3_1_8.X sg13cmos5l_dfrbpq_1_2.CLK 0.39427f
C1572 sg13cmos5l_inv_1_0.Y sg13cmos5l_a21oi_1_0.A2 0.01864f
C1573 a_8582_15238# a_8694_15302# 0.3854f
C1574 sg13cmos5l_buf_1_0.X a_3435_15356# 0.01828f
C1575 a_17578_14452# sg13cmos5l_dfrbpq_1_3.RESET_B 0.19309f
C1576 a_18021_14495# a_18202_15202# 0.0121f
C1577 sg13cmos5l_dlygate4sd3_1_1.A a_7822_13911# 0.01022f
C1578 VDD a_17238_15302# 0.16045f
C1579 sg13cmos5l_or3_1_2.B a_16552_15996# 0.09282f
C1580 sg13cmos5l_buf_8_2.X sg13cmos5l_dfrbpq_1_3.RESET_B 0.01196f
C1581 VDD sg13cmos5l_or3_1_1.B 1.88587f
C1582 sg13cmos5l_dfrbpq_1_1.RESET_B sg13cmos5l_dfrbpq_1_2.CLK 0.03866f
C1583 a_26373_16033# a_26554_16237# 0.04141f
C1584 sg13cmos5l_or3_1_1.B a_15782_13722# 0.04779f
C1585 VDD counter_value_o[4] 0.09581f
C1586 sg13cmos5l_buf_8_2.A sg13cmos5l_or3_1_1.B 0.33039f
C1587 sg13cmos5l_xor2_1_0.B a_3872_14570# 0.01249f
C1588 a_9861_15213# sg13cmos5l_nand4_1_0.Y 0.0176f
C1589 sg13cmos5l_dlygate4sd3_1_17.A sg13cmos5l_dfrbpq_1_6.Q 0.01411f
C1590 VDD a_20278_14862# 0.01267f
C1591 sg13cmos5l_or3_1_1.X sg13cmos5l_o21ai_1_2.B1 0.01824f
C1592 a_9444_15552# sg13cmos5l_dfrbpq_1_2.CLK 0.08307f
C1593 counter_value_o[7] VSS 2.33359f
C1594 counter_value_o[6] VSS 1.63261f
C1595 counter_value_o[5] VSS 1.92698f
C1596 counter_value_o[4] VSS 1.56945f
C1597 counter_value_o[3] VSS 1.53899f
C1598 counter_value_o[2] VSS 1.74775f
C1599 counter_value_o[1] VSS 1.5799f
C1600 counter_value_o[0] VSS 1.63892f
C1601 a_38720_3986# VSS 0.07631f ; **FLOATING
C1602 a_38536_3986# VSS 0.10768f ; **FLOATING
C1603 a_38720_10034# VSS 0.07628f ; **FLOATING
C1604 a_38536_10034# VSS 0.10768f ; **FLOATING
C1605 a_38720_13058# VSS 0.08763f ; **FLOATING
C1606 a_25109_12972# VSS 0.25522f
C1607 a_25203_13320# VSS 0.45994f
C1608 a_6575_13342# VSS 0.20137f
C1609 a_6280_13058# VSS 0.09809f ; **FLOATING
C1610 a_38720_13854# VSS 0.07452f ; **FLOATING
C1611 a_38536_13854# VSS 0.10767f ; **FLOATING
C1612 a_27826_13722# VSS 0.39632f
C1613 a_27313_13799# VSS 0.06782f
C1614 a_26374_13735# VSS 0.53262f
C1615 a_26436_13735# VSS 0.53884f
C1616 a_27609_14037# VSS 0.29831f
C1617 a_25956_13722# VSS 0.06121f
C1618 a_26505_14113# VSS 0.13109f
C1619 a_25862_13722# VSS 0.30589f
C1620 a_25037_14020# VSS 0.26318f
C1621 a_24704_13854# VSS 0.0401f ; **FLOATING
C1622 a_24520_13854# VSS 0.1039f ; **FLOATING
C1623 a_24841_13726# VSS 0.15095f
C1624 a_21549_14020# VSS 0.28251f
C1625 a_21460_14020# VSS 0.52082f
C1626 a_20968_13854# VSS 0.09008f ; **FLOATING
C1627 a_19232_13854# VSS 0.03773f ; **FLOATING
C1628 a_19048_13854# VSS 0.09994f ; **FLOATING
C1629 a_21251_13690# VSS 0.03834f
C1630 a_17233_13799# VSS 0.20929f
C1631 a_16356_13735# VSS 0.13271f
C1632 a_17529_14037# VSS 0.07696f
C1633 a_16425_14113# VSS 0.50217f
C1634 a_16068_14040# VSS 0.20049f
C1635 a_15782_13722# VSS 1.15951f
C1636 a_15680_13854# VSS 0.04657f ; **FLOATING
C1637 a_6080_13854# VSS 0.03878f ; **FLOATING
C1638 a_5896_13854# VSS 0.10286f ; **FLOATING
C1639 a_6286_13911# VSS 0.14189f
C1640 a_38720_14570# VSS 0.08673f ; **FLOATING
C1641 a_27417_14607# VSS 0.12686f
C1642 a_26313_14531# VSS 0.09521f
C1643 a_27634_14922# VSS 0.04455f
C1644 a_27121_14845# VSS 0.0678f
C1645 a_27472_14726# VSS 0.02568f
C1646 a_26244_14909# VSS 0.55965f
C1647 a_26182_14909# VSS 0.79375f
C1648 a_24263_14508# VSS 0.59707f
C1649 a_23736_14464# VSS 0.04886f
C1650 a_25764_14922# VSS 0.16376f
C1651 a_25670_14922# VSS 0.72012f
C1652 a_25094_14484# VSS 0.18968f
C1653 a_23552_14570# VSS 0.03863f ; **FLOATING
C1654 a_23368_14570# VSS 0.08476f ; **FLOATING
C1655 a_23638_14862# VSS 0.16918f
C1656 a_21417_14531# VSS 0.57652f
C1657 a_20376_14464# VSS 0.24207f
C1658 a_22225_14845# VSS 0.28476f
C1659 a_21348_14909# VSS 0.03666f
C1660 a_20868_14922# VSS 0.17329f
C1661 a_20774_14922# VSS 0.50797f
C1662 a_20278_14862# VSS 0.18479f
C1663 a_17961_14531# VSS 0.07346f
C1664 a_18769_14845# VSS 0.30331f
C1665 a_17892_14909# VSS 0.54013f
C1666 a_17830_14909# VSS 0.50346f
C1667 a_16955_14484# VSS 0.16646f
C1668 a_15338_14484# VSS 0.31827f
C1669 a_17412_14922# VSS 0.19118f
C1670 a_17057_14832# VSS 0.25488f
C1671 a_17318_14922# VSS 0.55406f
C1672 a_14344_14570# VSS 0.11656f ; **FLOATING
C1673 a_10016_14570# VSS 0.0411f ; **FLOATING
C1674 a_10618_14448# VSS 0.09765f
C1675 a_10222_14751# VSS 0.16058f
C1676 a_9536_14570# VSS 0.04987f ; **FLOATING
C1677 a_7833_14607# VSS 0.21642f
C1678 a_9658_14725# VSS 0.08137f
C1679 a_8779_14832# VSS 2.05795f
C1680 a_6729_14531# VSS 0.50345f
C1681 a_8050_14922# VSS 0.43618f
C1682 a_7537_14845# VSS 0.14418f
C1683 a_6660_14909# VSS 0.35245f
C1684 a_6598_14909# VSS 0.31578f
C1685 a_6180_14922# VSS 0.18831f
C1686 a_5707_14832# VSS 0.04721f
C1687 a_5504_14570# VSS 0.06581f ; **FLOATING
C1688 a_6086_14922# VSS 0.60611f
C1689 sg13cmos5l_dlygate4sd3_1_0.X VSS 0.04225f
C1690 a_3872_14570# VSS 0.06949f ; **FLOATING
C1691 a_2516_14484# VSS 0.22627f
C1692 a_2646_14842# VSS 0.0482f
C1693 a_2059_14832# VSS 0.62272f
C1694 a_1856_14570# VSS 0.06669f ; **FLOATING
C1695 a_1965_14832# VSS 0.07071f
C1696 a_38720_15366# VSS 0.08766f ; **FLOATING
C1697 a_27502_15423# VSS 0.16892f
C1698 a_24310_15230# VSS 1.57381f
C1699 a_24062_15242# VSS 0.06305f
C1700 a_23858_15242# VSS 0.01275f
C1701 a_23480_15242# VSS 0.09203f
C1702 a_23378_15242# VSS 0.04678f
C1703 a_25094_15238# VSS 0.18921f
C1704 sg13cmos5l_o21ai_1_2.Y VSS 0.11754f
C1705 a_24408_15552# VSS 0.41208f
C1706 a_23168_15366# VSS 0.05136f ; **FLOATING
C1707 a_21824_15366# VSS 0.04409f ; **FLOATING
C1708 a_20705_15260# VSS 0.09764f
C1709 a_20603_15532# VSS 0.32519f
C1710 a_20000_15366# VSS 0.03804f ; **FLOATING
C1711 a_19816_15366# VSS 0.08226f ; **FLOATING
C1712 a_21070_15423# VSS 0.03026f
C1713 sg13cmos5l_dlygate4sd3_1_9.X VSS 0.09206f
C1714 a_18665_15180# VSS 0.05051f
C1715 a_16175_15238# VSS 0.37281f
C1716 a_17238_15302# VSS 0.19906f
C1717 sg13cmos5l_a21oi_1_0.Y VSS 0.0238f
C1718 a_15870_15486# VSS 0.0567f
C1719 a_11752_15366# VSS 0.08325f ; **FLOATING
C1720 a_10609_15311# VSS 0.14761f
C1721 a_9670_15247# VSS 0.07864f
C1722 a_9732_15247# VSS 0.1153f
C1723 a_10905_15549# VSS 0.09938f
C1724 a_9252_15234# VSS 0.20127f
C1725 a_7829_15238# VSS 0.09487f
C1726 a_9801_15625# VSS 0.50347f
C1727 a_9158_15234# VSS 1.45711f
C1728 a_9418_15457# VSS 0.0195f
C1729 a_8582_15238# VSS 0.3273f
C1730 a_7058_15242# VSS 0.49023f
C1731 a_6578_15242# VSS 0.56482f
C1732 a_7923_15532# VSS 0.30095f
C1733 sg13cmos5l_nand4_1_0.Y VSS 0.03957f
C1734 a_5600_15366# VSS 0.04738f ; **FLOATING
C1735 a_5886_15486# VSS 0.0851f
C1736 a_4081_15311# VSS 0.14662f
C1737 a_3142_15247# VSS 0.97322f
C1738 a_3204_15247# VSS 0.72225f
C1739 a_3273_15625# VSS 0.02173f
C1740 a_2630_15234# VSS 0.4784f
C1741 sg13cmos5l_and2_1_0.X VSS 0.09449f
C1742 a_2528_15366# VSS 0.06282f ; **FLOATING
C1743 a_2890_15457# VSS 0.09289f
C1744 a_37192_16082# VSS 0.09909f ; **FLOATING
C1745 a_37484_15960# VSS 0.01239f
C1746 a_32200_16082# VSS 0.09676f ; **FLOATING
C1747 a_27296_16082# VSS 0.05227f ; **FLOATING
C1748 a_24923_15996# VSS 0.22259f
C1749 a_26170_16237# VSS 0.08239f
C1750 a_25025_16344# VSS 0.25926f
C1751 sg13cmos5l_dlygate4sd3_1_17.A VSS 0.15997f
C1752 a_26633_16334# VSS 0.07084f
C1753 a_25786_15960# VSS 0.41618f
C1754 a_25390_16263# VSS 0.06506f
C1755 a_22304_16082# VSS 0.04037f ; **FLOATING
C1756 a_21946_16237# VSS 0.05753f
C1757 a_20960_16082# VSS 0.06776f ; **FLOATING
C1758 a_17165_16020# VSS 0.1776f
C1759 sg13cmos5l_dfrbpq_1_6.D VSS 0.18416f
C1760 a_22025_16334# VSS 0.04998f
C1761 a_18454_16374# VSS 0.15119f
C1762 a_16969_16020# VSS 0.10779f
C1763 sg13cmos5l_inv_1_0.Y VSS 0.2253f
C1764 a_12232_16082# VSS 0.09383f ; **FLOATING
C1765 sg13cmos5l_dlygate4sd3_1_1.A VSS 0.09828f
C1766 a_7240_16082# VSS 0.09487f ; **FLOATING
C1767 a_3008_16082# VSS 0.03902f ; **FLOATING
C1768 a_2824_16082# VSS 0.07953f ; **FLOATING
C1769 a_3130_16237# VSS 0.09764f
C1770 a_2248_16082# VSS 0.10237f ; **FLOATING
C1771 VSS.t75 VSS 0.29772f
C1772 VSS.t11 VSS 1.97393f
C1773 VSS.t162 VSS 0.4511f
C1774 VSS.t2912 VSS 0.01995f
C1775 VSS.t2927 VSS 0.17545f
C1776 VSS.t2932 VSS 0.06052f
C1777 VSS.t2947 VSS 0.09964f
C1778 VSS.t2967 VSS 0.09178f
C1779 VSS.t2666 VSS 0.05735f
C1780 VSS.t2623 VSS 0.01049f
C1781 VSS.t2622 VSS 0.01049f
C1782 VSS.t2626 VSS 0.0238f
C1783 VSS.t2629 VSS 0.03603f
C1784 VSS.t2633 VSS 0.01239f
C1785 VSS.t2646 VSS 0.04333f
C1786 VSS.t2645 VSS 0.04333f
C1787 VSS.t2651 VSS 0.06747f
C1788 VSS.t2652 VSS 0.2965f
C1789 VSS.t2656 VSS 0.29777f
C1790 VSS.t2657 VSS 0.29777f
C1791 VSS.t2665 VSS 0.05735f
C1792 VSS.t2676 VSS 0.02266f
C1793 VSS.t2681 VSS 0.08782f
C1794 VSS.t2680 VSS 0.08782f
C1795 VSS.t2687 VSS 0.09598f
C1796 VSS.t2693 VSS 0.16135f
C1797 VSS.t2696 VSS 0.45397f
C1798 VSS.t2702 VSS 0.23404f
C1799 VSS.t2701 VSS 0.29721f
C1800 VSS.t2741 VSS 0.21872f
C1801 VSS.t2738 VSS 0.02111f
C1802 VSS.t2746 VSS 0.0598f
C1803 VSS.t2745 VSS 0.06765f
C1804 VSS.t2755 VSS 0.11915f
C1805 VSS.t2757 VSS 0.58199f
C1806 VSS.t2756 VSS 0.58199f
C1807 VSS.t2764 VSS 0.15104f
C1808 VSS.t2767 VSS 0.14021f
C1809 VSS.t2770 VSS 0.06319f
C1810 VSS.t2384 VSS 0.36388f
C1811 VSS.t2369 VSS 0.50347f
C1812 VSS.t2364 VSS 0.17205f
C1813 VSS.t2349 VSS 0.25173f
C1814 VSS.t2343 VSS 1.63396f
C1815 VSS.t2344 VSS 1.63396f
C1816 VSS.t2336 VSS 0.02552f
C1817 VSS.t2339 VSS 0.12129f
C1818 VSS.t2334 VSS 0.4772f
C1819 VSS.t2329 VSS 0.26967f
C1820 VSS.t2324 VSS 0.49836f
C1821 VSS.t2314 VSS 0.16676f
C1822 VSS.t2308 VSS 0.0826f
C1823 VSS.t2309 VSS 0.0826f
C1824 VSS.t2304 VSS 0.08651f
C1825 VSS.t2298 VSS 0.22939f
C1826 VSS.t2299 VSS 0.26542f
C1827 VSS.t2286 VSS 0.08667f
C1828 VSS.t2288 VSS 0.14106f
C1829 VSS.t2289 VSS 0.14106f
C1830 VSS.t2283 VSS 0.07476f
C1831 VSS.t2284 VSS 0.16143f
C1832 VSS.t2276 VSS 0.17661f
C1833 VSS.t2274 VSS 0.57558f
C1834 VSS.t2269 VSS 1.09977f
C1835 VSS.t2261 VSS 0.50347f
C1836 VSS.t2264 VSS 0.11469f
C1837 VSS.t2259 VSS 0.50347f
C1838 VSS.t2254 VSS 0.22698f
C1839 VSS.t2234 VSS 0.04589f
C1840 VSS.t2228 VSS 0.098f
C1841 VSS.t2229 VSS 0.098f
C1842 VSS.t150 VSS 0.50171f
C1843 VSS.t37 VSS 0.08544f
C1844 VSS.t119 VSS 0.64105f
C1845 VSS.t121 VSS 0.02525f
C1846 VSS.t39 VSS 0.30151f
C1847 VSS.t1 VSS 0.06244f
C1848 VSS.t184 VSS 0.55463f
C1849 VSS.t111 VSS 0.48365f
C1850 VSS.t30 VSS 0.37156f
C1851 VSS.t556 VSS 0.04725f
C1852 VSS.t543 VSS 0.01802f
C1853 VSS.t546 VSS 0.01924f
C1854 VSS.t541 VSS 0.01802f
C1855 VSS.t536 VSS 0.03919f
C1856 VSS.t531 VSS 0.03373f
C1857 VSS.t523 VSS 0.17154f
C1858 VSS.t526 VSS 0.06046f
C1859 VSS.t252 VSS 0.08634f
C1860 VSS.t520 VSS 0.0238f
C1861 VSS.t521 VSS 0.19534f
C1862 VSS.t44 VSS 0.48825f
C1863 VSS.t508 VSS 0.05875f
C1864 VSS.t501 VSS 0.01626f
C1865 VSS.t566 VSS 0.25554f
C1866 VSS.t570 VSS 0.24843f
C1867 VSS.t678 VSS 0.24843f
C1868 VSS.t49 VSS 0.20049f
C1869 VSS.t87 VSS 0.3123f
C1870 VSS.t573 VSS 0.35549f
C1871 VSS.t704 VSS 0.03782f
C1872 VSS.t578 VSS 0.02505f
C1873 VSS.t703 VSS 0.03834f
C1874 VSS.t580 VSS 0.02505f
C1875 VSS.t67 VSS 0.78513f
C1876 VSS.t145 VSS 0.0722f
C1877 VSS.t724 VSS 0.32579f
C1878 VSS.t723 VSS 0.32579f
C1879 VSS.t728 VSS 0.64302f
C1880 VSS.t617 VSS 0.07207f
C1881 VSS.t1004 VSS 0.10671f
C1882 VSS.t994 VSS 0.09974f
C1883 VSS.t983 VSS 0.11646f
C1884 VSS.t984 VSS 0.11646f
C1885 VSS.t974 VSS 0.06261f
C1886 VSS.t961 VSS 0.13302f
C1887 VSS.t959 VSS 0.13302f
C1888 VSS.t954 VSS 0.03542f
C1889 VSS.t948 VSS 0.04799f
C1890 VSS.t949 VSS 0.04799f
C1891 VSS.t944 VSS 0.05104f
C1892 VSS.t939 VSS 0.23779f
C1893 VSS.t933 VSS 0.0647f
C1894 VSS.t934 VSS 0.20536f
C1895 VSS.t914 VSS 0.21343f
C1896 VSS.t889 VSS 0.01475f
C1897 VSS.t883 VSS 0.03536f
C1898 VSS.t884 VSS 0.03536f
C1899 VSS.t874 VSS 0.01571f
C1900 VSS.t869 VSS 0.18356f
C1901 VSS.t859 VSS 0.09599f
C1902 VSS.t849 VSS 0.29837p
C1903 VSS.t839 VSS 0.0696f
C1904 VSS.t833 VSS 0.05691f
C1905 VSS.t834 VSS 0.26304f
C1906 VSS.t829 VSS 0.03142f
C1907 VSS.t811 VSS 0.0658f
C1908 VSS.t809 VSS 0.0658f
C1909 VSS.t789 VSS 0.06676f
C1910 VSS.t783 VSS 0.17453f
C1911 VSS.t784 VSS 0.33818f
C1912 VSS.t1169 VSS 0.0931f
C1913 VSS.t1174 VSS 0.25677f
C1914 VSS.t1176 VSS 0.86786f
C1915 VSS.t1179 VSS 0.14413f
C1916 VSS.t1190 VSS 0.16521f
C1917 VSS.t1193 VSS 0.18317f
C1918 VSS.t1192 VSS 0.22896f
C1919 VSS.t1196 VSS 0.0786f
C1920 VSS.t1195 VSS 0.04651f
C1921 VSS.t1197 VSS 0.0321f
C1922 VSS.t1353 VSS 0.04266f
C1923 VSS.t1535 VSS 0.02111f
C1924 VSS.t1530 VSS 0.79833f
C1925 VSS.t1510 VSS 0.08773f
C1926 VSS.t1500 VSS 0.20053f
C1927 VSS.t1490 VSS 0.28211f
C1928 VSS.t1485 VSS 0.08716f
C1929 VSS.t1480 VSS 0.02567f
C1930 VSS.t1475 VSS 0.08206f
C1931 VSS.t1470 VSS 0.28211f
C1932 VSS.t1465 VSS 0.26268f
C1933 VSS.t1460 VSS 0.63743f
C1934 VSS.t1550 VSS 0.11959f
C1935 VSS.t1560 VSS 0.05202f
C1936 VSS.t1564 VSS 0.19097f
C1937 VSS.t1565 VSS 0.86215f
C1938 VSS.t1570 VSS 0.02994f
C1939 VSS.t1580 VSS 0.03848f
C1940 VSS.t1585 VSS 0.11899f
C1941 VSS.t1590 VSS 0.02601f
C1942 VSS.t1600 VSS 0.50745f
C1943 VSS.t1604 VSS 0.11942f
C1944 VSS.t1605 VSS 0.11942f
C1945 VSS.t1620 VSS 0.01971f
C1946 VSS.t1625 VSS 0.1554f
C1947 VSS.t1627 VSS 0.02568f
C1948 VSS.t1635 VSS 0.27388f
C1949 VSS.t1645 VSS 0.05899f
C1950 VSS.t1655 VSS 0.11685f
C1951 VSS.t1660 VSS 0.07033f
C1952 VSS.t1664 VSS 0.08182f
C1953 VSS.t1665 VSS 0.22455f
C1954 VSS.t1670 VSS 0.19277f
C1955 VSS.t1675 VSS 0.21696f
C1956 VSS.t1680 VSS 0.25691f
C1957 VSS.t2077 VSS 0.08526f
C1958 VSS.t2067 VSS 0.08623f
C1959 VSS.t2027 VSS 0.43393f
C1960 VSS.t2011 VSS 0.02101f
C1961 VSS.t2012 VSS 0.02101f
C1962 VSS.t2006 VSS 0.03687f
C1963 VSS.t2007 VSS 0.03687f
C1964 VSS.t1997 VSS 0.12093f
C1965 VSS.t1987 VSS 0.12504f
C1966 VSS.t1982 VSS 0.01771f
C1967 VSS.t1972 VSS 0.03942f
C1968 VSS.t1966 VSS 0.02222f
C1969 VSS.t1967 VSS 0.02222f
C1970 VSS.t1957 VSS 0.07838f
C1971 VSS.t1947 VSS 0.04195f
C1972 VSS.t1942 VSS 0.0888f
C1973 VSS.t1919 VSS 0.1061f
C1974 VSS.t1921 VSS 0.04799f
C1975 VSS.t1922 VSS 0.04799f
C1976 VSS.t1914 VSS 0.06261f
C1977 VSS.t1917 VSS 0.1061f
C1978 VSS.t1909 VSS 0.14098f
C1979 VSS.t1912 VSS 0.06261f
C1980 VSS.t1907 VSS 0.14098f
C1981 VSS.t1899 VSS 1.52005f
C1982 VSS.t1897 VSS 1.52005f
C1983 VSS.t1881 VSS 0.03386f
C1984 VSS.t1882 VSS 0.03386f
C1985 VSS.t1876 VSS 0.0317f
C1986 VSS.t1877 VSS 0.0317f
C1987 VSS.t1866 VSS 0.17341f
C1988 VSS.t1867 VSS 0.17341f
C1989 VSS.t1862 VSS 0.10324f
C1990 VSS.t1857 VSS 0.32028f
C1991 VSS.t1837 VSS 0.04202f
C1992 VSS.t1926 VSS 0.13296f
C1993 VSS.t1927 VSS 0.13296f
C1994 VSS.t2002 VSS 0.59675p
C1995 VSS.t2071 VSS 0.04311f
C1996 VSS.t2072 VSS 0.04311f
C1997 VSS.t2082 VSS 0.28197f
C1998 VSS.t2096 VSS 0.02669f
C1999 VSS.t2097 VSS 0.02669f
C2000 VSS.t2112 VSS 0.02111f
C2001 VSS.t2114 VSS 0.02111f
C2002 VSS.t1685 VSS 0.26241f
C2003 VSS.t1690 VSS 0.07668f
C2004 VSS.t1700 VSS 0.08438f
C2005 VSS.t1705 VSS 0.19179f
C2006 VSS.t1710 VSS 0.01802f
C2007 VSS.t1715 VSS 0.05162f
C2008 VSS.t1720 VSS 0.02975f
C2009 VSS.t1719 VSS 0.02975f
C2010 VSS.t1712 VSS 0.01802f
C2011 VSS.t341 VSS 0.05949f
C2012 VSS.t155 VSS 0.15287f
C2013 VSS.t227 VSS 0.04333f
C2014 VSS.t366 VSS 0.11596f
C2015 VSS.t346 VSS 0.02098f
C2016 VSS.t236 VSS 0.53349f
C2017 VSS.t323 VSS 0.08338f
C2018 VSS.t83 VSS 0.62967f
C2019 VSS.t3226 VSS 0.03386f
C2020 VSS.t123 VSS 0.04148f
C2021 VSS.t397 VSS 0.04148f
C2022 VSS.t201 VSS 0.07668f
C2023 VSS.t89 VSS 0.21698f
C2024 VSS.t172 VSS 0.33974f
C2025 VSS.t142 VSS 0.08634f
C2026 VSS.t52 VSS 0.44774f
C2027 VSS.t13 VSS 0.83323f
C2028 VSS.t5 VSS 0.12232f
C2029 VSS.t42 VSS 0.66694f
C2030 VSS.t103 VSS 0.18968f
C2031 VSS.t65 VSS 1.46641f
C2032 VSS.t3221 VSS 0.4583f
C2033 VSS.t405 VSS 0.04604f
C2034 VSS.t404 VSS 0.04604f
C2035 VSS.t417 VSS 0.20178f
C2036 VSS.t420 VSS 0.08245f
C2037 VSS.t419 VSS 0.08245f
C2038 VSS.t423 VSS 0.35176f
C2039 VSS.t432 VSS 0.14106f
C2040 VSS.t431 VSS 0.14106f
C2041 VSS.t435 VSS 0.05338f
C2042 VSS.t1256 VSS 0.01553f
C2043 VSS.t1268 VSS 0.06847f
C2044 VSS.t1265 VSS 0.05009f
C2045 VSS.t1270 VSS 0.04169f
C2046 VSS.t1406 VSS 0.04951f
C2047 VSS.t1271 VSS 0.04169f
C2048 VSS.t1274 VSS 0.04951f
C2049 VSS.t1277 VSS 0.08443f
C2050 VSS.t1289 VSS 0.0159f
C2051 VSS.t1431 VSS 0.13887f
C2052 VSS.t1301 VSS 0.11248f
C2053 VSS.t1300 VSS 0.02581f
C2054 VSS.t1311 VSS 0.03044f
C2055 VSS.t1310 VSS 0.03044f
C2056 VSS.t1313 VSS 0.10974f
C2057 VSS.t1312 VSS 0.10974f
C2058 VSS.t1315 VSS 0.16935f
C2059 VSS.t1316 VSS 0.1862f
C2060 VSS.t1299 VSS 0.08667f
C2061 VSS.t1298 VSS 0.2062f
C2062 VSS.t1243 VSS 0.04215f
C2063 VSS.t1239 VSS 0.11349f
C2064 VSS.t1238 VSS 0.11349f
C2065 VSS.t1225 VSS 0.09962f
C2066 VSS.t1213 VSS 0.11638f
C2067 VSS.t1602 VSS 0.35904f
C2068 VSS.t1592 VSS 0.02601f
C2069 VSS.t1160 VSS 1.06497f
C2070 VSS.t779 VSS 0.11609f
C2071 VSS.t854 VSS 0.25061f
C2072 VSS.t996 VSS 0.09974f
C2073 VSS.t999 VSS 0.09639f
C2074 VSS.t1009 VSS 0.04005f
C2075 VSS.t1013 VSS 0.04501f
C2076 VSS.t1014 VSS 0.04501f
C2077 VSS.t1024 VSS 0.23946f
C2078 VSS.t1034 VSS 0.2162f
C2079 VSS.t1039 VSS 0.18093f
C2080 VSS.t620 VSS 0.20188f
C2081 VSS.t623 VSS 0.23599f
C2082 VSS.t626 VSS 0.0238f
C2083 VSS.t629 VSS 0.0238f
C2084 VSS.t2409 VSS 0.06771f
C2085 VSS.t2414 VSS 0.12276f
C2086 VSS.t2419 VSS 0.07206f
C2087 VSS.t2423 VSS 0.03205f
C2088 VSS.t2424 VSS 0.03205f
C2089 VSS.t2429 VSS 0.06925f
C2090 VSS.t2434 VSS 0.05073f
C2091 VSS.t2436 VSS 0.05073f
C2092 VSS.t2444 VSS 0.1936f
C2093 VSS.t2453 VSS 0.53249f
C2094 VSS.t2454 VSS 0.56711f
C2095 VSS.t2459 VSS 0.06283f
C2096 VSS.t2464 VSS 0.19927f
C2097 VSS.t2473 VSS 0.10848f
C2098 VSS.t2474 VSS 0.10848f
C2099 VSS.t2483 VSS 0.07787f
C2100 VSS.t2484 VSS 0.07787f
C2101 VSS.t2489 VSS 0.27378f
C2102 VSS.t2499 VSS 0.05959f
C2103 VSS.t2498 VSS 0.04219f
C2104 VSS.t2504 VSS 0.04172f
C2105 VSS.t2501 VSS 0.0174f
C2106 VSS.t2471 VSS 0.05336f
C2107 VSS.t2469 VSS 0.05336f
C2108 VSS.t3047 VSS 0.17977f
C2109 VSS.t3024 VSS 0.03865f
C2110 VSS.t3019 VSS 0.03516f
C2111 VSS.t3022 VSS 0.03865f
C2112 VSS.t3017 VSS 0.03516f
C2113 VSS.t3002 VSS 0.15458f
C2114 VSS.t2997 VSS 0.06341f
C2115 VSS.t2991 VSS 0.03026f
C2116 VSS.t2992 VSS 0.04523f
C2117 VSS.t2981 VSS 0.14918p
C2118 VSS.t2982 VSS 0.14918p
C2119 VSS.t3142 VSS 0.14412f
C2120 VSS.t2732 VSS 0.43125f
.ends
