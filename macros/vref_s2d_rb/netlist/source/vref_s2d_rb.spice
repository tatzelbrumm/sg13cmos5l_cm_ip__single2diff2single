* SPDX-FileCopyrightText: 2026 Christoph Maier
* SPDX-License-Identifier: Apache-2.0
* vref_s2d_rb: replica bias for the pad reference vref of sg13cmos5l_IOPadSingle2Diff (user's choice 1a: about 0.5 V, so
* that the pad range 0 ... 1 V includes iovss). Task docs/launch/replica_bias_TASK.md (branch harness-test); evidence
* docs/replica_bias/SURVEY.md and the G4 runs (macros/vcm_rb/testbenches/pad_char/results/g4_s2d_vref.tsv).
*
* The S2D input stays linear (INL <= 2 mV, u = +-0.5 V) for vref above an edge set by the input follower (hv PMOS 20u/1u)
* leaving saturation against the fold node x: edge = x - V_SG(follower, 5 uA) + 0.676 V (+-4 mV over corners and iovdd at
* 125 C). It is below 0.4 V up to 27 C and 0.46 ... 0.54 V at 125 C (fast PMOS highest).
* vref = vbnc - V_GS(F): an x-node replica at a lower current density (F = 4 fingers of the fold cascode, 15u/3u, at
* 1.67 uA, against the S2D's 30u/3u at 10 uA), so it rises with temperature like x and sits about 0.1 V above it:
* about 0.49 V at 27 C (pad range from 0 V), 0.44 V at -40 C, and >= 30 mV above the INL edge at 125 C
* (explore_vref.py). Output impedance about 1/gm(F) = 20 kOhm. No capacitor in this cell (Christoph 2026-11-07: the
* bypass in a cell of its own unless needed for stability; a follower has no loop, explore_stability.py): the bypass
* that holds vref during the pad's own transients (G6) is bypass_rb in pad_ref_rb, 8 x 12u x 12u hv NMOS to vss.
* Since 2026-11-07 the lines come from the shared cell bias_tree_rb (macros/pad_ref_rb), which also feeds vcm_rb; before,
* this block had its own copy (reference NI, BP, BNC). Supply current (tt 27 C): 1.67 uA (the follower).
* Ports: vdd vss ni vbnc vref en_3v3_b. ni / vbnc: bias_tree_rb's lines (ni = its 6u/6u NMOS reference diode, vbnc =
* its 1u/8u NMOS diode at 2 uA); en_3v3_b: complement of the enable.
* Disabled (en_3v3 = 0): the tree cuts the reference and pulls ni to vss (SF off), vbnc decays to vss (F off); SPD pulls
* vref to vss (the s2d pad's vref drives gates only). vref has no enable of its own: it is on whenever pad_ref_rb is
* (pulling vref low with the tree on would short the follower F from vbnc).
.subckt vref_s2d_rb vdd vss ni vbnc vref en_3v3_b
* --- the reference: x-node replica at low density
XF1 vdd vbnc vref vss sg13_hv_nmos w=15u l=3u ng=1 mm_ok=1
XF2 vdd vbnc vref vss sg13_hv_nmos w=15u l=3u ng=1 mm_ok=1
XF3 vdd vbnc vref vss sg13_hv_nmos w=15u l=3u ng=1 mm_ok=1
XF4 vdd vbnc vref vss sg13_hv_nmos w=15u l=3u ng=1 mm_ok=1
XSF vref ni vss vss sg13_hv_nmos w=2u l=6u ng=1 mm_ok=1
* --- disable
XSPD vref en_3v3_b vss vss sg13_hv_nmos w=1u l=0.45u ng=1 mm_ok=1
.ends vref_s2d_rb
