* SPDX-FileCopyrightText: 2026 Christoph Maier
* SPDX-License-Identifier: Apache-2.0
* bias_sel_pd: the bias of the pad driver, with a selectable reference current into ONE
* mirror tree (bias_tree_pd of bias_ref_pd.spice). vabp / vabn are current outputs into the class-AB diode
* stacks in the pad (since 2026-10-27; RP2 / RN2 in d2s_mpdda_pd, RP1 / RN1 in d2s_out_p / d2s_out_n), so no vddo / vsso.
*   sel1 sel0 = 0 0: harness ibias (a sourced current, ~5 uA = iDAC code 20 at 250 nA/step),
*                    through a transmission gate (TEN / TEP)
*               0 1: Oguey-Aebischer core (oa_core_pd)
*               1 0: bandgap core (bg_core_pd)
*               1 1: both cores (currents add)
* en_3v3 = 0: everything off as in bias_*_pd (the tree's own TG and TDN, both cores off, TG open).
* en_3v3_b = NOT en_3v3 comes in as a port (XIB in en_ctrl_3v3); the local inverter Xi is gone.
* A disabled core's output (POC drain) is off, so the cores share the tree input ir without a switch.
.subckt bias_sel_pd vdd vss ibias vbp vbn vbpc vbnc vabp vabn en_3v3 sel0_3v3 sel1_3v3 en_3v3_b
Xt vdd vss ir vbp vbn vbpc vbnc vabp vabn en_3v3 en_3v3_b bias_tree_pd
* decode
XDA vdd vss en_3v3 sel0_3v3 en_oa_b nand2_hv
XDB vdd vss en_oa_b en_oa inv_hv
XDC vdd vss en_3v3 sel1_3v3 en_bg_b nand2_hv
XDD vdd vss en_bg_b en_bg inv_hv
XDE vdd vss sel0_3v3 sel1_3v3 s00 nor2_hv
XDF vdd vss en_3v3 s00 en_ext_b nand2_hv
XDG vdd vss en_ext_b en_ext inv_hv
* reference sources into ir
Xoa vdd vss ir en_oa en_oa_b oa_core_pd
Xbg vdd vss ir en_bg en_bg_b bg_core_pd
XTEN ibias en_ext ir vss sg13_hv_nmos w=1u l=0.45u ng=1
XTEP ibias en_ext_b ir vdd sg13_hv_pmos w=1u l=0.45u ng=1
.ends bias_sel_pd
