* generated by scripts/cace/pex_for_sim.py from ../bg_core_pd/netlist/pex/bg_core_pd_magic_pex_3.spice: 41 capacitor-only nodes tied to vss through 1e12 Ohm
* PEX produced on Fri Oct 30 22:41:11 UTC 2026 using /usr/local/bin/sak-pex.sh with m=3 and s=1 (extresist threshold=10000 mOhm, minres=1000 mOhm, mindelay=1 ps)
* NGSPICE file created from bg_core_pd_pex.ext - technology: ihp-sg13cmos5l

.subckt bg_core_pd_pex vdd vss iout en_3v3 en_3v3_b
X0 a_4703_6072# bg_n4_0.ea vss.t46 rhigh l=9.94u w=0.5u
X1 a_4431_6072# bg_n4_0.eb vss.t44 rhigh l=9.94u w=0.5u
X2 a_623_6072# a_1167_3998# vss.t10 rhigh l=9.94u w=0.5u
X3 a_918_8440.t5 bg_pmir_pcas_c_0.vpg vdd vdd sg13_hv_pmos ad=3.4p pd=20.68u as=3.4p ps=20.68u w=10u l=1u
X4 bg_n4_0.g bg_n4_0.g bg_n4_0.g vss.t25 sg13_hv_nmos ad=0.68p pd=4.68u as=73.8615p ps=0.3643m w=2u l=4u
X5 vdd bg_pmir_pcas_c_0.vpg vdd vdd sg13_hv_pmos ad=0.102p pd=1.28u as=0.15688n ps=0.4126m w=0.3u l=1u
X6 a_918_6928.t1 bg_n4_0.vpc iout vdd sg13_hv_pmos ad=3.4p pd=20.68u as=3.4p ps=20.68u w=10u l=1u
X7 a_2799_6072# a_2391_3998# vss.t20 rhigh l=9.94u w=0.5u
X8 vdd bg_pmir_pcas_c_0.vpg bg_pmir_pcas_c_0.vpg vdd sg13_hv_pmos ad=3.4p pd=20.68u as=3.4p ps=20.68u w=10u l=1u
X9 a_1847_6072# a_2391_3998# vss.t4 rhigh l=9.94u w=0.5u
X10 vdd bg_pmir_pcas_c_0.vpg a_918_6928.t8 vdd sg13_hv_pmos ad=3.4p pd=20.68u as=3.4p ps=20.68u w=10u l=1u
X11 bg_n4_0.vpc bg_n4_0.vpc bg_pmir_pcas_c_0.vpg vdd sg13_hv_pmos ad=3.4p pd=20.68u as=3.4p ps=20.68u w=10u l=1u
X12 a_4703_6072# a_4159_3998# vss.t42 rhigh l=9.94u w=0.5u
X13 vdd bg_n4_0.vpc vdd vdd sg13_hv_pmos ad=0.102p pd=1.28u as=0 ps=0 w=0.3u l=1u
X14 a_3887_6072# a_4295_3998# vss.t40 rhigh l=9.94u w=0.5u
X15 vdd bg_n4_0.vpc vdd vdd sg13_hv_pmos ad=0.102p pd=1.28u as=0 ps=0 w=0.3u l=1u
X16 vss.t28 en_3v3_b bg_n4_0.ks vss.t27 sg13_hv_nmos ad=0.34p pd=2.68u as=0.34p ps=2.68u w=1u l=0.45u
X17 vss.t24 bg_n4_0.ks bg_n4_0.vpc vss.t41 sg13_hv_nmos ad=0.17p pd=1.68u as=0.17p ps=1.68u w=0.5u l=2u
X18 a_2527_6072# a_2255_3998# vss.t2 rhigh l=9.94u w=0.5u
X19 a_215_6072# a_487_3998# vss.t6 rhigh l=9.94u w=0.5u
X20 vdd en_3v3 bg_pmir_pcas_c_0.vpg vdd sg13_hv_pmos ad=0.34p pd=2.68u as=0.34p ps=2.68u w=1u l=0.45u
X21 vss.t36 vss.t66 bg_n4_0.ea pnpMPA a=4p p=8u
**devattr d=25908452,36976
X22 vdd bg_n4_0.vpc vdd vdd sg13_hv_pmos ad=0.102p pd=1.28u as=0 ps=0 w=0.3u l=1u
X23 vdd bg_n4_0.vpc vdd vdd sg13_hv_pmos ad=0.102p pd=1.28u as=0 ps=0 w=0.3u l=1u
X24 bg_n4_0.g bg_n4_0.g bg_n4_0.g vss.t25 sg13_hv_nmos ad=0.68p pd=4.68u as=0 ps=0 w=2u l=4u
X25 a_8390_5412# en_3v3_b a_5822_5262# vdd sg13_hv_pmos ad=0.17p pd=1.68u as=0.17p ps=1.68u w=0.5u l=12.5u
X26 a_3479_6072# a_4023_3998# vss.t22 rhigh l=9.94u w=0.5u
X27 a_3751_6072# a_3207_3998# vss.t35 rhigh l=9.94u w=0.5u
X28 vdd bg_pmir_pcas_c_0.vpg a_918_6928.t12 vdd sg13_hv_pmos ad=3.4p pd=20.68u as=3.4p ps=20.68u w=10u l=1u
X29 a_215_6072# bg_pnp_c_0.e2 vss.t29 rhigh l=9.94u w=0.5u
X30 bg_pmir_pcas_c_0.vpg bg_pmir_pcas_c_0.vpg vdd vdd sg13_hv_pmos ad=3.4p pd=20.68u as=3.4p ps=20.68u w=10u l=1u
X31 a_8390_5712# en_3v3_b a_5822_5562# vdd sg13_hv_pmos ad=0.17p pd=1.68u as=0.17p ps=1.68u w=0.5u l=12.5u
X32 a_1575_6072# a_1167_3998# vss.t34 rhigh l=9.94u w=0.5u
X33 a_918_8440.t2 bg_n4_0.vpc bg_n4_0.g vdd sg13_hv_pmos ad=3.4p pd=20.68u as=3.4p ps=20.68u w=10u l=1u
X34 bg_n4_0.ks en_3v3_b a_5822_5262# vdd sg13_hv_pmos ad=0.17p pd=1.68u as=0.17p ps=1.68u w=0.5u l=12.5u
X35 vdd bg_pmir_pcas_c_0.vpg bg_pmir_pcas_c_0.vpg vdd sg13_hv_pmos ad=3.4p pd=20.68u as=3.4p ps=20.68u w=10u l=1u
X36 bg_n4_0.g bg_n4_0.g bg_n4_0.ea vss.t23 sg13_hv_nmos ad=3.4p pd=20.68u as=3.4p ps=20.68u w=10u l=4u
X37 vss.t36 vss.t58 bg_pnp_c_0.e2 pnpMPA a=4p p=8u
**devattr d=25908452,36976
X38 a_3479_6072# a_2935_3998# vss.t14 rhigh l=9.94u w=0.5u
X39 a_2527_6072# a_3071_3998# vss.t21 rhigh l=9.94u w=0.5u
X40 iout bg_n4_0.vpc a_918_6928.t7 vdd sg13_hv_pmos ad=3.4p pd=20.68u as=3.4p ps=20.68u w=10u l=1u
X41 bg_pmir_pcas_c_0.vpg bg_n4_0.vpc bg_n4_0.vpc vdd sg13_hv_pmos ad=3.4p pd=20.68u as=3.4p ps=20.68u w=10u l=1u
X42 bg_n4_0.g bg_n4_0.g bg_n4_0.g vss.t26 sg13_hv_nmos ad=0.68p pd=4.68u as=0 ps=0 w=2u l=4u
X43 vdd bg_n4_0.vpc vdd vdd sg13_hv_pmos ad=0.102p pd=1.28u as=0 ps=0 w=0.3u l=1u
X44 a_8390_5412# en_3v3_b a_5822_5562# vdd sg13_hv_pmos ad=0.17p pd=1.68u as=0.17p ps=1.68u w=0.5u l=12.5u
X45 a_1303_6072# a_1031_3998# vss.t17 rhigh l=9.94u w=0.5u
X46 a_918_6928.t0 bg_n4_0.vpc iout vdd sg13_hv_pmos ad=3.4p pd=20.68u as=3.4p ps=20.68u w=10u l=1u
X47 iout bg_n4_0.vpc a_918_6928.t2 vdd sg13_hv_pmos ad=3.4p pd=20.68u as=3.4p ps=20.68u w=10u l=1u
X48 a_8390_6012# en_3v3_b a_5822_5862# vdd sg13_hv_pmos ad=0.17p pd=1.68u as=0.17p ps=1.68u w=0.5u l=12.5u
X49 a_918_6928.t11 bg_pmir_pcas_c_0.vpg vdd vdd sg13_hv_pmos ad=3.4p pd=20.68u as=3.4p ps=20.68u w=10u l=1u
X50 a_2799_6072# a_3207_3998# vss.t8 rhigh l=9.94u w=0.5u
X51 a_2663_6072# a_2935_3998# vss.t5 rhigh l=9.94u w=0.5u
X52 a_895_6072# a_351_3998# vss.t0 rhigh l=9.94u w=0.5u
X53 vdd bg_n4_0.vpc vdd vdd sg13_hv_pmos ad=0.102p pd=1.28u as=0 ps=0 w=0.3u l=1u
X54 a_8390_5712# en_3v3_b a_5822_5862# vdd sg13_hv_pmos ad=0.17p pd=1.68u as=0.17p ps=1.68u w=0.5u l=12.5u
X55 bg_n4_0.g bg_n4_0.vpc a_918_8440.t1 vdd sg13_hv_pmos ad=3.4p pd=20.68u as=3.4p ps=20.68u w=10u l=1u
X56 bg_n4_0.g bg_n4_0.g bg_n4_0.g vss.t26 sg13_hv_nmos ad=0.68p pd=4.68u as=0 ps=0 w=2u l=4u
X57 vdd bg_pmir_pcas_c_0.vpg vdd vdd sg13_hv_pmos ad=0.102p pd=1.28u as=0 ps=0 w=0.3u l=1u
X58 a_4567_6072# a_4839_3998# vss.t45 rhigh l=9.94u w=0.5u
X59 a_4431_6072# a_4023_3998# vss.t39 rhigh l=9.94u w=0.5u
X60 vdd en_3v3_b a_5822_6162# vdd sg13_hv_pmos ad=0.17p pd=1.68u as=0.17p ps=1.68u w=0.5u l=12.5u
X61 vdd bg_pmir_pcas_c_0.vpg a_918_8440.t4 vdd sg13_hv_pmos ad=3.4p pd=20.68u as=3.4p ps=20.68u w=10u l=1u
X62 a_623_6072# vss.t31 vss.t32 rhigh l=9.94u w=0.5u
X63 a_1983_6072# a_2255_3998# vss.t13 rhigh l=9.94u w=0.5u
X64 vss.t36 vss.t56 bg_pnp_c_0.e2 pnpMPA a=4p p=8u
**devattr d=25908452,36976
X65 bg_n4_0.g bg_n4_0.g bg_n4_0.g vss.t26 sg13_hv_nmos ad=0.68p pd=4.68u as=0 ps=0 w=2u l=4u
X66 vss.t24 bg_n4_0.g bg_n4_0.ks vss.t23 sg13_hv_nmos ad=3.4p pd=20.68u as=3.4p ps=20.68u w=10u l=1u
X67 a_1983_6072# a_1711_3998# vss.t1 rhigh l=9.94u w=0.5u
X68 bg_n4_0.g bg_n4_0.g bg_n4_0.g vss.t25 sg13_hv_nmos ad=0.68p pd=4.68u as=0 ps=0 w=2u l=4u
X69 a_918_6928.t4 bg_n4_0.vpc iout vdd sg13_hv_pmos ad=3.4p pd=20.68u as=3.4p ps=20.68u w=10u l=1u
X70 a_3751_6072# a_4159_3998# vss.t36 rhigh l=9.94u w=0.5u
X71 a_3887_6072# a_3615_3998# vss.t16 rhigh l=9.94u w=0.5u
X72 a_8390_6012# en_3v3_b a_5822_6162# vdd sg13_hv_pmos ad=0.17p pd=1.68u as=0.17p ps=1.68u w=0.5u l=12.5u
X73 vss.t36 vss.t52 bg_pnp_c_0.e2 pnpMPA a=4p p=8u
**devattr d=25908452,36976
X74 a_918_6928.t14 bg_pmir_pcas_c_0.vpg vdd vdd sg13_hv_pmos ad=3.4p pd=20.68u as=3.4p ps=20.68u w=10u l=1u
X75 vdd bg_pmir_pcas_c_0.vpg vdd vdd sg13_hv_pmos ad=0.102p pd=1.28u as=0 ps=0 w=0.3u l=1u
X76 vss.t31 vss.t19 vss.t30 rhigh l=9.94u w=0.5u
X77 bg_pmir_pcas_c_0.vpg bg_n4_0.vpc bg_n4_0.vpc vdd sg13_hv_pmos ad=3.4p pd=20.68u as=3.4p ps=20.68u w=10u l=1u
X78 bg_n4_0.g bg_n4_0.g bg_n4_0.g vss.t26 sg13_hv_nmos ad=0.68p pd=4.68u as=0 ps=0 w=2u l=4u
X79 bg_n4_0.g bg_n4_0.vpc a_918_8440.t3 vdd sg13_hv_pmos ad=3.4p pd=20.68u as=3.4p ps=20.68u w=10u l=1u
X80 a_5111_6072# bg_n4_0.eb vss.t43 rhigh l=9.94u w=0.5u
X81 a_1303_6072# a_1711_3998# vss.t33 rhigh l=9.94u w=0.5u
X82 bg_n4_0.ea bg_n4_0.g bg_n4_0.g vss.t23 sg13_hv_nmos ad=3.4p pd=20.68u as=3.4p ps=20.68u w=10u l=4u
X83 a_3343_6072# a_3615_3998# vss.t15 rhigh l=9.94u w=0.5u
X84 iout bg_n4_0.vpc a_918_6928.t6 vdd sg13_hv_pmos ad=3.4p pd=20.68u as=3.4p ps=20.68u w=10u l=1u
X85 vdd bg_pmir_pcas_c_0.vpg a_918_6928.t13 vdd sg13_hv_pmos ad=3.4p pd=20.68u as=3.4p ps=20.68u w=10u l=1u
X86 vdd bg_pmir_pcas_c_0.vpg vdd vdd sg13_hv_pmos ad=0.102p pd=1.28u as=0 ps=0 w=0.3u l=1u
X87 vdd bg_pmir_pcas_c_0.vpg vdd vdd sg13_hv_pmos ad=0.102p pd=1.28u as=0 ps=0 w=0.3u l=1u
X88 vss.t48 vss.t49 vss.t47 rhigh l=9.94u w=0.5u
X89 a_895_6072# a_1439_3998# vss.t11 rhigh l=9.94u w=0.5u
X90 vss.t36 vss.t54 bg_pnp_c_0.e2 pnpMPA a=4p p=8u
**devattr d=25908452,36976
X91 a_5111_6072# a_4839_3998# vss.t38 rhigh l=9.94u w=0.5u
X92 vss.t36 vss.t64 bg_pnp_c_0.e2 pnpMPA a=4p p=8u
**devattr d=25908452,36976
X93 a_759_6072# a_1031_3998# vss.t7 rhigh l=9.94u w=0.5u
X94 bg_n4_0.eb bg_n4_0.g bg_n4_0.vpc vss.t23 sg13_hv_nmos ad=3.4p pd=20.68u as=3.4p ps=20.68u w=10u l=4u
X95 bg_pmir_pcas_c_0.vpg bg_pmir_pcas_c_0.vpg vdd vdd sg13_hv_pmos ad=3.4p pd=20.68u as=3.4p ps=20.68u w=10u l=1u
X96 a_918_8440.t0 bg_n4_0.vpc bg_n4_0.g vdd sg13_hv_pmos ad=3.4p pd=20.68u as=3.4p ps=20.68u w=10u l=1u
X97 a_2663_6072# a_2119_3998# vss.t68 rhigh l=9.94u w=0.5u
X98 vss.t36 vss.t60 bg_pnp_c_0.e2 pnpMPA a=4p p=8u
**devattr d=25908452,36976
X99 a_4567_6072# a_4295_3998# vss.t37 rhigh l=9.94u w=0.5u
X100 vdd bg_pmir_pcas_c_0.vpg vdd vdd sg13_hv_pmos ad=0.102p pd=1.28u as=0 ps=0 w=0.3u l=1u
X101 iout bg_n4_0.vpc a_918_6928.t3 vdd sg13_hv_pmos ad=3.4p pd=20.68u as=3.4p ps=20.68u w=10u l=1u
X102 vdd bg_pmir_pcas_c_0.vpg a_918_6928.t9 vdd sg13_hv_pmos ad=3.4p pd=20.68u as=3.4p ps=20.68u w=10u l=1u
X103 a_759_6072# a_487_3998# vss.t9 rhigh l=9.94u w=0.5u
X104 vdd bg_pmir_pcas_c_0.vpg vdd vdd sg13_hv_pmos ad=0.102p pd=1.28u as=0 ps=0 w=0.3u l=1u
X105 vss.t19 a_351_3998# vss.t18 rhigh l=9.94u w=0.5u
X106 bg_n4_0.g bg_n4_0.g bg_n4_0.g vss.t25 sg13_hv_nmos ad=0.68p pd=4.68u as=0 ps=0 w=2u l=1u
X107 a_918_8440.t7 bg_pmir_pcas_c_0.vpg vdd vdd sg13_hv_pmos ad=3.4p pd=20.68u as=3.4p ps=20.68u w=10u l=1u
X108 bg_n4_0.vpc bg_n4_0.g bg_n4_0.eb vss.t23 sg13_hv_nmos ad=3.4p pd=20.68u as=3.4p ps=20.68u w=10u l=4u
X109 vdd bg_pmir_pcas_c_0.vpg vdd vdd sg13_hv_pmos ad=0.102p pd=1.28u as=0 ps=0 w=0.3u l=1u
X110 a_918_6928.t6 bg_pmir_pcas_c_0.vpg vdd vdd sg13_hv_pmos ad=3.4p pd=20.68u as=3.4p ps=20.68u w=10u l=1u
X111 vss.t36 vss.t50 bg_pnp_c_0.e2 pnpMPA a=4p p=8u
**devattr d=25908452,36976
X112 vss.t36 vss.t62 bg_pnp_c_0.e2 pnpMPA a=4p p=8u
**devattr d=25908452,36976
X113 vdd bg_n4_0.vpc vdd vdd sg13_hv_pmos ad=0.102p pd=1.28u as=0 ps=0 w=0.3u l=1u
X114 a_1575_6072# a_2119_3998# vss.t3 rhigh l=9.94u w=0.5u
X115 a_1847_6072# a_1439_3998# vss.t12 rhigh l=9.94u w=0.5u
X116 bg_n4_0.g bg_n4_0.g bg_n4_0.g vss.t25 sg13_hv_nmos ad=0.68p pd=4.68u as=0 ps=0 w=2u l=4u
X117 a_918_6928.t5 bg_n4_0.vpc iout vdd sg13_hv_pmos ad=3.4p pd=20.68u as=3.4p ps=20.68u w=10u l=1u
X118 vdd bg_n4_0.vpc vdd vdd sg13_hv_pmos ad=0.102p pd=1.28u as=0 ps=0 w=0.3u l=1u
X119 vdd bg_pmir_pcas_c_0.vpg a_918_8440.t6 vdd sg13_hv_pmos ad=3.4p pd=20.68u as=3.4p ps=20.68u w=10u l=1u
X120 a_3343_6072# a_3071_3998# vss.t69 rhigh l=9.94u w=0.5u
X121 a_918_6928.t10 bg_pmir_pcas_c_0.vpg vdd vdd sg13_hv_pmos ad=3.4p pd=20.68u as=3.4p ps=20.68u w=10u l=1u
X122 bg_n4_0.vpc bg_n4_0.vpc bg_pmir_pcas_c_0.vpg vdd sg13_hv_pmos ad=3.4p pd=20.68u as=3.4p ps=20.68u w=10u l=1u
R0 vss.n22 vss.t27 196.585
R1 vss.t27 vss.t47 156.72
R2 vss vss.n0 0.919726
R3 vss.t18 vss.n12 24.9276
R4 vss vss.t11 16.5884
R5 vss.n11 vss.t33 26.882
R6 vss.n10 vss.t29 65.03
R7 vss.n43 vss.t18 64.0156
R8 vss.n9 vss.t32 18.7124
R9 vss.n18 vss.t0 63.0384
R10 vss.n17 vss.t7 63.0384
R11 vss.n16 vss.t10 63.0384
R12 vss.n15 vss.t17 63.0384
R13 vss.n14 vss.t11 63.0384
R14 vss.t37 vss.t39 62.424
R15 vss.t42 vss.t37 62.424
R16 vss.t45 vss.t42 62.424
R17 vss.t44 vss.t45 62.424
R18 vss.t38 vss.t44 62.424
R19 vss.t46 vss.t38 62.424
R20 vss.t43 vss.t46 62.424
R21 vss.t47 vss.t43 62.424
R22 vss.n13 vss.t33 62.0612
R23 vss.n50 vss.t1 62.0612
R24 vss.n8 vss.t3 18.1928
R25 vss.n7 vss.t4 61.9582
R26 vss.t2 vss.n44 61.084
R27 vss.t68 vss.n45 61.084
R28 vss.t20 vss.n0 19.5032
R29 vss.n5 vss.t21 61.1251
R30 vss.n49 vss.t8 60.1068
R31 vss.n48 vss.t69 60.1068
R32 vss.n6 vss.t69 30.667
R33 vss.t35 vss.n46 59.1296
R34 vss.t16 vss.n47 59.1296
R35 vss.n4 vss.t22 20.329
R36 vss vss.t39 53.3333
R37 vss.n12 vss.t6 64.0156
R38 vss vss.t34 64.1597
R39 vss.t12 vss.n11 62.0612
R40 vss vss.n7 1.91465
R41 vss vss.n5 1.75921
R42 vss.n4 vss 0.99028
R43 vss.n31 vss.n28 39.7047
R44 vss.t23 vss.n2 41.6281
R45 vss.n1 vss.n3 7.9631
R46 vss.t25 vss.n19 32.1712
R47 vss.n46 vss.t15 29.8136
R48 vss.n47 vss.t35 29.8136
R49 vss.n22 vss.t41 29.0109
R50 vss.t5 vss.n5 17.6199
R51 vss.t21 vss.n49 28.8364
R52 vss.t8 vss.n48 28.8364
R53 vss.t13 vss.n7 18.5278
R54 vss.t4 vss.n44 27.8592
R55 vss.n45 vss.t2 27.8592
R56 vss.n0 vss.t68 29.7305
R57 vss.t34 vss.n13 26.882
R58 vss.n50 vss.t12 26.882
R59 vss.t1 vss.n8 28.8265
R60 vss.n18 vss.t9 25.9048
R61 vss.t0 vss.n17 25.9048
R62 vss.t7 vss.n16 25.9048
R63 vss.t10 vss.n15 25.9048
R64 vss.t17 vss.n14 25.9048
R65 vss.n10 vss.t30 15.1316
R66 vss.t29 vss.n43 24.9276
R67 vss.t41 vss.n3 24.7218
R68 vss.t26 vss.n3 9.2989
R69 vss.t24 vss.t28 19.3609
R70 vss.t9 vss.t36 18.5673
R71 vss.n42 vss.n41 18.3172
R72 vss.n37 vss.n21 18.3172
R73 vss.n37 vss.n23 18.3172
R74 vss.n36 vss.n21 18.3172
R75 vss.n36 vss.n24 18.3172
R76 vss.n35 vss.n24 18.3172
R77 vss.n35 vss.n25 18.3172
R78 vss.n34 vss.n25 18.3172
R79 vss.n34 vss.n26 18.3172
R80 vss.n33 vss.n26 18.3172
R81 vss.n33 vss.n27 18.3172
R82 vss.n32 vss.n27 18.3172
R83 vss.n41 vss.n29 18.3172
R84 vss.n42 vss.n30 18.3172
R85 vss.n30 vss.n20 18.3172
R86 vss vss.n11 2.87807
R87 vss vss.n12 2.87807
R88 vss.n38 vss.n40 17.0005
R89 vss.n38 vss.n31 17.0005
R90 vss.n38 vss.n39 17.0005
R91 vss.n1 vss.n28 17.0005
R92 vss.n8 vss 0.844499
R93 vss.t15 vss.t36 14.6585
R94 vss.t49 vss.t48 12.1867
R95 vss.n40 vss.t25 10.5104
R96 vss.t19 vss.t49 9.48174
R97 vss.n32 vss.n28 9.15884
R98 vss.n38 vss.n2 1.20605
R99 vss.n40 vss.n20 9.15884
R100 vss.n31 vss.n29 9.15884
R101 vss.n39 vss.n23 9.15884
R102 vss.t48 vss.n1 8.81414
R103 vss.n1 vss.n19 8.50175
R104 vss vss.t40 6.7383
R105 vss.n38 vss.n19 8.501
R106 vss.t52 vss 0.583618
R107 vss.t56 vss 0.57391
R108 vss vss.t66 0.570938
R109 vss.t60 vss 0.597978
R110 vss.t62 vss 0.584092
R111 vss.t50 vss 0.580045
R112 vss.t64 vss 0.603824
R113 vss vss.t54 0.569479
R114 vss vss.t58 0.630536
R115 vss.n39 vss.t23 4.67158
R116 vss.n38 vss.n30 3.92208
R117 vss.n41 vss.n38 3.92208
R118 vss.n38 vss.n32 3.92208
R119 vss.n38 vss.n33 3.92208
R120 vss.n38 vss.n34 3.92208
R121 vss.n38 vss.n35 3.92208
R122 vss.n38 vss.n36 3.92208
R123 vss.n38 vss.n37 3.92208
R124 vss.n1 vss.n42 3.92208
R125 vss.n1 vss.n29 3.92208
R126 vss.n1 vss.n27 3.92208
R127 vss.n1 vss.n26 3.92208
R128 vss.n1 vss.n25 3.92208
R129 vss.n1 vss.n24 3.92208
R130 vss.n1 vss.n21 3.92208
R131 vss.n1 vss.n23 3.92208
R132 vss.n1 vss.n2 1.20555
R133 vss.n1 vss.n22 3.92208
R134 vss.n10 vss 1.74766
R135 vss vss.n50 2.87807
R136 vss vss.n13 2.87807
R137 vss vss.n14 2.87807
R138 vss vss.n15 2.87807
R139 vss vss.n16 2.87807
R140 vss vss.n44 2.87807
R141 vss vss.n17 2.87807
R142 vss vss.n18 2.87807
R143 vss vss.n9 0.842102
R144 vss.n9 vss.t6 26.877
R145 vss vss.n43 2.87807
R146 vss vss.n48 2.87807
R147 vss vss.n49 2.87807
R148 vss vss.n45 2.87807
R149 vss.n4 vss.t16 31.6148
R150 vss vss.n47 2.87807
R151 vss vss.n46 2.87807
R152 vss.n6 vss.t14 20.0513
R153 vss vss.n6 0.9609
R154 vss.t31 vss 9.50005
R155 vss.n1 vss.n20 4.15607
R156 vss.t31 vss.t19 3.42124
R157 vss.t48 vss.t28 1.10219
R158 vss.n38 vss.t24 1.01757
R159 vss.t36 vss 1.01733
R160 a_918_8440.n12 a_918_8440.n6 28.7357
R161 a_918_8440.n10 a_918_8440.n2 27.4943
R162 a_918_8440.n0 a_918_8440.n12 22.9843
R163 a_918_8440.n10 a_918_8440.n4 15.2057
R164 a_918_8440.n2 a_918_8440.n3 0.163315
R165 a_918_8440.n4 a_918_8440.n5 0.163259
R166 a_918_8440.n6 a_918_8440.n7 0.163366
R167 a_918_8440.n0 a_918_8440.n1 0.190285
R168 a_918_8440.t5 a_918_8440.n5 1.06202
R169 a_918_8440.t4 a_918_8440.n3 1.0619
R170 a_918_8440.t6 a_918_8440.n7 1.06183
R171 a_918_8440.t7 a_918_8440.n1 0.50438
R172 a_918_8440.t1 a_918_8440.n9 1.31119
R173 a_918_8440.t2 a_918_8440.n11 1.31115
R174 a_918_8440.t0 a_918_8440.n8 1.31103
R175 a_918_8440.t5 a_918_8440.n9 1.311
R176 a_918_8440.t6 a_918_8440.n11 1.311
R177 a_918_8440.t4 a_918_8440.n8 1.31096
R178 a_918_8440.t3 a_918_8440.n0 1.03271
R179 a_918_8440.n5 a_918_8440.t1 1.07183
R180 a_918_8440.n3 a_918_8440.t0 1.07183
R181 a_918_8440.n7 a_918_8440.t2 1.07179
R182 a_918_8440.n12 a_918_8440.n10 0.691929
R183 a_918_8440.n8 a_918_8440.n2 0.230341
R184 a_918_8440.n11 a_918_8440.n6 0.23027
R185 a_918_8440.n9 a_918_8440.n4 0.230248
R186 a_918_8440.n1 a_918_8440.t3 1.49828
R187 a_918_6928.n1 a_918_6928.n0 16.5305
R188 a_918_6928.n11 a_918_6928.n10 16.4387
R189 a_918_6928.n13 a_918_6928.n12 16.4387
R190 a_918_6928.n0 a_918_6928.n13 14.3382
R191 a_918_6928.n11 a_918_6928.n9 14.3382
R192 a_918_6928.n2 a_918_6928.t14 0.499621
R193 a_918_6928.n1 a_918_6928.n2 0.142659
R194 a_918_6928.t7 a_918_6928.n2 1.51171
R195 a_918_6928.n13 a_918_6928.n11 1.55098
R196 a_918_6928.n3 a_918_6928.t4 0.581552
R197 a_918_6928.t2 a_918_6928.n6 0.596176
R198 a_918_6928.n9 a_918_6928.n5 3.07875
R199 a_918_6928.n4 a_918_6928.n12 7.58878
R200 a_918_6928.n6 a_918_6928.t10 0.582311
R201 a_918_6928.t7 a_918_6928.n1 1.08497
R202 a_918_6928.t1 a_918_6928.n7 0.589697
R203 a_918_6928.t9 a_918_6928.n7 0.58896
R204 a_918_6928.t11 a_918_6928.n8 0.589682
R205 a_918_6928.t3 a_918_6928.n8 0.588894
R206 a_918_6928.n9 a_918_6928.n7 16.6039
R207 a_918_6928.n10 a_918_6928.n8 7.58393
R208 a_918_6928.t6 a_918_6928.n0 3.07893
R209 a_918_6928.t8 a_918_6928.n5 0.597006
R210 a_918_6928.n5 a_918_6928.t0 0.581688
R211 a_918_6928.n6 a_918_6928.n10 3.07886
R212 a_918_6928.n4 a_918_6928.t5 0.596952
R213 a_918_6928.n3 a_918_6928.t12 0.596872
R214 a_918_6928.t13 a_918_6928.n4 0.581587
R215 a_918_6928.n3 a_918_6928.n12 3.07881
C0 vdd a_2663_6072# 0.01931f
C1 a_1303_6072# a_1575_6072# 0.3002f
C2 a_2935_3998# a_3479_4084# 0.02746f
C3 a_5383_4084# bg_n4_0.ea 0.0621f
C4 a_5383_4084# a_5247_4084# 0.50008f
C5 vdd a_5111_6072# 0.01689f
C6 a_895_4084# a_759_4084# 0.50008f
C7 a_4023_4084# a_3479_6072# 0.02699f
C8 a_759_4084# a_487_3998# 0.02699f
C9 a_4023_3998# a_4023_4084# 0.02746f
C10 vdd a_4567_6072# 0.01965f
C11 a_2119_3998# a_2663_4084# 0.02746f
C12 a_8390_5412# bg_n4_0.ks 0.01481f
C13 a_623_6072# a_759_6072# 0.55081f
C14 a_3479_4084# a_3479_6072# 0.02699f
C15 a_1847_6072# a_1983_6072# 0.37789f
C16 a_1167_3998# a_351_3998# 0.01822f
C17 bg_n4_0.vpc bg_n4_0.ks 0.26637f
C18 a_3071_4084# a_3207_4084# 0.50008f
C19 a_5111_6072# a_4431_6072# 0.11607f
C20 a_487_4084# a_623_4084# 0.50008f
C21 bg_n4_0.vpc bg_n4_0.g 29.4909f
C22 a_895_6072# a_759_6072# 0.41057f
C23 a_4431_6072# a_4567_6072# 0.55081f
C24 bg_n4_0.g bg_n4_0.eb 7.48165f
C25 bg_n4_0.vpc bg_n4_0.ea 1.30134f
C26 bg_n4_0.ea a_4839_3998# 0.1073f
C27 bg_n4_0.ea bg_n4_0.eb 0.59879f
C28 en_3v3_b a_5822_5562# 0.07478f
C29 bg_pnp_c_0.e2 bg_n4_0.ea 0.19213f
C30 a_4703_4084# a_4839_4084# 0.50008f
C31 a_895_6072# a_623_6072# 0.10301f
C32 a_5383_4084# a_5519_4084# 0.50008f
C33 vdd en_3v3 3.46729f
C34 en_3v3_b a_5519_4084# 0.03777f
C35 a_4975_4084# a_4431_6072# 0.02746f
C36 a_1167_4084# a_623_6072# 0.02746f
C37 a_2255_3998# a_2255_4084# 0.02699f
C38 a_2935_4084# a_2663_6072# 0.02699f
C39 a_5822_5562# a_5822_5862# 0.01385f
C40 a_3071_4084# a_2935_4084# 0.50008f
C41 a_1575_6072# a_1847_6072# 0.28195f
C42 en_3v3_b a_8390_6012# 0.06778f
C43 a_759_4084# a_759_6072# 0.02699f
C44 a_215_4084# a_351_4084# 0.50008f
C45 a_4295_3998# a_4295_4084# 0.02699f
C46 en_3v3_b a_8390_5712# 0.06784f
C47 bg_pnp_c_0.e2 a_215_4084# 0.02774f
C48 a_2119_4084# a_1983_4084# 0.50008f
C49 a_4295_3998# a_4023_3998# 0.28009f
C50 a_3071_4084# a_3071_3998# 0.02699f
C51 a_4839_3998# a_4839_4084# 0.02746f
C52 a_5111_6072# a_5383_4084# 0.02746f
C53 a_3887_4084# a_3751_4084# 0.50008f
C54 a_215_6072# a_215_4084# 0.02699f
C55 a_4295_4084# a_4159_4084# 0.50008f
C56 vdd a_2799_6072# 0.10596f
C57 a_1575_6072# a_1575_4084# 0.02699f
C58 a_487_3998# a_487_4084# 0.02699f
C59 a_3479_4084# a_3343_4084# 0.50008f
C60 vdd a_5822_5262# 0.02761f
C61 a_3887_6072# a_4703_6072# 0.01125f
C62 a_1167_3998# a_1711_3998# 0.14798f
C63 a_8390_5412# a_8390_5712# 0.01385f
C64 a_895_4084# a_1031_4084# 0.50008f
C65 a_2527_4084# a_2255_3998# 0.02699f
C66 a_3615_3998# a_3615_4084# 0.02746f
C67 bg_pmir_pcas_c_0.vpg bg_n4_0.g 1.01641f
C68 a_3207_3998# a_3615_3998# 0.3154f
C69 a_1983_4084# a_1711_3998# 0.02728f
C70 a_4567_4084# a_4567_6072# 0.02699f
C71 a_895_4084# a_351_3998# 0.02728f
C72 a_79_4084# a_215_4084# 0.50008f
C73 a_2799_6072# a_3479_6072# 0.01297f
C74 a_3207_4084# a_2799_6072# 0.02719f
C75 a_487_3998# a_351_3998# 0.52659f
C76 a_4703_6072# a_5247_4084# 0.02699f
C77 vdd a_3479_6072# 0.04964f
C78 a_487_4084# a_351_4084# 0.50008f
C79 vdd a_4431_6072# 0.01537f
C80 a_3343_6072# a_2799_6072# 0.10146f
C81 vdd a_3343_6072# 0.01537f
C82 a_1439_3998# a_1711_3998# 0.40167f
C83 a_3751_6072# a_4159_4084# 0.02746f
C84 a_215_6072# a_487_4084# 0.02728f
C85 a_4839_3998# a_5111_4084# 0.02746f
C86 a_2527_6072# a_2663_6072# 0.55081f
C87 a_3479_4084# a_3615_4084# 0.50008f
C88 a_1439_3998# a_1167_3998# 0.3002f
C89 a_4159_3998# a_4295_3998# 0.52659f
C90 vdd a_1303_6072# 0.01f
C91 a_3071_4084# a_2527_6072# 0.02746f
C92 bg_n4_0.ks bg_n4_0.g 0.54986f
C93 a_351_4084# a_351_3998# 0.02699f
C94 a_895_6072# a_1575_6072# 0.13337f
C95 bg_n4_0.ks bg_n4_0.ea 2.12138f
C96 bg_pnp_c_0.e2 a_351_3998# 0.14138f
C97 a_3343_6072# a_3479_6072# 0.40019f
C98 a_4295_3998# a_4567_4084# 0.02699f
C99 a_4159_3998# a_4159_4084# 0.02699f
C100 a_2663_4084# a_2663_6072# 0.02699f
C101 vdd iout 1.88431f
C102 bg_n4_0.ea bg_n4_0.g 4.64889f
C103 a_4975_4084# bg_n4_0.eb 0.02699f
C104 a_2255_3998# a_1711_3998# 0.01822f
C105 a_1031_4084# a_759_6072# 0.02699f
C106 a_1575_6072# a_1983_6072# 0.41801f
C107 a_2391_4084# a_1847_6072# 0.02746f
C108 bg_n4_0.ea a_5247_4084# 0.07032f
C109 a_2935_4084# a_2935_3998# 0.02746f
C110 vdd a_5822_6162# 0.02761f
C111 a_2527_6072# a_2527_4084# 0.02746f
C112 vdd en_3v3_b 9.41678f
C113 a_4431_4084# a_4295_4084# 0.50008f
C114 en_3v3_b a_5822_5262# 0.0746f
C115 a_2935_3998# a_3071_3998# 0.55081f
C116 a_1303_4084# a_1303_6072# 0.02746f
C117 vdd a_5822_5862# 0.0278f
C118 a_4431_4084# a_4023_3998# 0.02746f
C119 a_1711_4084# a_1711_3998# 0.02699f
C120 a_4431_6072# a_4431_4084# 0.02746f
C121 a_2391_4084# a_2391_3998# 0.02699f
C122 a_2799_4084# a_2799_6072# 0.02699f
C123 a_2527_4084# a_2663_4084# 0.50008f
C124 a_1031_3998# a_1031_4084# 0.02746f
C125 a_3751_6072# a_3479_6072# 0.38193f
C126 vdd a_8390_5412# 0.02802f
C127 a_5111_6072# a_4703_6072# 0.3154f
C128 a_3751_6072# a_3343_6072# 0.11607f
C129 a_1031_3998# a_351_3998# 0.10146f
C130 a_4703_6072# a_4567_6072# 0.41057f
C131 a_5519_4084# bg_n4_0.ks 0.03313f
C132 a_2255_4084# a_1983_6072# 0.02699f
C133 a_1167_4084# a_1031_4084# 0.50008f
C134 a_4159_3998# a_4023_3998# 0.38255f
C135 vdd a_1847_6072# 0.01537f
C136 vdd bg_n4_0.vpc 18.6927f
C137 a_3207_4084# a_3343_4084# 0.50008f
C138 a_5519_4084# bg_n4_0.ea 0.05915f
C139 a_2119_3998# a_2119_4084# 0.02746f
C140 a_2527_6072# a_2799_6072# 0.20448f
C141 a_3343_6072# a_3343_4084# 0.02746f
C142 a_3887_6072# a_3887_4084# 0.02699f
C143 vdd a_2527_6072# 0.01537f
C144 a_3887_6072# a_4567_6072# 0.01297f
C145 a_3751_6072# a_3751_4084# 0.02746f
C146 a_1303_6072# a_1711_4084# 0.02746f
C147 a_1303_4084# a_1439_4084# 0.50008f
C148 a_1983_4084# a_1847_4084# 0.50008f
C149 a_1439_4084# a_1439_3998# 0.02746f
C150 bg_pmir_pcas_c_0.vpg en_3v3 0.54287f
C151 a_2391_3998# a_2935_3998# 0.10146f
C152 a_1575_4084# a_1167_3998# 0.02699f
C153 en_3v3_b a_5822_6162# 0.097f
C154 vdd a_759_6072# 0.01763f
C155 bg_n4_0.ea a_5111_4084# 0.01551f
C156 a_5247_4084# a_5111_4084# 0.50008f
C157 a_2935_4084# a_2799_4084# 0.50008f
C158 a_4431_4084# a_4567_4084# 0.50008f
C159 a_3207_3998# a_2935_3998# 0.10301f
C160 a_5822_6162# a_5822_5862# 0.01385f
C161 en_3v3_b a_5822_5862# 0.07524f
C162 a_2119_3998# a_1711_3998# 0.10146f
C163 a_1847_4084# a_1439_3998# 0.02746f
C164 a_1303_6072# a_1847_6072# 0.11607f
C165 a_3071_3998# a_3343_4084# 0.02699f
C166 a_3207_4084# a_3207_3998# 0.02699f
C167 en_3v3_b a_8390_5412# 0.06806f
C168 a_3343_6072# a_3615_4084# 0.02746f
C169 bg_pmir_pcas_c_0.vpg vdd 25.1269f
C170 a_3615_3998# a_3887_4084# 0.02746f
C171 bg_n4_0.vpc iout 29.3875f
C172 a_1031_3998# a_1167_3998# 0.40019f
C173 a_4567_6072# a_4839_4084# 0.02699f
C174 vdd a_4703_6072# 0.13551f
C175 a_4159_3998# a_4703_4084# 0.02728f
C176 en_3v3_b bg_n4_0.vpc 0.32276f
C177 vdd a_895_6072# 0.13438f
C178 bg_n4_0.g en_3v3 0.01132f
C179 a_4703_4084# a_4567_4084# 0.50008f
C180 a_5383_4084# bg_n4_0.eb 0.0202f
C181 a_8390_5712# a_8390_6012# 0.01385f
C182 a_2391_3998# a_2255_3998# 0.41558f
C183 a_4975_4084# a_4839_4084# 0.50008f
C184 a_1167_4084# a_1167_3998# 0.02699f
C185 a_623_6072# a_623_4084# 0.02746f
C186 a_2391_3998# a_3071_3998# 0.01297f
C187 a_4159_3998# a_4839_3998# 0.10146f
C188 a_3887_4084# a_4023_4084# 0.50008f
C189 a_4159_3998# bg_n4_0.eb 0.01822f
C190 vdd a_1983_6072# 0.07554f
C191 a_1031_3998# a_1303_4084# 0.02746f
C192 a_1711_4084# a_1847_4084# 0.50008f
C193 a_3751_4084# a_3615_4084# 0.50008f
C194 vdd a_3887_6072# 0.10596f
C195 a_4431_6072# a_4703_6072# 0.10301f
C196 a_1031_3998# a_1439_3998# 0.11607f
C197 a_1303_6072# a_623_6072# 0.11607f
C198 vdd bg_n4_0.ks 0.2122f
C199 a_3207_3998# a_3751_4084# 0.02699f
C200 bg_pnp_c_0.e2 a_487_3998# 0.0224f
C201 a_2119_4084# a_1575_6072# 0.02699f
C202 a_3207_3998# a_3071_3998# 0.41057f
C203 a_5822_5262# bg_n4_0.ks 0.02294f
C204 vdd bg_n4_0.g 1.12983f
C205 a_2391_3998# a_2799_4084# 0.02719f
C206 a_1575_4084# a_1711_4084# 0.50008f
C207 a_5111_6072# a_5111_4084# 0.02746f
C208 a_1983_6072# a_1983_4084# 0.02699f
C209 a_2119_3998# a_2255_3998# 0.55081f
C210 a_3887_6072# a_4295_4084# 0.02719f
C211 a_1303_4084# a_1167_4084# 0.50008f
C212 a_3887_6072# a_3479_6072# 0.29761f
C213 a_1847_6072# a_1847_4084# 0.02746f
C214 bg_n4_0.vpc bg_n4_0.eb 0.25735f
C215 bg_pmir_pcas_c_0.vpg iout 0.13849f
C216 a_3887_6072# a_4431_6072# 0.10146f
C217 a_895_6072# a_1303_6072# 0.21541f
C218 a_1575_4084# a_1439_4084# 0.50008f
C219 a_4839_3998# bg_n4_0.eb 0.4008f
C220 a_2799_4084# a_2663_4084# 0.50008f
C221 a_2527_6072# a_1847_6072# 0.11607f
C222 a_2391_4084# a_2255_4084# 0.50008f
C223 vdd a_1575_6072# 0.04964f
C224 a_4975_4084# a_5111_4084# 0.50008f
C225 a_759_4084# a_623_4084# 0.50008f
C226 a_4023_4084# a_4159_4084# 0.50008f
C227 a_2119_4084# a_2255_4084# 0.50008f
C228 a_3615_3998# a_2935_3998# 0.11607f
C229 vdd a_5822_5562# 0.0278f
C230 a_3887_6072# a_3751_6072# 0.30446f
C231 a_3207_3998# a_2391_3998# 0.01125f
C232 a_4703_4084# a_4703_6072# 0.02699f
C233 a_5822_5562# a_5822_5262# 0.01385f
C234 a_895_6072# a_895_4084# 0.02699f
C235 a_215_6072# a_759_6072# 0.01822f
C236 a_3615_3998# a_4023_3998# 0.11607f
C237 vdd a_5519_4084# 0.07928f
C238 a_2391_4084# a_2527_4084# 0.50008f
C239 bg_n4_0.g iout 5.8717f
C240 en_3v3_b bg_n4_0.ks 1.2426f
C241 bg_pmir_pcas_c_0.vpg bg_n4_0.vpc 3.38914f
C242 vdd a_8390_6012# 0.04353f
C243 a_895_6072# a_1439_4084# 0.02699f
C244 a_2119_3998# a_2391_3998# 0.20448f
C245 vdd a_8390_5712# 0.02831f
C246 a_2799_6072# a_2663_6072# 0.41558f
C247 en_3v3_b bg_n4_0.g 0.20392f
C248 a_215_6072# a_623_6072# 0.10146f
C249 iout vss 2.09723f
C250 vdd vss 2.7024f
C251 a_5822_5262# vss 0.03497f
C252 a_8390_5412# vss 0.04077f
C253 a_5822_5562# vss 0.03497f
C254 a_8390_5712# vss 0.04077f
C255 a_5822_5862# vss 0.03662f
C256 bg_n4_0.ea vss 5.83772f
C257 a_5111_6072# vss 0.92725f
C258 bg_n4_0.eb vss 4.175f
C259 a_4839_3998# vss 0.84644f
C260 a_4703_6072# vss 1.00553f
C261 a_4567_6072# vss 0.82637f
C262 a_4431_6072# vss 0.85911f
C263 a_4295_3998# vss 0.91793f
C264 a_4159_3998# vss 0.90737f
C265 a_4023_3998# vss 0.83879f
C266 a_3887_6072# vss 0.95103f
C267 a_3751_6072# vss 0.81543f
C268 a_3615_3998# vss 0.82009f
C269 a_3479_6072# vss 0.87439f
C270 a_3343_6072# vss 0.8031f
C271 a_3207_3998# vss 1.16959f
C272 a_3071_3998# vss 0.82617f
C273 a_2935_3998# vss 0.85535f
C274 a_2799_6072# vss 0.94942f
C275 a_2663_6072# vss 0.81417f
C276 a_2527_6072# vss 0.84667f
C277 a_2391_3998# vss 1.10169f
C278 a_2255_3998# vss 0.81898f
C279 a_2119_3998# vss 0.85809f
C280 a_1983_6072# vss 0.89773f
C281 a_1847_6072# vss 0.84337f
C282 a_1711_3998# vss 0.87137f
C283 a_1575_6072# vss 0.86963f
C284 a_1439_3998# vss 0.82268f
C285 a_1303_6072# vss 0.82259f
C286 a_1167_3998# vss 0.90551f
C287 a_1031_3998# vss 0.82699f
C288 a_895_6072# vss 0.98467f
C289 a_759_6072# vss 0.82263f
C290 a_623_6072# vss 0.88017f
C291 a_487_3998# vss 1.29329f
C292 a_351_3998# vss 1.21969f
C293 bg_pnp_c_0.e2 vss 8.57521f
C294 a_215_6072# vss 1.42104f
C295 a_8390_6012# vss 0.04077f
C296 a_5822_6162# vss 0.03927f
C297 a_918_6928.t6 vss 4.74402f
C298 a_918_6928.n0 vss 1.78792f
C299 a_918_6928.n1 vss 3.02602f
C300 a_918_6928.n2 vss 0.44252f
C301 a_918_6928.n3 vss 2.1107f
C302 a_918_6928.n4 vss 3.01516f
C303 a_918_6928.n5 vss 2.11092f
C304 a_918_6928.n6 vss 2.11043f
C305 a_918_6928.n7 vss 3.34904f
C306 a_918_6928.n8 vss 3.01441f
C307 a_918_6928.t9 vss 1.31777f
C308 a_918_6928.t1 vss 2.83826f
C309 a_918_6928.t0 vss 1.30884f
C310 a_918_6928.t8 vss 1.32434f
C311 a_918_6928.n9 vss 1.80046f
C312 a_918_6928.t3 vss 1.31782f
C313 a_918_6928.t11 vss 1.31789f
C314 a_918_6928.t10 vss 1.30945f
C315 a_918_6928.t2 vss 1.32417f
C316 a_918_6928.n10 vss 1.8702f
C317 a_918_6928.n11 vss 0.82483f
C318 a_918_6928.t13 vss 1.30907f
C319 a_918_6928.t5 vss 1.3242f
C320 a_918_6928.t4 vss 1.309f
C321 a_918_6928.t12 vss 1.74513f
C322 a_918_6928.n12 vss 1.87186f
C323 a_918_6928.n13 vss 0.82483f
C324 a_918_6928.t14 vss 1.22659f
C325 a_918_6928.t7 vss 1.30202f
C326 a_918_8440.n0 vss 5.29786f
C327 a_918_8440.n1 vss 0.73204f
C328 a_918_8440.t3 vss 1.64416f
C329 a_918_8440.n2 vss 4.2905f
C330 a_918_8440.n3 vss 0.78103f
C331 a_918_8440.n4 vss 4.35248f
C332 a_918_8440.n5 vss 0.78077f
C333 a_918_8440.n6 vss 3.85242f
C334 a_918_8440.n7 vss 0.78138f
C335 a_918_8440.t7 vss 1.56563f
C336 a_918_8440.n8 vss 0.83718f
C337 a_918_8440.t0 vss 1.56964f
C338 a_918_8440.t4 vss 1.56528f
C339 a_918_8440.n9 vss 0.83732f
C340 a_918_8440.t1 vss 1.56946f
C341 a_918_8440.t5 vss 1.68177f
C342 a_918_8440.n10 vss 2.45262f
C343 a_918_8440.n11 vss 0.83723f
C344 a_918_8440.t2 vss 1.56962f
C345 a_918_8440.t6 vss 1.56525f
C346 a_918_8440.n12 vss 2.75613f
C347 vss.t28 vss 0.81034f
C348 vss.t48 vss 0.45872f
C349 vss.t19 vss 0.87629f
C350 vss.t31 vss 0.86735f
C351 vss.t24 vss 1.32378f
C352 vss.t49 vss 0.45872f
Rtie0 a_1031_4084# vss 1e12
Rtie1 a_1167_4084# vss 1e12
Rtie2 a_1303_4084# vss 1e12
Rtie3 a_1439_4084# vss 1e12
Rtie4 a_1575_4084# vss 1e12
Rtie5 a_1711_4084# vss 1e12
Rtie6 a_1847_4084# vss 1e12
Rtie7 a_1983_4084# vss 1e12
Rtie8 a_2119_4084# vss 1e12
Rtie9 a_215_4084# vss 1e12
Rtie10 a_2255_4084# vss 1e12
Rtie11 a_2391_4084# vss 1e12
Rtie12 a_2527_4084# vss 1e12
Rtie13 a_2663_4084# vss 1e12
Rtie14 a_2799_4084# vss 1e12
Rtie15 a_2935_4084# vss 1e12
Rtie16 a_3071_4084# vss 1e12
Rtie17 a_3207_4084# vss 1e12
Rtie18 a_3343_4084# vss 1e12
Rtie19 a_3479_4084# vss 1e12
Rtie20 a_351_4084# vss 1e12
Rtie21 a_3615_4084# vss 1e12
Rtie22 a_3751_4084# vss 1e12
Rtie23 a_3887_4084# vss 1e12
Rtie24 a_4023_4084# vss 1e12
Rtie25 a_4159_4084# vss 1e12
Rtie26 a_4295_4084# vss 1e12
Rtie27 a_4431_4084# vss 1e12
Rtie28 a_4567_4084# vss 1e12
Rtie29 a_4703_4084# vss 1e12
Rtie30 a_4839_4084# vss 1e12
Rtie31 a_487_4084# vss 1e12
Rtie32 a_4975_4084# vss 1e12
Rtie33 a_5111_4084# vss 1e12
Rtie34 a_5247_4084# vss 1e12
Rtie35 a_5383_4084# vss 1e12
Rtie36 a_5519_4084# vss 1e12
Rtie37 a_623_4084# vss 1e12
Rtie38 a_759_4084# vss 1e12
Rtie39 a_79_4084# vss 1e12
Rtie40 a_895_4084# vss 1e12
.ends
