* generated by scripts/cace/pex_for_sim.py from ../bg_core_pd/netlist/pex/bg_core_pd_magic_pex_2.spice: 41 capacitor-only nodes tied to vss through 1e12 Ohm
* PEX produced on Fri Oct 30 22:41:10 UTC 2026 using /usr/local/bin/sak-pex.sh with m=2 and s=1
* NGSPICE file created from bg_core_pd_pex.ext - technology: ihp-sg13cmos5l

.subckt bg_core_pd_pex vdd vss iout en_3v3 en_3v3_b
X0 a_4703_6072# bg_n4_0.ea vss rhigh l=9.94u w=0.5u
X1 a_4431_6072# bg_n4_0.eb vss rhigh l=9.94u w=0.5u
X2 a_623_6072# a_1167_3998# vss rhigh l=9.94u w=0.5u
X3 a_918_8440# bg_pmir_pcas_c_0.vpg vdd vdd sg13_hv_pmos ad=3.4p pd=20.68u as=3.4p ps=20.68u w=10u l=1u
X4 bg_n4_0.g bg_n4_0.g bg_n4_0.g vss sg13_hv_nmos ad=0.68p pd=4.68u as=73.8615p ps=0.3643m w=2u l=4u
X5 vdd bg_pmir_pcas_c_0.vpg vdd vdd sg13_hv_pmos ad=0.102p pd=1.28u as=0.15688n ps=0.4126m w=0.3u l=1u
X6 a_918_6928# bg_n4_0.vpc iout vdd sg13_hv_pmos ad=3.4p pd=20.68u as=3.4p ps=20.68u w=10u l=1u
X7 a_2799_6072# a_2391_3998# vss rhigh l=9.94u w=0.5u
X8 vdd bg_pmir_pcas_c_0.vpg bg_pmir_pcas_c_0.vpg vdd sg13_hv_pmos ad=3.4p pd=20.68u as=3.4p ps=20.68u w=10u l=1u
X9 a_1847_6072# a_2391_3998# vss rhigh l=9.94u w=0.5u
X10 vdd bg_pmir_pcas_c_0.vpg a_918_6928# vdd sg13_hv_pmos ad=3.4p pd=20.68u as=3.4p ps=20.68u w=10u l=1u
X11 bg_n4_0.vpc bg_n4_0.vpc bg_pmir_pcas_c_0.vpg vdd sg13_hv_pmos ad=3.4p pd=20.68u as=3.4p ps=20.68u w=10u l=1u
X12 a_4703_6072# a_4159_3998# vss rhigh l=9.94u w=0.5u
X13 vdd bg_n4_0.vpc vdd vdd sg13_hv_pmos ad=0.102p pd=1.28u as=0 ps=0 w=0.3u l=1u
X14 a_3887_6072# a_4295_3998# vss rhigh l=9.94u w=0.5u
X15 vdd bg_n4_0.vpc vdd vdd sg13_hv_pmos ad=0.102p pd=1.28u as=0 ps=0 w=0.3u l=1u
X16 vss en_3v3_b bg_n4_0.ks vss sg13_hv_nmos ad=0.34p pd=2.68u as=0.34p ps=2.68u w=1u l=0.45u
X17 vss bg_n4_0.ks bg_n4_0.vpc vss sg13_hv_nmos ad=0.17p pd=1.68u as=0.17p ps=1.68u w=0.5u l=2u
X18 a_2527_6072# a_2255_3998# vss rhigh l=9.94u w=0.5u
X19 a_215_6072# a_487_3998# vss rhigh l=9.94u w=0.5u
X20 vdd en_3v3 bg_pmir_pcas_c_0.vpg vdd sg13_hv_pmos ad=0.34p pd=2.68u as=0.34p ps=2.68u w=1u l=0.45u
X21 vss vss bg_n4_0.ea pnpMPA a=4p p=8u
X22 vdd bg_n4_0.vpc vdd vdd sg13_hv_pmos ad=0.102p pd=1.28u as=0 ps=0 w=0.3u l=1u
X23 vdd bg_n4_0.vpc vdd vdd sg13_hv_pmos ad=0.102p pd=1.28u as=0 ps=0 w=0.3u l=1u
X24 bg_n4_0.g bg_n4_0.g bg_n4_0.g vss sg13_hv_nmos ad=0.68p pd=4.68u as=0 ps=0 w=2u l=4u
X25 a_8390_5412# en_3v3_b a_5822_5262# vdd sg13_hv_pmos ad=0.17p pd=1.68u as=0.17p ps=1.68u w=0.5u l=12.5u
X26 a_3479_6072# a_4023_3998# vss rhigh l=9.94u w=0.5u
X27 a_3751_6072# a_3207_3998# vss rhigh l=9.94u w=0.5u
X28 vdd bg_pmir_pcas_c_0.vpg a_918_6928# vdd sg13_hv_pmos ad=3.4p pd=20.68u as=3.4p ps=20.68u w=10u l=1u
X29 a_215_6072# bg_pnp_c_0.e2 vss rhigh l=9.94u w=0.5u
X30 bg_pmir_pcas_c_0.vpg bg_pmir_pcas_c_0.vpg vdd vdd sg13_hv_pmos ad=3.4p pd=20.68u as=3.4p ps=20.68u w=10u l=1u
X31 a_8390_5712# en_3v3_b a_5822_5562# vdd sg13_hv_pmos ad=0.17p pd=1.68u as=0.17p ps=1.68u w=0.5u l=12.5u
X32 a_1575_6072# a_1167_3998# vss rhigh l=9.94u w=0.5u
X33 a_918_8440# bg_n4_0.vpc bg_n4_0.g vdd sg13_hv_pmos ad=3.4p pd=20.68u as=3.4p ps=20.68u w=10u l=1u
X34 bg_n4_0.ks en_3v3_b a_5822_5262# vdd sg13_hv_pmos ad=0.17p pd=1.68u as=0.17p ps=1.68u w=0.5u l=12.5u
X35 vdd bg_pmir_pcas_c_0.vpg bg_pmir_pcas_c_0.vpg vdd sg13_hv_pmos ad=3.4p pd=20.68u as=3.4p ps=20.68u w=10u l=1u
X36 bg_n4_0.g bg_n4_0.g bg_n4_0.ea vss sg13_hv_nmos ad=3.4p pd=20.68u as=3.4p ps=20.68u w=10u l=4u
X37 vss vss bg_pnp_c_0.e2 pnpMPA a=4p p=8u
X38 a_3479_6072# a_2935_3998# vss rhigh l=9.94u w=0.5u
X39 a_2527_6072# a_3071_3998# vss rhigh l=9.94u w=0.5u
X40 iout bg_n4_0.vpc a_918_6928# vdd sg13_hv_pmos ad=3.4p pd=20.68u as=3.4p ps=20.68u w=10u l=1u
X41 bg_pmir_pcas_c_0.vpg bg_n4_0.vpc bg_n4_0.vpc vdd sg13_hv_pmos ad=3.4p pd=20.68u as=3.4p ps=20.68u w=10u l=1u
X42 bg_n4_0.g bg_n4_0.g bg_n4_0.g vss sg13_hv_nmos ad=0.68p pd=4.68u as=0 ps=0 w=2u l=4u
X43 vdd bg_n4_0.vpc vdd vdd sg13_hv_pmos ad=0.102p pd=1.28u as=0 ps=0 w=0.3u l=1u
X44 a_8390_5412# en_3v3_b a_5822_5562# vdd sg13_hv_pmos ad=0.17p pd=1.68u as=0.17p ps=1.68u w=0.5u l=12.5u
X45 a_1303_6072# a_1031_3998# vss rhigh l=9.94u w=0.5u
X46 a_918_6928# bg_n4_0.vpc iout vdd sg13_hv_pmos ad=3.4p pd=20.68u as=3.4p ps=20.68u w=10u l=1u
X47 iout bg_n4_0.vpc a_918_6928# vdd sg13_hv_pmos ad=3.4p pd=20.68u as=3.4p ps=20.68u w=10u l=1u
X48 a_8390_6012# en_3v3_b a_5822_5862# vdd sg13_hv_pmos ad=0.17p pd=1.68u as=0.17p ps=1.68u w=0.5u l=12.5u
X49 a_918_6928# bg_pmir_pcas_c_0.vpg vdd vdd sg13_hv_pmos ad=3.4p pd=20.68u as=3.4p ps=20.68u w=10u l=1u
X50 a_2799_6072# a_3207_3998# vss rhigh l=9.94u w=0.5u
X51 a_2663_6072# a_2935_3998# vss rhigh l=9.94u w=0.5u
X52 a_895_6072# a_351_3998# vss rhigh l=9.94u w=0.5u
X53 vdd bg_n4_0.vpc vdd vdd sg13_hv_pmos ad=0.102p pd=1.28u as=0 ps=0 w=0.3u l=1u
X54 a_8390_5712# en_3v3_b a_5822_5862# vdd sg13_hv_pmos ad=0.17p pd=1.68u as=0.17p ps=1.68u w=0.5u l=12.5u
X55 bg_n4_0.g bg_n4_0.vpc a_918_8440# vdd sg13_hv_pmos ad=3.4p pd=20.68u as=3.4p ps=20.68u w=10u l=1u
X56 bg_n4_0.g bg_n4_0.g bg_n4_0.g vss sg13_hv_nmos ad=0.68p pd=4.68u as=0 ps=0 w=2u l=4u
X57 vdd bg_pmir_pcas_c_0.vpg vdd vdd sg13_hv_pmos ad=0.102p pd=1.28u as=0 ps=0 w=0.3u l=1u
X58 a_4567_6072# a_4839_3998# vss rhigh l=9.94u w=0.5u
X59 a_4431_6072# a_4023_3998# vss rhigh l=9.94u w=0.5u
X60 vdd en_3v3_b a_5822_6162# vdd sg13_hv_pmos ad=0.17p pd=1.68u as=0.17p ps=1.68u w=0.5u l=12.5u
X61 vdd bg_pmir_pcas_c_0.vpg a_918_8440# vdd sg13_hv_pmos ad=3.4p pd=20.68u as=3.4p ps=20.68u w=10u l=1u
X62 a_623_6072# vss vss rhigh l=9.94u w=0.5u
X63 a_1983_6072# a_2255_3998# vss rhigh l=9.94u w=0.5u
X64 vss vss bg_pnp_c_0.e2 pnpMPA a=4p p=8u
X65 bg_n4_0.g bg_n4_0.g bg_n4_0.g vss sg13_hv_nmos ad=0.68p pd=4.68u as=0 ps=0 w=2u l=4u
X66 vss bg_n4_0.g bg_n4_0.ks vss sg13_hv_nmos ad=3.4p pd=20.68u as=3.4p ps=20.68u w=10u l=1u
X67 a_1983_6072# a_1711_3998# vss rhigh l=9.94u w=0.5u
X68 bg_n4_0.g bg_n4_0.g bg_n4_0.g vss sg13_hv_nmos ad=0.68p pd=4.68u as=0 ps=0 w=2u l=4u
X69 a_918_6928# bg_n4_0.vpc iout vdd sg13_hv_pmos ad=3.4p pd=20.68u as=3.4p ps=20.68u w=10u l=1u
X70 a_3751_6072# a_4159_3998# vss rhigh l=9.94u w=0.5u
X71 a_3887_6072# a_3615_3998# vss rhigh l=9.94u w=0.5u
X72 a_8390_6012# en_3v3_b a_5822_6162# vdd sg13_hv_pmos ad=0.17p pd=1.68u as=0.17p ps=1.68u w=0.5u l=12.5u
X73 vss vss bg_pnp_c_0.e2 pnpMPA a=4p p=8u
X74 a_918_6928# bg_pmir_pcas_c_0.vpg vdd vdd sg13_hv_pmos ad=3.4p pd=20.68u as=3.4p ps=20.68u w=10u l=1u
X75 vdd bg_pmir_pcas_c_0.vpg vdd vdd sg13_hv_pmos ad=0.102p pd=1.28u as=0 ps=0 w=0.3u l=1u
X76 vss vss vss rhigh l=9.94u w=0.5u
X77 bg_pmir_pcas_c_0.vpg bg_n4_0.vpc bg_n4_0.vpc vdd sg13_hv_pmos ad=3.4p pd=20.68u as=3.4p ps=20.68u w=10u l=1u
X78 bg_n4_0.g bg_n4_0.g bg_n4_0.g vss sg13_hv_nmos ad=0.68p pd=4.68u as=0 ps=0 w=2u l=4u
X79 bg_n4_0.g bg_n4_0.vpc a_918_8440# vdd sg13_hv_pmos ad=3.4p pd=20.68u as=3.4p ps=20.68u w=10u l=1u
X80 a_5111_6072# bg_n4_0.eb vss rhigh l=9.94u w=0.5u
X81 a_1303_6072# a_1711_3998# vss rhigh l=9.94u w=0.5u
X82 bg_n4_0.ea bg_n4_0.g bg_n4_0.g vss sg13_hv_nmos ad=3.4p pd=20.68u as=3.4p ps=20.68u w=10u l=4u
X83 a_3343_6072# a_3615_3998# vss rhigh l=9.94u w=0.5u
X84 iout bg_n4_0.vpc a_918_6928# vdd sg13_hv_pmos ad=3.4p pd=20.68u as=3.4p ps=20.68u w=10u l=1u
X85 vdd bg_pmir_pcas_c_0.vpg a_918_6928# vdd sg13_hv_pmos ad=3.4p pd=20.68u as=3.4p ps=20.68u w=10u l=1u
X86 vdd bg_pmir_pcas_c_0.vpg vdd vdd sg13_hv_pmos ad=0.102p pd=1.28u as=0 ps=0 w=0.3u l=1u
X87 vdd bg_pmir_pcas_c_0.vpg vdd vdd sg13_hv_pmos ad=0.102p pd=1.28u as=0 ps=0 w=0.3u l=1u
X88 vss vss vss rhigh l=9.94u w=0.5u
X89 a_895_6072# a_1439_3998# vss rhigh l=9.94u w=0.5u
X90 vss vss bg_pnp_c_0.e2 pnpMPA a=4p p=8u
X91 a_5111_6072# a_4839_3998# vss rhigh l=9.94u w=0.5u
X92 vss vss bg_pnp_c_0.e2 pnpMPA a=4p p=8u
X93 a_759_6072# a_1031_3998# vss rhigh l=9.94u w=0.5u
X94 bg_n4_0.eb bg_n4_0.g bg_n4_0.vpc vss sg13_hv_nmos ad=3.4p pd=20.68u as=3.4p ps=20.68u w=10u l=4u
X95 bg_pmir_pcas_c_0.vpg bg_pmir_pcas_c_0.vpg vdd vdd sg13_hv_pmos ad=3.4p pd=20.68u as=3.4p ps=20.68u w=10u l=1u
X96 a_918_8440# bg_n4_0.vpc bg_n4_0.g vdd sg13_hv_pmos ad=3.4p pd=20.68u as=3.4p ps=20.68u w=10u l=1u
X97 a_2663_6072# a_2119_3998# vss rhigh l=9.94u w=0.5u
X98 vss vss bg_pnp_c_0.e2 pnpMPA a=4p p=8u
X99 a_4567_6072# a_4295_3998# vss rhigh l=9.94u w=0.5u
X100 vdd bg_pmir_pcas_c_0.vpg vdd vdd sg13_hv_pmos ad=0.102p pd=1.28u as=0 ps=0 w=0.3u l=1u
X101 iout bg_n4_0.vpc a_918_6928# vdd sg13_hv_pmos ad=3.4p pd=20.68u as=3.4p ps=20.68u w=10u l=1u
X102 vdd bg_pmir_pcas_c_0.vpg a_918_6928# vdd sg13_hv_pmos ad=3.4p pd=20.68u as=3.4p ps=20.68u w=10u l=1u
X103 a_759_6072# a_487_3998# vss rhigh l=9.94u w=0.5u
X104 vdd bg_pmir_pcas_c_0.vpg vdd vdd sg13_hv_pmos ad=0.102p pd=1.28u as=0 ps=0 w=0.3u l=1u
X105 vss a_351_3998# vss rhigh l=9.94u w=0.5u
X106 bg_n4_0.g bg_n4_0.g bg_n4_0.g vss sg13_hv_nmos ad=0.68p pd=4.68u as=0 ps=0 w=2u l=1u
X107 a_918_8440# bg_pmir_pcas_c_0.vpg vdd vdd sg13_hv_pmos ad=3.4p pd=20.68u as=3.4p ps=20.68u w=10u l=1u
X108 bg_n4_0.vpc bg_n4_0.g bg_n4_0.eb vss sg13_hv_nmos ad=3.4p pd=20.68u as=3.4p ps=20.68u w=10u l=4u
X109 vdd bg_pmir_pcas_c_0.vpg vdd vdd sg13_hv_pmos ad=0.102p pd=1.28u as=0 ps=0 w=0.3u l=1u
X110 a_918_6928# bg_pmir_pcas_c_0.vpg vdd vdd sg13_hv_pmos ad=3.4p pd=20.68u as=3.4p ps=20.68u w=10u l=1u
X111 vss vss bg_pnp_c_0.e2 pnpMPA a=4p p=8u
X112 vss vss bg_pnp_c_0.e2 pnpMPA a=4p p=8u
X113 vdd bg_n4_0.vpc vdd vdd sg13_hv_pmos ad=0.102p pd=1.28u as=0 ps=0 w=0.3u l=1u
X114 a_1575_6072# a_2119_3998# vss rhigh l=9.94u w=0.5u
X115 a_1847_6072# a_1439_3998# vss rhigh l=9.94u w=0.5u
X116 bg_n4_0.g bg_n4_0.g bg_n4_0.g vss sg13_hv_nmos ad=0.68p pd=4.68u as=0 ps=0 w=2u l=4u
X117 a_918_6928# bg_n4_0.vpc iout vdd sg13_hv_pmos ad=3.4p pd=20.68u as=3.4p ps=20.68u w=10u l=1u
X118 vdd bg_n4_0.vpc vdd vdd sg13_hv_pmos ad=0.102p pd=1.28u as=0 ps=0 w=0.3u l=1u
X119 vdd bg_pmir_pcas_c_0.vpg a_918_8440# vdd sg13_hv_pmos ad=3.4p pd=20.68u as=3.4p ps=20.68u w=10u l=1u
X120 a_3343_6072# a_3071_3998# vss rhigh l=9.94u w=0.5u
X121 a_918_6928# bg_pmir_pcas_c_0.vpg vdd vdd sg13_hv_pmos ad=3.4p pd=20.68u as=3.4p ps=20.68u w=10u l=1u
X122 bg_n4_0.vpc bg_n4_0.vpc bg_pmir_pcas_c_0.vpg vdd sg13_hv_pmos ad=3.4p pd=20.68u as=3.4p ps=20.68u w=10u l=1u
C0 vdd bg_n4_0.g 1.12983f
C1 a_3479_6072# a_3887_6072# 0.29761f
C2 iout a_918_6928# 2.5436f
C3 a_1711_4084# a_1711_3998# 0.02699f
C4 a_759_6072# a_623_6072# 0.55081f
C5 vdd a_8390_5412# 0.02802f
C6 a_8390_5712# a_8390_5412# 0.01385f
C7 a_487_3998# a_351_3998# 0.52659f
C8 vdd a_2799_6072# 0.10596f
C9 a_4839_3998# a_4159_3998# 0.10146f
C10 a_2527_6072# a_3071_4084# 0.02746f
C11 a_2935_4084# a_2799_4084# 0.50008f
C12 a_2799_4084# a_2391_3998# 0.02719f
C13 a_1983_6072# a_1575_6072# 0.41801f
C14 a_2255_4084# a_2119_4084# 0.50008f
C15 a_4703_4084# a_4159_3998# 0.02728f
C16 a_2935_4084# a_3071_4084# 0.50008f
C17 a_895_4084# a_895_6072# 0.02699f
C18 a_5822_5862# a_5822_6162# 0.01385f
C19 bg_pmir_pcas_c_0.vpg vdd 25.1269f
C20 a_3479_6072# a_2799_6072# 0.01297f
C21 a_2799_6072# a_2527_6072# 0.20448f
C22 en_3v3_b a_5519_4084# 0.03777f
C23 a_1303_6072# a_1303_4084# 0.02746f
C24 a_2391_4084# a_2527_4084# 0.50008f
C25 a_1167_3998# a_1031_3998# 0.40019f
C26 a_4023_4084# a_4159_4084# 0.50008f
C27 a_2799_4084# a_2799_6072# 0.02699f
C28 a_895_4084# a_351_3998# 0.02728f
C29 a_895_6072# a_623_6072# 0.10301f
C30 a_3207_3998# a_3071_3998# 0.41057f
C31 a_5247_4084# a_5111_4084# 0.50008f
C32 vdd a_5519_4084# 0.07928f
C33 a_3343_6072# a_3615_4084# 0.02746f
C34 a_4159_3998# a_4295_3998# 0.52659f
C35 en_3v3_b a_918_8440# 0.23464f
C36 a_4431_6072# a_5111_6072# 0.11607f
C37 a_1303_6072# a_1711_4084# 0.02746f
C38 vdd a_1983_6072# 0.07554f
C39 a_1167_3998# a_1711_3998# 0.14798f
C40 a_2391_4084# a_2391_3998# 0.02699f
C41 a_4023_3998# a_4159_3998# 0.38255f
C42 bg_pmir_pcas_c_0.vpg bg_n4_0.g 1.01641f
C43 a_3343_4084# a_3207_4084# 0.50008f
C44 a_4431_4084# a_4295_4084# 0.50008f
C45 vdd a_5111_6072# 0.01689f
C46 vdd a_918_8440# 7.09172f
C47 a_1167_3998# a_351_3998# 0.01822f
C48 a_2119_4084# a_1575_6072# 0.02699f
C49 a_215_4084# bg_pnp_c_0.e2 0.02774f
C50 a_895_6072# a_1575_6072# 0.13337f
C51 a_4839_4084# a_4567_6072# 0.02699f
C52 a_4703_6072# a_5111_6072# 0.3154f
C53 en_3v3_b bg_n4_0.vpc 0.32276f
C54 a_1167_4084# a_1303_4084# 0.50008f
C55 a_2935_3998# a_3615_3998# 0.11607f
C56 a_759_6072# vdd 0.01763f
C57 a_4295_3998# a_4295_4084# 0.02699f
C58 a_1575_4084# a_1439_4084# 0.50008f
C59 en_3v3_b bg_n4_0.ks 1.2426f
C60 a_3207_4084# a_3071_4084# 0.50008f
C61 a_1303_4084# a_1439_4084# 0.50008f
C62 vdd bg_n4_0.vpc 18.6927f
C63 vdd bg_n4_0.ks 0.2122f
C64 a_2391_3998# a_2119_3998# 0.20448f
C65 a_3343_4084# a_3479_4084# 0.50008f
C66 a_4567_6072# a_4567_4084# 0.02699f
C67 a_3207_4084# a_2799_6072# 0.02719f
C68 a_918_8440# bg_n4_0.g 2.23424f
C69 a_3615_4084# a_3615_3998# 0.02746f
C70 a_3479_6072# a_3479_4084# 0.02699f
C71 a_1303_6072# a_623_6072# 0.11607f
C72 bg_n4_0.ea bg_n4_0.g 4.64889f
C73 a_1303_6072# a_1847_6072# 0.11607f
C74 vdd a_918_6928# 5.31037f
C75 a_5111_4084# a_4975_4084# 0.50008f
C76 a_2935_4084# a_2935_3998# 0.02746f
C77 a_2935_3998# a_2391_3998# 0.10146f
C78 a_3751_4084# a_3751_6072# 0.02746f
C79 a_4839_4084# a_4975_4084# 0.50008f
C80 a_351_3998# a_351_4084# 0.02699f
C81 a_759_6072# a_1031_4084# 0.02699f
C82 a_1711_4084# a_1575_4084# 0.50008f
C83 a_895_6072# vdd 0.13438f
C84 a_4703_6072# a_4703_4084# 0.02699f
C85 a_623_6072# a_215_6072# 0.10146f
C86 a_4431_6072# a_4431_4084# 0.02746f
C87 bg_n4_0.vpc bg_n4_0.g 29.4909f
C88 bg_pmir_pcas_c_0.vpg a_918_8440# 25.1257f
C89 a_1303_6072# a_1575_6072# 0.3002f
C90 bg_n4_0.ks bg_n4_0.g 0.54986f
C91 a_4159_3998# bg_n4_0.eb 0.01822f
C92 a_2255_4084# a_2255_3998# 0.02699f
C93 a_1031_3998# a_1031_4084# 0.02746f
C94 vdd en_3v3 3.46729f
C95 a_623_4084# a_623_6072# 0.02746f
C96 bg_n4_0.ks a_8390_5412# 0.01481f
C97 bg_n4_0.g a_918_6928# 7.73994f
C98 a_1167_4084# a_623_6072# 0.02746f
C99 a_4023_3998# a_3615_3998# 0.11607f
C100 vdd a_2663_6072# 0.01931f
C101 a_1167_3998# a_1167_4084# 0.02699f
C102 bg_pmir_pcas_c_0.vpg bg_n4_0.vpc 3.38914f
C103 bg_n4_0.ea a_5519_4084# 0.05915f
C104 a_759_6072# a_759_4084# 0.02699f
C105 a_5519_4084# a_5383_4084# 0.50008f
C106 a_1983_4084# a_1847_4084# 0.50008f
C107 a_2663_6072# a_2527_6072# 0.55081f
C108 a_4023_4084# a_3479_6072# 0.02699f
C109 a_1167_3998# a_1575_4084# 0.02699f
C110 a_4159_4084# a_4159_3998# 0.02699f
C111 bg_pmir_pcas_c_0.vpg a_918_6928# 29.2007f
C112 a_2935_4084# a_2663_6072# 0.02699f
C113 en_3v3 bg_n4_0.g 0.01132f
C114 a_3615_3998# a_3887_4084# 0.02746f
C115 a_1303_6072# vdd 0.01f
C116 a_1031_3998# a_1439_3998# 0.11607f
C117 a_5111_6072# a_5383_4084# 0.02746f
C118 a_5519_4084# bg_n4_0.ks 0.03313f
C119 a_215_4084# a_215_6072# 0.02699f
C120 bg_n4_0.ea a_5383_4084# 0.0621f
C121 en_3v3_b a_5822_6162# 0.097f
C122 bg_n4_0.ea bg_pnp_c_0.e2 0.19213f
C123 en_3v3_b a_5822_5862# 0.07524f
C124 a_1575_4084# a_1575_6072# 0.02699f
C125 a_3343_4084# a_3071_3998# 0.02699f
C126 a_918_8440# bg_n4_0.vpc 1.19739f
C127 a_2663_6072# a_2799_6072# 0.41558f
C128 a_1711_3998# a_1439_3998# 0.40167f
C129 bg_n4_0.ea bg_n4_0.vpc 1.30134f
C130 vdd a_5822_6162# 0.02761f
C131 a_4159_4084# a_4295_4084# 0.50008f
C132 a_1711_4084# a_1847_4084# 0.50008f
C133 a_487_4084# a_215_6072# 0.02728f
C134 bg_pmir_pcas_c_0.vpg en_3v3 0.54287f
C135 a_3887_6072# a_3887_4084# 0.02699f
C136 vdd a_5822_5862# 0.0278f
C137 a_2391_3998# a_3071_3998# 0.01297f
C138 bg_n4_0.eb a_4975_4084# 0.02699f
C139 bg_n4_0.ea bg_n4_0.ks 2.12138f
C140 a_2527_4084# a_2663_4084# 0.50008f
C141 a_2935_3998# a_3479_4084# 0.02746f
C142 a_3071_3998# a_3071_4084# 0.02699f
C143 a_918_8440# a_918_6928# 3.9161f
C144 a_4839_3998# bg_n4_0.ea 0.1073f
C145 a_623_4084# a_487_4084# 0.50008f
C146 a_2119_3998# a_2119_4084# 0.02746f
C147 bg_n4_0.ks bg_n4_0.vpc 0.26637f
C148 a_5822_5862# a_5822_5562# 0.01385f
C149 a_2799_4084# a_2663_4084# 0.50008f
C150 a_895_6072# a_759_6072# 0.41057f
C151 a_1711_3998# a_2119_3998# 0.10146f
C152 a_5111_4084# a_5111_6072# 0.02746f
C153 a_3479_4084# a_3615_4084# 0.50008f
C154 bg_n4_0.vpc a_918_6928# 2.51187f
C155 a_2255_3998# a_2527_4084# 0.02699f
C156 a_5111_4084# bg_n4_0.ea 0.01551f
C157 a_3615_3998# a_3207_3998# 0.3154f
C158 en_3v3_b a_5822_5262# 0.0746f
C159 en_3v3 a_918_8440# 1.24878f
C160 a_1847_4084# a_1847_6072# 0.02746f
C161 a_1167_4084# a_1031_4084# 0.50008f
C162 a_351_3998# bg_pnp_c_0.e2 0.14138f
C163 vdd a_5822_5262# 0.02761f
C164 a_3751_6072# a_4159_4084# 0.02746f
C165 a_2255_3998# a_2391_3998# 0.41558f
C166 bg_n4_0.eb bg_n4_0.g 7.48165f
C167 a_487_4084# a_487_3998# 0.02699f
C168 a_3751_4084# a_3615_4084# 0.50008f
C169 a_1847_6072# a_1575_6072# 0.28195f
C170 vdd iout 1.88431f
C171 a_2391_3998# a_3207_3998# 0.01125f
C172 a_4839_3998# a_5111_4084# 0.02746f
C173 a_4839_3998# a_4839_4084# 0.02746f
C174 a_1031_3998# a_351_3998# 0.10146f
C175 a_5822_5562# a_5822_5262# 0.01385f
C176 a_4703_4084# a_4839_4084# 0.50008f
C177 en_3v3 a_918_6928# 0.01225f
C178 en_3v3_b a_8390_6012# 0.06778f
C179 a_623_4084# a_759_4084# 0.50008f
C180 a_1439_4084# a_1439_3998# 0.02746f
C181 a_2935_3998# a_3071_3998# 0.55081f
C182 a_5247_4084# a_4703_6072# 0.02699f
C183 vdd a_8390_6012# 0.04353f
C184 a_8390_5712# a_8390_6012# 0.01385f
C185 a_759_6072# a_215_6072# 0.01822f
C186 iout bg_n4_0.g 5.8717f
C187 a_4431_6072# a_4567_6072# 0.55081f
C188 a_3343_6072# a_3751_6072# 0.11607f
C189 a_4703_4084# a_4567_4084# 0.50008f
C190 vdd a_1847_6072# 0.01537f
C191 a_2119_3998# a_2663_4084# 0.02746f
C192 a_1983_4084# a_1983_6072# 0.02699f
C193 a_895_4084# a_1031_4084# 0.50008f
C194 a_3343_6072# vdd 0.01537f
C195 vdd a_4567_6072# 0.01965f
C196 a_4023_3998# a_4431_4084# 0.02746f
C197 a_4703_6072# a_4567_6072# 0.41057f
C198 a_895_6072# a_1303_6072# 0.21541f
C199 a_1847_6072# a_2527_6072# 0.11607f
C200 a_4567_4084# a_4431_4084# 0.50008f
C201 a_3343_6072# a_3343_4084# 0.02746f
C202 a_3343_6072# a_3479_6072# 0.40019f
C203 a_4023_3998# a_4295_3998# 0.28009f
C204 a_79_4084# a_215_4084# 0.50008f
C205 a_487_3998# a_759_4084# 0.02699f
C206 vdd a_1575_6072# 0.04964f
C207 bg_pmir_pcas_c_0.vpg iout 0.13849f
C208 bg_n4_0.ea bg_n4_0.eb 0.59879f
C209 a_3887_6072# a_4295_4084# 0.02719f
C210 a_3207_4084# a_3207_3998# 0.02699f
C211 bg_n4_0.eb a_5383_4084# 0.0202f
C212 a_3751_4084# a_3887_4084# 0.50008f
C213 a_4295_3998# a_4567_4084# 0.02699f
C214 a_2255_3998# a_2119_3998# 0.55081f
C215 a_4567_6072# a_3887_6072# 0.01297f
C216 a_4023_4084# a_4023_3998# 0.02746f
C217 a_215_4084# a_351_4084# 0.50008f
C218 a_4431_6072# a_4975_4084# 0.02746f
C219 a_2255_4084# a_2391_4084# 0.50008f
C220 bg_n4_0.eb bg_n4_0.vpc 0.25735f
C221 a_895_4084# a_759_4084# 0.50008f
C222 en_3v3_b vdd 9.41678f
C223 a_487_4084# a_351_4084# 0.50008f
C224 en_3v3_b a_8390_5712# 0.06784f
C225 a_3343_6072# a_2799_6072# 0.10146f
C226 a_2935_3998# a_3207_3998# 0.10301f
C227 a_4431_6072# vdd 0.01537f
C228 a_4839_3998# bg_n4_0.eb 0.4008f
C229 a_487_3998# bg_pnp_c_0.e2 0.0224f
C230 a_4023_4084# a_3887_4084# 0.50008f
C231 a_1983_4084# a_2119_4084# 0.50008f
C232 a_2255_4084# a_1983_6072# 0.02699f
C233 a_4431_6072# a_4703_6072# 0.10301f
C234 a_918_8440# iout 0.14304f
C235 a_1031_3998# a_1303_4084# 0.02746f
C236 a_895_6072# a_1439_4084# 0.02699f
C237 vdd a_8390_5712# 0.02831f
C238 a_2391_4084# a_1847_6072# 0.02746f
C239 a_1711_3998# a_1983_4084# 0.02728f
C240 a_1167_3998# a_1439_3998# 0.3002f
C241 vdd a_4703_6072# 0.13551f
C242 a_3751_6072# a_3479_6072# 0.38193f
C243 en_3v3_b a_5822_5562# 0.07478f
C244 a_5822_5262# bg_n4_0.ks 0.02294f
C245 a_4431_6072# a_3887_6072# 0.10146f
C246 a_1847_4084# a_1439_3998# 0.02746f
C247 a_2663_6072# a_2663_4084# 0.02699f
C248 a_3751_6072# a_3887_6072# 0.30446f
C249 a_3479_6072# vdd 0.04964f
C250 a_2255_3998# a_1711_3998# 0.01822f
C251 vdd a_2527_6072# 0.01537f
C252 en_3v3_b bg_n4_0.g 0.20392f
C253 iout bg_n4_0.vpc 29.3875f
C254 a_2527_4084# a_2527_6072# 0.02746f
C255 vdd a_3887_6072# 0.10596f
C256 vdd a_5822_5562# 0.0278f
C257 a_3751_4084# a_3207_3998# 0.02699f
C258 a_5247_4084# bg_n4_0.ea 0.07032f
C259 a_5247_4084# a_5383_4084# 0.50008f
C260 a_1847_6072# a_1983_6072# 0.37789f
C261 a_4703_6072# a_3887_6072# 0.01125f
C262 en_3v3_b a_8390_5412# 0.06806f
C263 iout vss 1.96456f
C264 vdd vss 2.66306f
C265 a_5822_5262# vss 0.03034f
C266 a_8390_5412# vss 0.04077f
C267 a_5822_5562# vss 0.03034f
C268 a_8390_5712# vss 0.04077f
C269 a_5822_5862# vss 0.032f
C270 bg_n4_0.ea vss 6.62902f
C271 a_5111_6072# vss 0.92758f
C272 bg_n4_0.eb vss 3.91026f
C273 a_4839_3998# vss 0.84702f
C274 a_4703_6072# vss 1.00652f
C275 a_4567_6072# vss 0.82686f
C276 a_4431_6072# vss 0.8594f
C277 a_4295_3998# vss 0.91898f
C278 a_4159_3998# vss 0.9081f
C279 a_4023_3998# vss 0.8392f
C280 a_3887_6072# vss 0.95207f
C281 a_3751_6072# vss 0.81569f
C282 a_3615_3998# vss 0.82038f
C283 a_3479_6072# vss 0.87487f
C284 a_3343_6072# vss 0.80338f
C285 a_3207_3998# vss 1.17064f
C286 a_3071_3998# vss 0.82666f
C287 a_2935_3998# vss 0.85563f
C288 a_2799_6072# vss 0.95046f
C289 a_2663_6072# vss 0.81466f
C290 a_2527_6072# vss 0.84696f
C291 a_2391_3998# vss 1.1028f
C292 a_2255_3998# vss 0.81941f
C293 a_2119_3998# vss 0.85838f
C294 a_1983_6072# vss 0.89868f
C295 a_1847_6072# vss 0.84366f
C296 a_1711_3998# vss 0.87186f
C297 a_1575_6072# vss 0.86998f
C298 a_1439_3998# vss 0.82295f
C299 a_1303_6072# vss 0.82285f
C300 a_1167_3998# vss 0.90599f
C301 a_1031_3998# vss 0.82728f
C302 a_895_6072# vss 0.98573f
C303 a_759_6072# vss 0.82312f
C304 a_623_6072# vss 0.88046f
C305 a_487_3998# vss 1.29416f
C306 a_351_3998# vss 1.22013f
C307 bg_pnp_c_0.e2 vss 9.91156f
C308 a_215_6072# vss 1.42159f
C309 a_8390_6012# vss 0.04077f
C310 a_5822_6162# vss 0.03927f
C311 a_918_8440# vss 1.60278f
C312 a_918_6928# vss 1.80838f
Rtie0 a_1031_4084# vss 1e12
Rtie1 a_1167_4084# vss 1e12
Rtie2 a_1303_4084# vss 1e12
Rtie3 a_1439_4084# vss 1e12
Rtie4 a_1575_4084# vss 1e12
Rtie5 a_1711_4084# vss 1e12
Rtie6 a_1847_4084# vss 1e12
Rtie7 a_1983_4084# vss 1e12
Rtie8 a_2119_4084# vss 1e12
Rtie9 a_215_4084# vss 1e12
Rtie10 a_2255_4084# vss 1e12
Rtie11 a_2391_4084# vss 1e12
Rtie12 a_2527_4084# vss 1e12
Rtie13 a_2663_4084# vss 1e12
Rtie14 a_2799_4084# vss 1e12
Rtie15 a_2935_4084# vss 1e12
Rtie16 a_3071_4084# vss 1e12
Rtie17 a_3207_4084# vss 1e12
Rtie18 a_3343_4084# vss 1e12
Rtie19 a_3479_4084# vss 1e12
Rtie20 a_351_4084# vss 1e12
Rtie21 a_3615_4084# vss 1e12
Rtie22 a_3751_4084# vss 1e12
Rtie23 a_3887_4084# vss 1e12
Rtie24 a_4023_4084# vss 1e12
Rtie25 a_4159_4084# vss 1e12
Rtie26 a_4295_4084# vss 1e12
Rtie27 a_4431_4084# vss 1e12
Rtie28 a_4567_4084# vss 1e12
Rtie29 a_4703_4084# vss 1e12
Rtie30 a_4839_4084# vss 1e12
Rtie31 a_487_4084# vss 1e12
Rtie32 a_4975_4084# vss 1e12
Rtie33 a_5111_4084# vss 1e12
Rtie34 a_5247_4084# vss 1e12
Rtie35 a_5383_4084# vss 1e12
Rtie36 a_5519_4084# vss 1e12
Rtie37 a_623_4084# vss 1e12
Rtie38 a_759_4084# vss 1e12
Rtie39 a_79_4084# vss 1e12
Rtie40 a_895_4084# vss 1e12
.ends
