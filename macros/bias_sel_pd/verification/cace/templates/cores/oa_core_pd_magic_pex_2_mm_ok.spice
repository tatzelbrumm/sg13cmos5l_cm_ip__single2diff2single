* generated by scripts/cace/pex_for_sim.py from ../oa_core_pd/netlist/pex/oa_core_pd_magic_pex_2.spice: mm_ok=1 on 111 devices; 0 capacitor-only nodes tied to vss through 1e12 Ohm
* PEX produced on Fri Oct 30 17:23:07 UTC 2026 using /usr/local/bin/sak-pex.sh with m=2 and s=1
* NGSPICE file created from oa_core_pd_pex.ext - technology: ihp-sg13cmos5l

.subckt oa_core_pd_pex vdd vss iout en_3v3 en_3v3_b
X0 vss oa_n10_0.vnc vss vss sg13_hv_nmos ad=0.68p pd=4.68u as=0.13424n ps=0.53061m w=2u l=1u mm_ok=1
X1 oa_pcas_c_0.co oa_n10_0.vpc iout vdd sg13_hv_pmos ad=0.68p pd=4.68u as=0.68p ps=4.68u w=2u l=2u mm_ok=1
X2 oa_pcas_c_0.c2 oa_svpg_0.vpg vdd vdd sg13_hv_pmos ad=0.68p pd=4.68u as=0.68p ps=4.68u w=2u l=8u mm_ok=1
X3 vdd oa_svpg_0.vpg oa_pcas_c_0.co vdd sg13_hv_pmos ad=0.68p pd=4.68u as=0.68p ps=4.68u w=2u l=8u mm_ok=1
X4 oa_pcas_c_0.co oa_svpg_0.vpg vdd vdd sg13_hv_pmos ad=0.68p pd=4.68u as=0.68p ps=4.68u w=2u l=8u mm_ok=1
X5 oa_n10_0.vpc oa_n10_0.ks vss vss sg13_hv_nmos ad=0.17p pd=1.68u as=0.17p ps=1.68u w=0.5u l=2u mm_ok=1
X6 a_724_2272# oa_n10_0.vnc oa_mcs_c_0.vres vss sg13_hv_nmos ad=3.4p pd=20.68u as=3.4p ps=20.68u w=10u l=1u mm_ok=1
X7 oa_pcas_c_0.co oa_n10_0.vpc iout vdd sg13_hv_pmos ad=0.68p pd=4.68u as=0.68p ps=4.68u w=2u l=2u mm_ok=1
X8 oa_svpg_0.vpg oa_svpg_0.vpg vdd vdd sg13_hv_pmos ad=0.68p pd=4.68u as=0.68p ps=4.68u w=2u l=8u mm_ok=1
X9 a_724_2272# oa_n10_0.vnc oa_mcs_c_0.vres vss sg13_hv_nmos ad=3.4p pd=20.68u as=3.4p ps=20.68u w=10u l=1u mm_ok=1
X10 oa_pcas_c_0.co oa_svpg_0.vpg vdd vdd sg13_hv_pmos ad=0.68p pd=4.68u as=0.68p ps=4.68u w=2u l=8u mm_ok=1
X11 oa_n10_0.ks oa_mcs_c_0.vbr vss vss sg13_hv_nmos ad=3.4p pd=20.68u as=3.4p ps=20.68u w=10u l=1u mm_ok=1
X12 vdd oa_svpg_0.vpg vdd vdd sg13_hv_pmos ad=0.102p pd=1.28u as=0.13884n ps=0.38488m w=0.3u l=8u mm_ok=1
X13 vdd oa_svpg_0.vpg oa_pcas_c_0.co vdd sg13_hv_pmos ad=0.68p pd=4.68u as=0.68p ps=4.68u w=2u l=8u mm_ok=1
X14 vdd oa_svpg_0.vpg vdd vdd sg13_hv_pmos ad=0.102p pd=1.28u as=0 ps=0 w=0.3u l=8u mm_ok=1
X15 oa_mcs_c_0.vbr oa_mcs_c_0.vbr vss vss sg13_hv_nmos ad=1.156p pd=7.48u as=1.156p ps=7.48u w=3.4u l=30u mm_ok=1
X16 oa_pcas_c_0.co oa_n10_0.vpc iout vdd sg13_hv_pmos ad=0.68p pd=4.68u as=0.68p ps=4.68u w=2u l=2u mm_ok=1
X17 vdd oa_svpg_0.vpg vdd vdd sg13_hv_pmos ad=0.102p pd=1.28u as=0 ps=0 w=0.3u l=8u mm_ok=1
X18 oa_n10_0.vpc oa_mcs_c_0.vbr a_724_2272# vss sg13_hv_nmos ad=3.4p pd=20.68u as=3.4p ps=20.68u w=10u l=1u mm_ok=1
X19 vss oa_n10_0.vnc vss vss sg13_hv_nmos ad=0.68p pd=4.68u as=0 ps=0 w=2u l=1u mm_ok=1
X20 vss oa_n10_0.vnc vss vss sg13_hv_nmos ad=0.68p pd=4.68u as=0 ps=0 w=2u l=1u mm_ok=1
X21 vss oa_n10_0.vnc vss vss sg13_hv_nmos ad=0.68p pd=4.68u as=0 ps=0 w=2u l=1u mm_ok=1
X22 vss oa_mcs_c_0.vbr vss vss sg13_hv_nmos ad=0.68p pd=4.68u as=0 ps=0 w=2u l=1u mm_ok=1
X23 oa_pcas_c_0.co oa_n10_0.vpc iout vdd sg13_hv_pmos ad=0.68p pd=4.68u as=0.68p ps=4.68u w=2u l=2u mm_ok=1
X24 oa_pcas_c_0.c8 oa_svpg_0.vpg vdd vdd sg13_hv_pmos ad=0.68p pd=4.68u as=0.68p ps=4.68u w=2u l=8u mm_ok=1
X25 vdd oa_svpg_0.vpg oa_pcas_c_0.co vdd sg13_hv_pmos ad=0.68p pd=4.68u as=0.68p ps=4.68u w=2u l=8u mm_ok=1
X26 vss oa_n10_0.vnc vss vss sg13_hv_nmos ad=0.68p pd=4.68u as=0 ps=0 w=2u l=1u mm_ok=1
X27 vdd oa_svpg_0.vpg vdd vdd sg13_hv_pmos ad=0.102p pd=1.28u as=0 ps=0 w=0.3u l=8u mm_ok=1
X28 vdd oa_svpg_0.vpg oa_pcas_c_0.co vdd sg13_hv_pmos ad=0.68p pd=4.68u as=0.68p ps=4.68u w=2u l=8u mm_ok=1
X29 vss oa_n10_0.vnc vss vss sg13_hv_nmos ad=0.68p pd=4.68u as=0 ps=0 w=2u l=1u mm_ok=1
X30 a_724_2272# oa_n10_0.vnc oa_mcs_c_0.vres vss sg13_hv_nmos ad=3.4p pd=20.68u as=3.4p ps=20.68u w=10u l=1u mm_ok=1
X31 oa_pcas_c_0.co oa_svpg_0.vpg vdd vdd sg13_hv_pmos ad=0.68p pd=4.68u as=0.68p ps=4.68u w=2u l=8u mm_ok=1
X32 oa_pcas_c_0.co oa_svpg_0.vpg vdd vdd sg13_hv_pmos ad=0.68p pd=4.68u as=0.68p ps=4.68u w=2u l=8u mm_ok=1
X33 a_724_2272# oa_n10_0.vnc oa_mcs_c_0.vres vss sg13_hv_nmos ad=3.4p pd=20.68u as=3.4p ps=20.68u w=10u l=1u mm_ok=1
X34 vss oa_n10_0.vnc vss vss sg13_hv_nmos ad=0.68p pd=4.68u as=0 ps=0 w=2u l=1u mm_ok=1
X35 a_724_2272# oa_n10_0.vnc oa_mcs_c_0.vres vss sg13_hv_nmos ad=3.4p pd=20.68u as=3.4p ps=20.68u w=10u l=1u mm_ok=1
X36 oa_pcas_c_0.co oa_n10_0.vpc iout vdd sg13_hv_pmos ad=0.68p pd=4.68u as=0.68p ps=4.68u w=2u l=2u mm_ok=1
X37 vdd oa_svpg_0.vpg oa_pcas_c_0.c8 vdd sg13_hv_pmos ad=0.68p pd=4.68u as=0.68p ps=4.68u w=2u l=8u mm_ok=1
X38 vss oa_n10_0.vnc vss vss sg13_hv_nmos ad=0.68p pd=4.68u as=0 ps=0 w=2u l=1u mm_ok=1
X39 vdd oa_svpg_0.vpg oa_pcas_c_0.co vdd sg13_hv_pmos ad=0.68p pd=4.68u as=0.68p ps=4.68u w=2u l=8u mm_ok=1
X40 vss oa_n10_0.vnc vss vss sg13_hv_nmos ad=0.68p pd=4.68u as=0 ps=0 w=2u l=1u mm_ok=1
X41 a_724_2272# oa_n10_0.vnc oa_mcs_c_0.vres vss sg13_hv_nmos ad=3.4p pd=20.68u as=3.4p ps=20.68u w=10u l=1u mm_ok=1
X42 oa_n10_0.vnc oa_n10_0.vnc vss vss sg13_hv_nmos ad=3.4p pd=20.68u as=3.4p ps=20.68u w=10u l=1u mm_ok=1
X43 oa_pcas_c_0.co oa_svpg_0.vpg vdd vdd sg13_hv_pmos ad=0.68p pd=4.68u as=0.68p ps=4.68u w=2u l=8u mm_ok=1
X44 a_724_2272# oa_n10_0.vnc oa_mcs_c_0.vres vss sg13_hv_nmos ad=3.4p pd=20.68u as=3.4p ps=20.68u w=10u l=1u mm_ok=1
X45 oa_n10_0.vnc oa_n10_0.vnc vss vss sg13_hv_nmos ad=3.4p pd=20.68u as=3.4p ps=20.68u w=10u l=1u mm_ok=1
X46 vdd oa_svpg_0.vpg vdd vdd sg13_hv_pmos ad=0.102p pd=1.28u as=0 ps=0 w=0.3u l=8u mm_ok=1
X47 oa_n10_0.vnc oa_n10_0.vnc vss vss sg13_hv_nmos ad=3.4p pd=20.68u as=3.4p ps=20.68u w=10u l=1u mm_ok=1
X48 a_724_2272# oa_n10_0.vnc oa_mcs_c_0.vres vss sg13_hv_nmos ad=3.4p pd=20.68u as=3.4p ps=20.68u w=10u l=1u mm_ok=1
X49 oa_n10_0.vnc oa_n10_0.vnc vss vss sg13_hv_nmos ad=3.4p pd=20.68u as=3.4p ps=20.68u w=10u l=1u mm_ok=1
X50 vdd oa_svpg_0.vpg oa_pcas_c_0.c8 vdd sg13_hv_pmos ad=0.68p pd=4.68u as=0.68p ps=4.68u w=2u l=8u mm_ok=1
X51 oa_pcas_c_0.co oa_svpg_0.vpg vdd vdd sg13_hv_pmos ad=0.68p pd=4.68u as=0.68p ps=4.68u w=2u l=8u mm_ok=1
X52 oa_n10_0.vnc oa_n10_0.vnc vss vss sg13_hv_nmos ad=3.4p pd=20.68u as=3.4p ps=20.68u w=10u l=1u mm_ok=1
X53 a_7002_5993# en_3v3_b a_4434_6143# vdd sg13_hv_pmos ad=0.17p pd=1.68u as=0.17p ps=1.68u w=0.5u l=12.5u mm_ok=1
X54 vss oa_n10_0.vnc vss vss sg13_hv_nmos ad=0.68p pd=4.68u as=0 ps=0 w=2u l=1u mm_ok=1
X55 oa_pcas_c_0.co oa_svpg_0.vpg vdd vdd sg13_hv_pmos ad=0.68p pd=4.68u as=0.68p ps=4.68u w=2u l=8u mm_ok=1
X56 vdd oa_svpg_0.vpg oa_pcas_c_0.co vdd sg13_hv_pmos ad=0.68p pd=4.68u as=0.68p ps=4.68u w=2u l=8u mm_ok=1
X57 oa_n10_0.vnc oa_n10_0.vnc vss vss sg13_hv_nmos ad=3.4p pd=20.68u as=3.4p ps=20.68u w=10u l=1u mm_ok=1
X58 a_7002_5993# en_3v3_b vdd vdd sg13_hv_pmos ad=0.17p pd=1.68u as=0.17p ps=1.68u w=0.5u l=12.5u mm_ok=1
X59 oa_n10_0.vnc oa_n10_0.vnc vss vss sg13_hv_nmos ad=3.4p pd=20.68u as=3.4p ps=20.68u w=10u l=1u mm_ok=1
X60 a_7002_6293# en_3v3_b a_4434_6443# vdd sg13_hv_pmos ad=0.17p pd=1.68u as=0.17p ps=1.68u w=0.5u l=12.5u mm_ok=1
X61 oa_n10_0.vnc oa_n10_0.vnc vss vss sg13_hv_nmos ad=3.4p pd=20.68u as=3.4p ps=20.68u w=10u l=1u mm_ok=1
X62 a_724_2272# oa_n10_0.vnc oa_mcs_c_0.vres vss sg13_hv_nmos ad=3.4p pd=20.68u as=3.4p ps=20.68u w=10u l=1u mm_ok=1
X63 vdd oa_svpg_0.vpg vdd vdd sg13_hv_pmos ad=0.68p pd=4.68u as=0 ps=0 w=2u l=8u mm_ok=1
X64 vss oa_n10_0.vnc vss vss sg13_hv_nmos ad=0.68p pd=4.68u as=0 ps=0 w=2u l=1u mm_ok=1
X65 oa_n10_0.vnc oa_n10_0.vnc vss vss sg13_hv_nmos ad=3.4p pd=20.68u as=3.4p ps=20.68u w=10u l=1u mm_ok=1
X66 vdd oa_svpg_0.vpg oa_pcas_c_0.co vdd sg13_hv_pmos ad=0.68p pd=4.68u as=0.68p ps=4.68u w=2u l=8u mm_ok=1
X67 oa_mcs_c_0.vres oa_mcs_c_0.vbr vss vss sg13_hv_nmos ad=1.156p pd=7.48u as=1.156p ps=7.48u w=3.4u l=30u mm_ok=1
X68 oa_pcas_c_0.c8 oa_n10_0.vpc oa_n10_0.vnc vdd sg13_hv_pmos ad=0.68p pd=4.68u as=0.68p ps=4.68u w=2u l=2u mm_ok=1
X69 vss oa_n10_0.vnc vss vss sg13_hv_nmos ad=0.68p pd=4.68u as=0 ps=0 w=2u l=1u mm_ok=1
X70 a_724_2272# oa_n10_0.vnc oa_mcs_c_0.vres vss sg13_hv_nmos ad=3.4p pd=20.68u as=3.4p ps=20.68u w=10u l=1u mm_ok=1
X71 a_7002_6593# en_3v3_b a_4434_6743# vdd sg13_hv_pmos ad=0.17p pd=1.68u as=0.17p ps=1.68u w=0.5u l=12.5u mm_ok=1
X72 vdd oa_svpg_0.vpg oa_pcas_c_0.c2 vdd sg13_hv_pmos ad=0.68p pd=4.68u as=0.68p ps=4.68u w=2u l=8u mm_ok=1
X73 a_7002_6293# en_3v3_b a_4434_6143# vdd sg13_hv_pmos ad=0.17p pd=1.68u as=0.17p ps=1.68u w=0.5u l=12.5u mm_ok=1
X74 a_724_2272# oa_n10_0.vnc oa_mcs_c_0.vres vss sg13_hv_nmos ad=3.4p pd=20.68u as=3.4p ps=20.68u w=10u l=1u mm_ok=1
X75 oa_n10_0.ks en_3v3_b vss vss sg13_hv_nmos ad=0.34p pd=2.68u as=0.34p ps=2.68u w=1u l=0.45u mm_ok=1
X76 vdd oa_svpg_0.vpg vdd vdd sg13_hv_pmos ad=0.102p pd=1.28u as=0 ps=0 w=0.3u l=8u mm_ok=1
X77 oa_pcas_c_0.co oa_svpg_0.vpg vdd vdd sg13_hv_pmos ad=0.68p pd=4.68u as=0.68p ps=4.68u w=2u l=8u mm_ok=1
X78 a_7002_6593# en_3v3_b a_4434_6443# vdd sg13_hv_pmos ad=0.17p pd=1.68u as=0.17p ps=1.68u w=0.5u l=12.5u mm_ok=1
X79 oa_pcas_c_0.co oa_svpg_0.vpg vdd vdd sg13_hv_pmos ad=0.68p pd=4.68u as=0.68p ps=4.68u w=2u l=8u mm_ok=1
X80 vdd oa_svpg_0.vpg oa_pcas_c_0.co vdd sg13_hv_pmos ad=0.68p pd=4.68u as=0.68p ps=4.68u w=2u l=8u mm_ok=1
X81 a_724_2272# oa_n10_0.vnc oa_mcs_c_0.vres vss sg13_hv_nmos ad=3.4p pd=20.68u as=3.4p ps=20.68u w=10u l=1u mm_ok=1
X82 oa_pcas_c_0.co oa_svpg_0.vpg vdd vdd sg13_hv_pmos ad=0.68p pd=4.68u as=0.68p ps=4.68u w=2u l=8u mm_ok=1
X83 vss oa_n10_0.vnc vss vss sg13_hv_nmos ad=0.68p pd=4.68u as=0 ps=0 w=2u l=1u mm_ok=1
X84 a_7002_6893# en_3v3_b oa_n10_0.ks vdd sg13_hv_pmos ad=0.17p pd=1.68u as=0.17p ps=1.68u w=0.5u l=12.5u mm_ok=1
X85 vss oa_n10_0.vnc vss vss sg13_hv_nmos ad=0.68p pd=4.68u as=0 ps=0 w=2u l=1u mm_ok=1
X86 oa_pcas_c_0.c8 oa_svpg_0.vpg vdd vdd sg13_hv_pmos ad=0.68p pd=4.68u as=0.68p ps=4.68u w=2u l=8u mm_ok=1
X87 vdd oa_svpg_0.vpg oa_pcas_c_0.c8 vdd sg13_hv_pmos ad=0.68p pd=4.68u as=0.68p ps=4.68u w=2u l=8u mm_ok=1
X88 a_724_2272# oa_n10_0.vnc oa_mcs_c_0.vres vss sg13_hv_nmos ad=3.4p pd=20.68u as=3.4p ps=20.68u w=10u l=1u mm_ok=1
X89 vss oa_n10_0.vnc vss vss sg13_hv_nmos ad=0.68p pd=4.68u as=0 ps=0 w=2u l=1u mm_ok=1
X90 a_7002_6893# en_3v3_b a_4434_6743# vdd sg13_hv_pmos ad=0.17p pd=1.68u as=0.17p ps=1.68u w=0.5u l=12.5u mm_ok=1
X91 a_724_2272# oa_n10_0.vnc oa_mcs_c_0.vres vss sg13_hv_nmos ad=3.4p pd=20.68u as=3.4p ps=20.68u w=10u l=1u mm_ok=1
X92 oa_pcas_c_0.c8 oa_n10_0.vpc oa_n10_0.vnc vdd sg13_hv_pmos ad=0.68p pd=4.68u as=0.68p ps=4.68u w=2u l=2u mm_ok=1
X93 oa_pcas_c_0.c8 oa_svpg_0.vpg vdd vdd sg13_hv_pmos ad=0.68p pd=4.68u as=0.68p ps=4.68u w=2u l=8u mm_ok=1
X94 vdd oa_svpg_0.vpg oa_pcas_c_0.co vdd sg13_hv_pmos ad=0.68p pd=4.68u as=0.68p ps=4.68u w=2u l=8u mm_ok=1
X95 vss oa_n10_0.vnc vss vss sg13_hv_nmos ad=0.68p pd=4.68u as=0 ps=0 w=2u l=1u mm_ok=1
X96 a_724_2272# oa_n10_0.vnc oa_mcs_c_0.vres vss sg13_hv_nmos ad=3.4p pd=20.68u as=3.4p ps=20.68u w=10u l=1u mm_ok=1
X97 vss oa_mcs_c_0.vbr vss vss sg13_hv_nmos ad=0.68p pd=4.68u as=0 ps=0 w=2u l=1u mm_ok=1
X98 vdd oa_svpg_0.vpg vdd vdd sg13_hv_pmos ad=0.102p pd=1.28u as=0 ps=0 w=0.3u l=8u mm_ok=1
X99 vdd en_3v3 oa_svpg_0.vpg vdd sg13_hv_pmos ad=0.34p pd=2.68u as=0.34p ps=2.68u w=1u l=0.45u mm_ok=1
X100 vdd oa_svpg_0.vpg oa_pcas_c_0.c8 vdd sg13_hv_pmos ad=0.68p pd=4.68u as=0.68p ps=4.68u w=2u l=8u mm_ok=1
X101 vdd oa_svpg_0.vpg vdd vdd sg13_hv_pmos ad=0.102p pd=1.28u as=0 ps=0 w=0.3u l=8u mm_ok=1
X102 a_724_2272# oa_n10_0.vnc oa_mcs_c_0.vres vss sg13_hv_nmos ad=3.4p pd=20.68u as=3.4p ps=20.68u w=10u l=1u mm_ok=1
X103 a_724_2272# oa_n10_0.vnc oa_mcs_c_0.vres vss sg13_hv_nmos ad=3.4p pd=20.68u as=3.4p ps=20.68u w=10u l=1u mm_ok=1
X104 vss oa_n10_0.vnc vss vss sg13_hv_nmos ad=0.68p pd=4.68u as=0 ps=0 w=2u l=1u mm_ok=1
X105 vdd oa_svpg_0.vpg oa_pcas_c_0.co vdd sg13_hv_pmos ad=0.68p pd=4.68u as=0.68p ps=4.68u w=2u l=8u mm_ok=1
X106 oa_svpg_0.vpg oa_n10_0.vpc oa_n10_0.vpc vdd sg13_hv_pmos ad=0.17p pd=1.68u as=0.17p ps=1.68u w=0.5u l=2u mm_ok=1
X107 oa_pcas_c_0.c8 oa_svpg_0.vpg vdd vdd sg13_hv_pmos ad=0.68p pd=4.68u as=0.68p ps=4.68u w=2u l=8u mm_ok=1
X108 vss oa_n10_0.vnc vss vss sg13_hv_nmos ad=0.68p pd=4.68u as=0 ps=0 w=2u l=1u mm_ok=1
X109 a_724_2272# oa_n10_0.vnc oa_mcs_c_0.vres vss sg13_hv_nmos ad=3.4p pd=20.68u as=3.4p ps=20.68u w=10u l=1u mm_ok=1
X110 oa_pcas_c_0.c2 oa_n10_0.vpc oa_mcs_c_0.vbr vdd sg13_hv_pmos ad=0.34p pd=2.68u as=0.34p ps=2.68u w=1u l=2u mm_ok=1
C0 oa_n10_0.vpc vdd 4.40193f
C1 oa_n10_0.vpc en_3v3_b 0.25154f
C2 oa_n10_0.vnc a_7002_5993# 0.02184f
C3 a_4434_6143# iout 0.02926f
C4 a_7002_6593# a_7002_6893# 0.01385f
C5 oa_mcs_c_0.vbr a_724_2272# 0.43868f
C6 a_4434_6443# a_4434_6143# 0.01385f
C7 iout a_7002_6293# 0.03781f
C8 a_724_2272# oa_n10_0.ks 0.09645f
C9 oa_svpg_0.vpg a_7002_6893# 0.01391f
C10 oa_pcas_c_0.co iout 0.37673f
C11 oa_pcas_c_0.c8 iout 0.04318f
C12 oa_mcs_c_0.vbr iout 0.09979f
C13 en_3v3_b vdd 8.08073f
C14 iout oa_n10_0.ks 0.05455f
C15 a_4434_6443# oa_n10_0.ks 0.05634f
C16 oa_pcas_c_0.co oa_n10_0.vpc 0.67601f
C17 oa_pcas_c_0.c8 oa_n10_0.vpc 0.14406f
C18 a_7002_6893# en_3v3 0.0162f
C19 oa_mcs_c_0.vbr oa_n10_0.vpc 3.13174f
C20 oa_n10_0.vnc a_724_2272# 9.367f
C21 oa_n10_0.vpc oa_n10_0.ks 2.13117f
C22 oa_svpg_0.vpg iout 0.02944f
C23 oa_n10_0.vnc iout 4.41184f
C24 oa_mcs_c_0.vres oa_mcs_c_0.vbr 1.46031f
C25 oa_svpg_0.vpg oa_n10_0.vpc 0.06591f
C26 iout en_3v3 0.0625f
C27 a_4434_6143# vdd 0.03829f
C28 oa_n10_0.vnc oa_n10_0.vpc 0.27426f
C29 a_4434_6143# en_3v3_b 0.02989f
C30 a_4434_6443# a_4434_6743# 0.01385f
C31 vdd a_7002_6293# 0.02334f
C32 en_3v3_b a_7002_6293# 0.04511f
C33 oa_pcas_c_0.co vdd 5.61286f
C34 oa_pcas_c_0.c8 vdd 2.2607f
C35 oa_mcs_c_0.vbr vdd 0.53382f
C36 oa_pcas_c_0.co en_3v3_b 0.03362f
C37 vdd oa_n10_0.ks 0.40956f
C38 oa_pcas_c_0.c8 en_3v3_b 0.34029f
C39 oa_mcs_c_0.vbr en_3v3_b 1.17328f
C40 oa_mcs_c_0.vres oa_n10_0.vnc 26.6334f
C41 en_3v3_b oa_n10_0.ks 0.29422f
C42 a_7002_6593# vdd 0.02964f
C43 a_7002_6593# en_3v3_b 0.05295f
C44 oa_pcas_c_0.c2 oa_n10_0.vpc 0.03777f
C45 oa_svpg_0.vpg vdd 83.1487f
C46 oa_n10_0.vnc vdd 0.49458f
C47 oa_svpg_0.vpg en_3v3_b 0.34154f
C48 oa_n10_0.vnc en_3v3_b 0.61168f
C49 a_4434_6743# vdd 0.0303f
C50 vdd en_3v3 0.22312f
C51 a_4434_6143# oa_mcs_c_0.vbr 0.02219f
C52 a_4434_6743# en_3v3_b 0.05267f
C53 en_3v3_b en_3v3 0.03489f
C54 a_4434_6143# oa_n10_0.ks 0.05206f
C55 oa_pcas_c_0.c8 oa_pcas_c_0.co 10.9656f
C56 oa_pcas_c_0.c2 vdd 1.75044f
C57 oa_pcas_c_0.co oa_n10_0.ks 0.06724f
C58 oa_pcas_c_0.c8 oa_n10_0.ks 0.13124f
C59 oa_mcs_c_0.vbr oa_n10_0.ks 0.46712f
C60 a_7002_6593# a_7002_6293# 0.01385f
C61 oa_n10_0.vnc a_4434_6143# 0.02916f
C62 oa_svpg_0.vpg oa_pcas_c_0.co 4.70797f
C63 oa_svpg_0.vpg oa_pcas_c_0.c8 2.58548f
C64 oa_n10_0.vnc oa_pcas_c_0.c8 0.04328f
C65 oa_n10_0.vnc oa_mcs_c_0.vbr 4.3164f
C66 oa_n10_0.vnc oa_n10_0.ks 0.055f
C67 oa_n10_0.vpc a_724_2272# 0.4516f
C68 a_4434_6743# oa_pcas_c_0.co 0.01899f
C69 a_7002_5993# vdd 0.02714f
C70 a_4434_6743# oa_n10_0.ks 0.07134f
C71 oa_n10_0.vpc iout 0.90163f
C72 a_7002_5993# en_3v3_b 0.05585f
C73 oa_mcs_c_0.vres a_724_2272# 19.7416f
C74 oa_pcas_c_0.c2 oa_pcas_c_0.co 1.15185f
C75 oa_pcas_c_0.c8 oa_pcas_c_0.c2 8.61381f
C76 oa_pcas_c_0.c2 oa_mcs_c_0.vbr 0.01084f
C77 vdd a_7002_6893# 0.04225f
C78 oa_pcas_c_0.c2 oa_n10_0.ks 0.02865f
C79 en_3v3_b a_7002_6893# 0.05282f
C80 oa_svpg_0.vpg en_3v3 0.21614f
C81 en_3v3_b a_724_2272# 0.07181f
C82 oa_svpg_0.vpg oa_pcas_c_0.c2 8.0679f
C83 iout vdd 0.668f
C84 iout en_3v3_b 0.98519f
C85 a_7002_5993# a_7002_6293# 0.01385f
C86 a_4434_6443# vdd 0.03217f
C87 a_4434_6443# en_3v3_b 0.05267f
C88 a_7002_5993# oa_mcs_c_0.vbr 0.02588f
C89 iout vss 1.31141f
C90 vdd vss 0.6215f
C91 oa_mcs_c_0.vres vss 6.31088f
C92 a_724_2272# vss 23.8683f
C93 a_7002_5993# vss 0.69634f
C94 a_4434_6143# vss 0.65934f
C95 a_7002_6293# vss 0.03948f
C96 a_7002_6593# vss 0.03372f
C97 a_7002_6893# vss 0.01023f
C98 oa_n10_0.ks vss 16.4703f
C99 oa_pcas_c_0.c2 vss 1.08941f
C100 oa_pcas_c_0.c8 vss 0.15033f
C101 oa_pcas_c_0.co vss 1.54406f
.ends
