* PEX produced on Fri Oct 30 17:23:08 UTC 2026 using /usr/local/bin/sak-pex.sh with m=3 and s=1 (extresist threshold=10000 mOhm, minres=1000 mOhm, mindelay=1 ps)
* NGSPICE file created from oa_core_pd_pex.ext - technology: ihp-sg13cmos5l

.subckt oa_core_pd_pex vdd vss iout en_3v3 en_3v3_b
X0 vss.t4 oa_n10_0.vnc vss.t4 vss.t0 sg13_hv_nmos ad=0.68p pd=4.68u as=0 ps=0 w=2u l=1u
X1 oa_pcas_c_0.co oa_n10_0.vpc iout vdd sg13_hv_pmos ad=0.68p pd=4.68u as=0.68p ps=4.68u w=2u l=2u
X2 oa_pcas_c_0.c2 oa_svpg_0.vpg.t1 vdd vdd sg13_hv_pmos ad=0.68p pd=4.68u as=0.68p ps=4.68u w=2u l=8u
X3 vdd oa_svpg_0.vpg.t4 oa_pcas_c_0.co vdd sg13_hv_pmos ad=0.68p pd=4.68u as=0.68p ps=4.68u w=2u l=8u
X4 oa_pcas_c_0.co oa_svpg_0.vpg.t6 vdd vdd sg13_hv_pmos ad=0.68p pd=4.68u as=0.68p ps=4.68u w=2u l=8u
X5 oa_n10_0.vpc oa_n10_0.ks vss.t1 vss.t0 sg13_hv_nmos ad=0.17p pd=1.68u as=0.17p ps=1.68u w=0.5u l=2u
X6 a_724_2272# oa_n10_0.vnc oa_mcs_c_0.vres vss.t0 sg13_hv_nmos ad=3.4p pd=20.68u as=3.4p ps=20.68u w=10u l=1u
X7 oa_pcas_c_0.co oa_n10_0.vpc iout vdd sg13_hv_pmos ad=0.68p pd=4.68u as=0.68p ps=4.68u w=2u l=2u
X8 oa_svpg_0.vpg.t2 oa_svpg_0.vpg.t1 vdd vdd sg13_hv_pmos ad=0.68p pd=4.68u as=0.68p ps=4.68u w=2u l=8u
X9 a_724_2272# oa_n10_0.vnc oa_mcs_c_0.vres vss.t0 sg13_hv_nmos ad=3.4p pd=20.68u as=3.4p ps=20.68u w=10u l=1u
X10 oa_pcas_c_0.co oa_svpg_0.vpg.t6 vdd vdd sg13_hv_pmos ad=0.68p pd=4.68u as=0.68p ps=4.68u w=2u l=8u
X11 oa_n10_0.ks oa_mcs_c_0.vbr vss.t1 vss.t0 sg13_hv_nmos ad=3.4p pd=20.68u as=3.4p ps=20.68u w=10u l=1u
X12 vdd oa_svpg_0.vpg.t6 vdd vdd sg13_hv_pmos ad=0.102p pd=1.28u as=0.13884n ps=0.38488m w=0.3u l=8u
X13 vdd oa_svpg_0.vpg.t5 oa_pcas_c_0.co vdd sg13_hv_pmos ad=0.68p pd=4.68u as=0.68p ps=4.68u w=2u l=8u
X14 vdd oa_svpg_0.vpg.t6 vdd vdd sg13_hv_pmos ad=0.102p pd=1.28u as=0 ps=0 w=0.3u l=8u
X15 oa_mcs_c_0.vbr oa_mcs_c_0.vbr vss.t7 vss.t0 sg13_hv_nmos ad=1.156p pd=7.48u as=1.156p ps=7.48u w=3.4u l=30u
X16 oa_pcas_c_0.co oa_n10_0.vpc iout vdd sg13_hv_pmos ad=0.68p pd=4.68u as=0.68p ps=4.68u w=2u l=2u
X17 vdd oa_svpg_0.vpg.t1 vdd vdd sg13_hv_pmos ad=0.102p pd=1.28u as=0 ps=0 w=0.3u l=8u
X18 oa_n10_0.vpc oa_mcs_c_0.vbr a_724_2272# vss.t0 sg13_hv_nmos ad=3.4p pd=20.68u as=3.4p ps=20.68u w=10u l=1u
X19 vss.t17 oa_n10_0.vnc vss.t17 vss.t0 sg13_hv_nmos ad=0.68p pd=4.68u as=0 ps=0 w=2u l=1u
X20 vss.t4 oa_n10_0.vnc vss.t4 vss.t0 sg13_hv_nmos ad=0.68p pd=4.68u as=0 ps=0 w=2u l=1u
X21 vss.t4 oa_n10_0.vnc vss.t4 vss.t0 sg13_hv_nmos ad=0.68p pd=4.68u as=0 ps=0 w=2u l=1u
X22 vss.t1 oa_mcs_c_0.vbr vss.t1 vss.t0 sg13_hv_nmos ad=0.68p pd=4.68u as=0 ps=0 w=2u l=1u
X23 oa_pcas_c_0.co oa_n10_0.vpc iout vdd sg13_hv_pmos ad=0.68p pd=4.68u as=0.68p ps=4.68u w=2u l=2u
X24 oa_pcas_c_0.c8 oa_svpg_0.vpg.t1 vdd vdd sg13_hv_pmos ad=0.68p pd=4.68u as=0.68p ps=4.68u w=2u l=8u
X25 vdd oa_svpg_0.vpg.t5 oa_pcas_c_0.co vdd sg13_hv_pmos ad=0.68p pd=4.68u as=0.68p ps=4.68u w=2u l=8u
X26 vss.t24 oa_n10_0.vnc vss.t24 vss.t0 sg13_hv_nmos ad=0.68p pd=4.68u as=0 ps=0 w=2u l=1u
X27 vdd oa_svpg_0.vpg.t5 vdd vdd sg13_hv_pmos ad=0.102p pd=1.28u as=0 ps=0 w=0.3u l=8u
X28 vdd oa_svpg_0.vpg.t4 oa_pcas_c_0.co vdd sg13_hv_pmos ad=0.68p pd=4.68u as=0.68p ps=4.68u w=2u l=8u
X29 vss.t17 oa_n10_0.vnc vss.t17 vss.t0 sg13_hv_nmos ad=0.68p pd=4.68u as=0 ps=0 w=2u l=1u
X30 a_724_2272# oa_n10_0.vnc oa_mcs_c_0.vres vss.t0 sg13_hv_nmos ad=3.4p pd=20.68u as=3.4p ps=20.68u w=10u l=1u
X31 oa_pcas_c_0.co oa_svpg_0.vpg.t6 vdd vdd sg13_hv_pmos ad=0.68p pd=4.68u as=0.68p ps=4.68u w=2u l=8u
X32 oa_pcas_c_0.co oa_svpg_0.vpg.t1 vdd vdd sg13_hv_pmos ad=0.68p pd=4.68u as=0.68p ps=4.68u w=2u l=8u
X33 a_724_2272# oa_n10_0.vnc oa_mcs_c_0.vres vss.t0 sg13_hv_nmos ad=3.4p pd=20.68u as=3.4p ps=20.68u w=10u l=1u
X34 vss.t4 oa_n10_0.vnc vss.t20 vss.t0 sg13_hv_nmos ad=0.68p pd=4.68u as=0 ps=0 w=2u l=1u
X35 a_724_2272# oa_n10_0.vnc oa_mcs_c_0.vres vss.t0 sg13_hv_nmos ad=3.4p pd=20.68u as=3.4p ps=20.68u w=10u l=1u
X36 oa_pcas_c_0.co oa_n10_0.vpc iout vdd sg13_hv_pmos ad=0.68p pd=4.68u as=0.68p ps=4.68u w=2u l=2u
X37 vdd oa_svpg_0.vpg.t5 oa_pcas_c_0.c8 vdd sg13_hv_pmos ad=0.68p pd=4.68u as=0.68p ps=4.68u w=2u l=8u
X38 vss.t20 oa_n10_0.vnc vss.t24 vss.t0 sg13_hv_nmos ad=0.68p pd=4.68u as=0 ps=0 w=2u l=1u
X39 vdd oa_svpg_0.vpg.t5 oa_pcas_c_0.co vdd sg13_hv_pmos ad=0.68p pd=4.68u as=0.68p ps=4.68u w=2u l=8u
X40 vss.t1 oa_n10_0.vnc vss.t17 vss.t0 sg13_hv_nmos ad=0.68p pd=4.68u as=0 ps=0 w=2u l=1u
X41 a_724_2272# oa_n10_0.vnc oa_mcs_c_0.vres vss.t0 sg13_hv_nmos ad=3.4p pd=20.68u as=3.4p ps=20.68u w=10u l=1u
X42 oa_n10_0.vnc oa_n10_0.vnc vss.t13 vss.t0 sg13_hv_nmos ad=3.4p pd=20.68u as=3.4p ps=20.68u w=10u l=1u
X43 oa_pcas_c_0.co oa_svpg_0.vpg.t1 vdd vdd sg13_hv_pmos ad=0.68p pd=4.68u as=0.68p ps=4.68u w=2u l=8u
X44 a_724_2272# oa_n10_0.vnc oa_mcs_c_0.vres vss.t0 sg13_hv_nmos ad=3.4p pd=20.68u as=3.4p ps=20.68u w=10u l=1u
X45 oa_n10_0.vnc oa_n10_0.vnc vss.t12 vss.t0 sg13_hv_nmos ad=3.4p pd=20.68u as=3.4p ps=20.68u w=10u l=1u
X46 vdd oa_svpg_0.vpg.t1 vdd vdd sg13_hv_pmos ad=0.102p pd=1.28u as=0 ps=0 w=0.3u l=8u
X47 oa_n10_0.vnc oa_n10_0.vnc vss.t30 vss.t0 sg13_hv_nmos ad=3.4p pd=20.68u as=3.4p ps=20.68u w=10u l=1u
X48 a_724_2272# oa_n10_0.vnc oa_mcs_c_0.vres vss.t0 sg13_hv_nmos ad=3.4p pd=20.68u as=3.4p ps=20.68u w=10u l=1u
X49 oa_n10_0.vnc oa_n10_0.vnc vss.t14 vss.t0 sg13_hv_nmos ad=3.4p pd=20.68u as=3.4p ps=20.68u w=10u l=1u
X50 vdd oa_svpg_0.vpg.t4 oa_pcas_c_0.c8 vdd sg13_hv_pmos ad=0.68p pd=4.68u as=0.68p ps=4.68u w=2u l=8u
X51 oa_pcas_c_0.co oa_svpg_0.vpg.t6 vdd vdd sg13_hv_pmos ad=0.68p pd=4.68u as=0.68p ps=4.68u w=2u l=8u
X52 oa_n10_0.vnc oa_n10_0.vnc vss.t29 vss.t0 sg13_hv_nmos ad=3.4p pd=20.68u as=3.4p ps=20.68u w=10u l=1u
X53 a_7002_5993# en_3v3_b a_4434_6143# vdd sg13_hv_pmos ad=0.17p pd=1.68u as=0.17p ps=1.68u w=0.5u l=12.5u
X54 vss.t24 oa_n10_0.vnc vss.t24 vss.t0 sg13_hv_nmos ad=0.68p pd=4.68u as=0 ps=0 w=2u l=1u
X55 oa_pcas_c_0.co oa_svpg_0.vpg.t1 vdd vdd sg13_hv_pmos ad=0.68p pd=4.68u as=0.68p ps=4.68u w=2u l=8u
X56 vdd oa_svpg_0.vpg.t4 oa_pcas_c_0.co vdd sg13_hv_pmos ad=0.68p pd=4.68u as=0.68p ps=4.68u w=2u l=8u
X57 oa_n10_0.vnc oa_n10_0.vnc vss.t31 vss.t0 sg13_hv_nmos ad=3.4p pd=20.68u as=3.4p ps=20.68u w=10u l=1u
X58 a_7002_5993# en_3v3_b vdd vdd sg13_hv_pmos ad=0.17p pd=1.68u as=0.17p ps=1.68u w=0.5u l=12.5u
X59 oa_n10_0.vnc oa_n10_0.vnc vss.t22 vss.t0 sg13_hv_nmos ad=3.4p pd=20.68u as=3.4p ps=20.68u w=10u l=1u
X60 a_7002_6293# en_3v3_b a_4434_6443# vdd sg13_hv_pmos ad=0.17p pd=1.68u as=0.17p ps=1.68u w=0.5u l=12.5u
X61 oa_n10_0.vnc oa_n10_0.vnc vss.t21 vss.t0 sg13_hv_nmos ad=3.4p pd=20.68u as=3.4p ps=20.68u w=10u l=1u
X62 a_724_2272# oa_n10_0.vnc oa_mcs_c_0.vres vss.t0 sg13_hv_nmos ad=3.4p pd=20.68u as=3.4p ps=20.68u w=10u l=1u
X63 vdd oa_svpg_0.vpg.t5 vdd vdd sg13_hv_pmos ad=0.68p pd=4.68u as=0 ps=0 w=2u l=8u
X64 vss.t24 oa_n10_0.vnc vss.t24 vss.t0 sg13_hv_nmos ad=0.68p pd=4.68u as=0 ps=0 w=2u l=1u
X65 oa_n10_0.vnc oa_n10_0.vnc vss.t8 vss.t0 sg13_hv_nmos ad=3.4p pd=20.68u as=3.4p ps=20.68u w=10u l=1u
X66 vdd oa_svpg_0.vpg.t4 oa_pcas_c_0.co vdd sg13_hv_pmos ad=0.68p pd=4.68u as=0.68p ps=4.68u w=2u l=8u
X67 oa_mcs_c_0.vres oa_mcs_c_0.vbr vss.t3 vss.t0 sg13_hv_nmos ad=1.156p pd=7.48u as=1.156p ps=7.48u w=3.4u l=30u
X68 oa_pcas_c_0.c8 oa_n10_0.vpc oa_n10_0.vnc vdd sg13_hv_pmos ad=0.68p pd=4.68u as=0.68p ps=4.68u w=2u l=2u
X69 vss.t17 oa_n10_0.vnc vss.t17 vss.t0 sg13_hv_nmos ad=0.68p pd=4.68u as=0 ps=0 w=2u l=1u
X70 a_724_2272# oa_n10_0.vnc oa_mcs_c_0.vres vss.t0 sg13_hv_nmos ad=3.4p pd=20.68u as=3.4p ps=20.68u w=10u l=1u
X71 a_7002_6593# en_3v3_b a_4434_6743# vdd sg13_hv_pmos ad=0.17p pd=1.68u as=0.17p ps=1.68u w=0.5u l=12.5u
X72 vdd oa_svpg_0.vpg.t5 oa_pcas_c_0.c2 vdd sg13_hv_pmos ad=0.68p pd=4.68u as=0.68p ps=4.68u w=2u l=8u
X73 a_7002_6293# en_3v3_b a_4434_6143# vdd sg13_hv_pmos ad=0.17p pd=1.68u as=0.17p ps=1.68u w=0.5u l=12.5u
X74 a_724_2272# oa_n10_0.vnc oa_mcs_c_0.vres vss.t0 sg13_hv_nmos ad=3.4p pd=20.68u as=3.4p ps=20.68u w=10u l=1u
X75 oa_n10_0.ks en_3v3_b vss.t1 vss.t0 sg13_hv_nmos ad=0.34p pd=2.68u as=0.34p ps=2.68u w=1u l=0.45u
X76 vdd oa_svpg_0.vpg.t5 vdd vdd sg13_hv_pmos ad=0.102p pd=1.28u as=0 ps=0 w=0.3u l=8u
X77 oa_pcas_c_0.co oa_svpg_0.vpg.t6 vdd vdd sg13_hv_pmos ad=0.68p pd=4.68u as=0.68p ps=4.68u w=2u l=8u
X78 a_7002_6593# en_3v3_b a_4434_6443# vdd sg13_hv_pmos ad=0.17p pd=1.68u as=0.17p ps=1.68u w=0.5u l=12.5u
X79 oa_pcas_c_0.co oa_svpg_0.vpg.t1 vdd vdd sg13_hv_pmos ad=0.68p pd=4.68u as=0.68p ps=4.68u w=2u l=8u
X80 vdd oa_svpg_0.vpg.t4 oa_pcas_c_0.co vdd sg13_hv_pmos ad=0.68p pd=4.68u as=0.68p ps=4.68u w=2u l=8u
X81 a_724_2272# oa_n10_0.vnc oa_mcs_c_0.vres vss.t0 sg13_hv_nmos ad=3.4p pd=20.68u as=3.4p ps=20.68u w=10u l=1u
X82 oa_pcas_c_0.co oa_svpg_0.vpg.t6 vdd vdd sg13_hv_pmos ad=0.68p pd=4.68u as=0.68p ps=4.68u w=2u l=8u
X83 vss.t4 oa_n10_0.vnc vss.t4 vss.t0 sg13_hv_nmos ad=0.68p pd=4.68u as=0 ps=0 w=2u l=1u
X84 a_7002_6893# en_3v3_b oa_n10_0.ks vdd sg13_hv_pmos ad=0.17p pd=1.68u as=0.17p ps=1.68u w=0.5u l=12.5u
X85 vss.t1 oa_n10_0.vnc vss.t1 vss.t0 sg13_hv_nmos ad=0.68p pd=4.68u as=0 ps=0 w=2u l=1u
X86 oa_pcas_c_0.c8 oa_svpg_0.vpg.t1 vdd vdd sg13_hv_pmos ad=0.68p pd=4.68u as=0.68p ps=4.68u w=2u l=8u
X87 vdd oa_svpg_0.vpg.t4 oa_pcas_c_0.c8 vdd sg13_hv_pmos ad=0.68p pd=4.68u as=0.68p ps=4.68u w=2u l=8u
X88 a_724_2272# oa_n10_0.vnc oa_mcs_c_0.vres vss.t0 sg13_hv_nmos ad=3.4p pd=20.68u as=3.4p ps=20.68u w=10u l=1u
X89 vss.t1 oa_n10_0.vnc vss.t1 vss.t0 sg13_hv_nmos ad=0.68p pd=4.68u as=0 ps=0 w=2u l=1u
X90 a_7002_6893# en_3v3_b a_4434_6743# vdd sg13_hv_pmos ad=0.17p pd=1.68u as=0.17p ps=1.68u w=0.5u l=12.5u
X91 a_724_2272# oa_n10_0.vnc oa_mcs_c_0.vres vss.t0 sg13_hv_nmos ad=3.4p pd=20.68u as=3.4p ps=20.68u w=10u l=1u
X92 oa_pcas_c_0.c8 oa_n10_0.vpc oa_n10_0.vnc vdd sg13_hv_pmos ad=0.68p pd=4.68u as=0.68p ps=4.68u w=2u l=2u
X93 oa_pcas_c_0.c8 oa_svpg_0.vpg.t6 vdd vdd sg13_hv_pmos ad=0.68p pd=4.68u as=0.68p ps=4.68u w=2u l=8u
X94 vdd oa_svpg_0.vpg.t4 oa_pcas_c_0.co vdd sg13_hv_pmos ad=0.68p pd=4.68u as=0.68p ps=4.68u w=2u l=8u
X95 vss.t17 oa_n10_0.vnc vss.t17 vss.t0 sg13_hv_nmos ad=0.68p pd=4.68u as=0 ps=0 w=2u l=1u
X96 a_724_2272# oa_n10_0.vnc oa_mcs_c_0.vres vss.t0 sg13_hv_nmos ad=3.4p pd=20.68u as=3.4p ps=20.68u w=10u l=1u
X97 vss.t4 oa_mcs_c_0.vbr vss.t4 vss.t0 sg13_hv_nmos ad=0.68p pd=4.68u as=0 ps=0 w=2u l=1u
X98 vdd oa_svpg_0.vpg.t4 vdd vdd sg13_hv_pmos ad=0.102p pd=1.28u as=0 ps=0 w=0.3u l=8u
X99 vdd en_3v3 oa_svpg_0.vpg.t0 vdd sg13_hv_pmos ad=0.34p pd=2.68u as=0.34p ps=2.68u w=1u l=0.45u
X100 vdd oa_svpg_0.vpg.t5 oa_pcas_c_0.c8 vdd sg13_hv_pmos ad=0.68p pd=4.68u as=0.68p ps=4.68u w=2u l=8u
X101 vdd oa_svpg_0.vpg.t4 vdd vdd sg13_hv_pmos ad=0.102p pd=1.28u as=0 ps=0 w=0.3u l=8u
X102 a_724_2272# oa_n10_0.vnc oa_mcs_c_0.vres vss.t0 sg13_hv_nmos ad=3.4p pd=20.68u as=3.4p ps=20.68u w=10u l=1u
X103 a_724_2272# oa_n10_0.vnc oa_mcs_c_0.vres vss.t0 sg13_hv_nmos ad=3.4p pd=20.68u as=3.4p ps=20.68u w=10u l=1u
X104 vss.t17 oa_n10_0.vnc vss.t17 vss.t0 sg13_hv_nmos ad=0.68p pd=4.68u as=0 ps=0 w=2u l=1u
X105 vdd oa_svpg_0.vpg.t5 oa_pcas_c_0.co vdd sg13_hv_pmos ad=0.68p pd=4.68u as=0.68p ps=4.68u w=2u l=8u
X106 oa_svpg_0.vpg.t3 oa_n10_0.vpc oa_n10_0.vpc vdd sg13_hv_pmos ad=0.17p pd=1.68u as=0.17p ps=1.68u w=0.5u l=2u
X107 oa_pcas_c_0.c8 oa_svpg_0.vpg.t6 vdd vdd sg13_hv_pmos ad=0.68p pd=4.68u as=0.68p ps=4.68u w=2u l=8u
X108 vss.t17 oa_n10_0.vnc vss.t17 vss.t0 sg13_hv_nmos ad=0.68p pd=4.68u as=0 ps=0 w=2u l=1u
X109 a_724_2272# oa_n10_0.vnc oa_mcs_c_0.vres vss.t0 sg13_hv_nmos ad=3.4p pd=20.68u as=3.4p ps=20.68u w=10u l=1u
X110 oa_pcas_c_0.c2 oa_n10_0.vpc oa_mcs_c_0.vbr vdd sg13_hv_pmos ad=0.34p pd=2.68u as=0.34p ps=2.68u w=1u l=2u
R0 vss.t0 vss.n1 0.153433
R1 vss.t17 vss.n2 1.11349
R2 vss.n2 vss.n1 0.00876207
R3 vss.t24 vss.t29 4.89705
R4 vss.t31 vss.t17 4.89705
R5 vss.t21 vss.t20 4.89705
R6 vss.t17 vss.t8 4.89705
R7 vss.t4 vss.t12 4.89705
R8 vss.t14 vss.t1 4.89705
R9 vss.t29 vss.t30 3.11084
R10 vss.t30 vss.t31 3.11084
R11 vss.t22 vss.t21 3.11084
R12 vss.t8 vss.t22 3.11084
R13 vss.t12 vss.t13 3.11084
R14 vss.t13 vss.t14 3.11084
R15 vss.n1 vss.t24 1.00207
R16 vss.t7 vss.t3 1.31251
R17 vss vss.t7 1.25908
R18 vss.t3 vss.n0 0.832518
R19 vss.t20 vss.t4 0.562392
R20 vss.t24 vss.n0 0.880986
R21 vss.n0 vss.n2 1.39672
R22 vss.t1 vss.t17 1.36212
R23 vss.t20 vss.t24 1.20182
R24 oa_svpg_0.vpg oa_svpg_0.vpg.t3 24.8167
R25 oa_svpg_0.vpg oa_svpg_0.vpg.t4 19.3027
R26 oa_svpg_0.vpg.n1 oa_svpg_0.vpg 17.5453
R27 oa_svpg_0.vpg.n4 oa_svpg_0.vpg.n3 14.0539
R28 oa_svpg_0.vpg.n3 oa_svpg_0.vpg.n2 12.4919
R29 oa_svpg_0.vpg.t6 oa_svpg_0.vpg 10.3363
R30 oa_svpg_0.vpg oa_svpg_0.vpg.n0 9.0005
R31 oa_svpg_0.vpg.n3 oa_svpg_0.vpg.t2 7.71432
R32 oa_svpg_0.vpg oa_svpg_0.vpg.t0 5.6887
R33 oa_svpg_0.vpg.n4 oa_svpg_0.vpg.t1 2.9168
R34 oa_svpg_0.vpg.n0 oa_svpg_0.vpg.t5 2.63886
R35 oa_svpg_0.vpg.t5 oa_svpg_0.vpg.n1 2.38435
R36 oa_svpg_0.vpg.n2 oa_svpg_0.vpg.t1 2.376
R37 oa_svpg_0.vpg.n2 oa_svpg_0.vpg.t4 2.01148
R38 oa_svpg_0.vpg.t4 oa_svpg_0.vpg.n4 2.00879
R39 oa_svpg_0.vpg.n1 oa_svpg_0.vpg.t6 2.00704
R40 oa_svpg_0.vpg.n0 oa_svpg_0.vpg.t6 2.00201
R41 oa_svpg_0.vpg.t1 oa_svpg_0.vpg.t5 1.80503
C0 oa_svpg_0.vpg oa_pcas_c_0.c2 8.0679f
C1 iout oa_n10_0.vnc 4.41184f
C2 oa_pcas_c_0.c8 en_3v3_b 0.34029f
C3 iout vdd 0.668f
C4 oa_n10_0.ks oa_pcas_c_0.c2 0.02865f
C5 en_3v3 iout 0.0625f
C6 a_4434_6443# a_4434_6143# 0.01385f
C7 oa_pcas_c_0.c2 oa_pcas_c_0.co 1.15185f
C8 en_3v3_b oa_n10_0.vnc 0.61168f
C9 oa_mcs_c_0.vbr a_4434_6143# 0.02219f
C10 en_3v3_b vdd 8.08073f
C11 oa_n10_0.vnc oa_mcs_c_0.vres 26.6334f
C12 en_3v3 en_3v3_b 0.03489f
C13 a_7002_6593# a_7002_6293# 0.01385f
C14 oa_pcas_c_0.c8 oa_n10_0.vpc 0.14406f
C15 iout a_4434_6143# 0.02926f
C16 oa_n10_0.vnc oa_n10_0.vpc 0.27426f
C17 oa_n10_0.vpc vdd 4.40193f
C18 en_3v3_b a_4434_6143# 0.02989f
C19 oa_pcas_c_0.c2 oa_mcs_c_0.vbr 0.01084f
C20 oa_svpg_0.vpg oa_pcas_c_0.co 4.70797f
C21 a_7002_6293# a_7002_5993# 0.01385f
C22 vdd a_7002_6893# 0.04225f
C23 en_3v3 a_7002_6893# 0.0162f
C24 oa_n10_0.ks oa_pcas_c_0.co 0.06724f
C25 oa_pcas_c_0.c8 oa_n10_0.vnc 0.04328f
C26 oa_pcas_c_0.c8 vdd 2.2607f
C27 oa_n10_0.vnc vdd 0.49458f
C28 a_7002_6593# en_3v3_b 0.05295f
C29 en_3v3 vdd 0.22312f
C30 a_724_2272# oa_n10_0.ks 0.09645f
C31 oa_n10_0.ks a_4434_6443# 0.05634f
C32 a_7002_5993# oa_mcs_c_0.vbr 0.02588f
C33 oa_n10_0.ks oa_mcs_c_0.vbr 0.46712f
C34 a_4434_6743# oa_n10_0.ks 0.07134f
C35 oa_pcas_c_0.c2 oa_n10_0.vpc 0.03777f
C36 oa_svpg_0.vpg iout 0.02944f
C37 a_4434_6743# oa_pcas_c_0.co 0.01899f
C38 oa_n10_0.vnc a_4434_6143# 0.02916f
C39 vdd a_4434_6143# 0.03829f
C40 iout oa_n10_0.ks 0.05455f
C41 en_3v3_b a_7002_5993# 0.05585f
C42 oa_svpg_0.vpg en_3v3_b 0.34154f
C43 iout oa_pcas_c_0.co 0.37673f
C44 a_7002_6593# a_7002_6893# 0.01385f
C45 iout a_7002_6293# 0.03781f
C46 oa_n10_0.ks en_3v3_b 0.29422f
C47 oa_pcas_c_0.c8 oa_pcas_c_0.c2 8.61381f
C48 a_724_2272# oa_mcs_c_0.vbr 0.43868f
C49 a_4434_6743# a_4434_6443# 0.01385f
C50 en_3v3_b oa_pcas_c_0.co 0.03362f
C51 en_3v3_b a_7002_6293# 0.04511f
C52 oa_svpg_0.vpg oa_n10_0.vpc 0.06591f
C53 oa_pcas_c_0.c2 vdd 1.75044f
C54 a_7002_6593# vdd 0.02964f
C55 oa_n10_0.ks oa_n10_0.vpc 2.13117f
C56 oa_svpg_0.vpg a_7002_6893# 0.01391f
C57 iout oa_mcs_c_0.vbr 0.09979f
C58 oa_n10_0.vpc oa_pcas_c_0.co 0.67601f
C59 a_724_2272# en_3v3_b 0.07181f
C60 en_3v3_b a_4434_6443# 0.05267f
C61 a_724_2272# oa_mcs_c_0.vres 19.7416f
C62 oa_svpg_0.vpg oa_pcas_c_0.c8 2.58548f
C63 en_3v3_b oa_mcs_c_0.vbr 1.17328f
C64 a_4434_6743# en_3v3_b 0.05267f
C65 oa_pcas_c_0.c8 oa_n10_0.ks 0.13124f
C66 oa_mcs_c_0.vbr oa_mcs_c_0.vres 1.46031f
C67 oa_n10_0.vnc a_7002_5993# 0.02184f
C68 a_7002_5993# vdd 0.02714f
C69 oa_svpg_0.vpg vdd 83.1487f
C70 a_724_2272# oa_n10_0.vpc 0.4516f
C71 oa_pcas_c_0.c8 oa_pcas_c_0.co 10.9656f
C72 oa_svpg_0.vpg en_3v3 0.21614f
C73 oa_n10_0.ks oa_n10_0.vnc 0.055f
C74 iout en_3v3_b 0.98519f
C75 oa_n10_0.ks vdd 0.40956f
C76 oa_n10_0.vpc oa_mcs_c_0.vbr 3.13174f
C77 vdd oa_pcas_c_0.co 5.61286f
C78 a_7002_6293# vdd 0.02334f
C79 iout oa_n10_0.vpc 0.90163f
C80 oa_n10_0.ks a_4434_6143# 0.05206f
C81 a_724_2272# oa_n10_0.vnc 9.367f
C82 a_4434_6443# vdd 0.03217f
C83 en_3v3_b oa_n10_0.vpc 0.25154f
C84 oa_n10_0.vnc oa_mcs_c_0.vbr 4.3164f
C85 oa_mcs_c_0.vbr vdd 0.53382f
C86 iout oa_pcas_c_0.c8 0.04318f
C87 a_4434_6743# vdd 0.0303f
C88 en_3v3_b a_7002_6893# 0.05282f
C89 iout vss 1.35974f
C90 vdd vss 47.3716f
C91 oa_mcs_c_0.vres vss 7.79556f
C92 a_724_2272# vss 25.4605f
C93 a_7002_5993# vss 0.70057f
C94 a_4434_6143# vss 0.66358f
C95 a_7002_6293# vss 0.03948f
C96 a_7002_6593# vss 0.03372f
C97 a_7002_6893# vss 0.01023f
C98 oa_n10_0.ks vss 16.70665f
C99 oa_pcas_c_0.c2 vss 12.59724f
C100 oa_pcas_c_0.c8 vss 0.09877f
C101 oa_pcas_c_0.co vss 36.89144f
C102 oa_svpg_0.vpg vss 2.51732f
C103 oa_svpg_0.vpg.t3 vss 0.14741f
C104 oa_svpg_0.vpg.n0 vss 1.29694f
C105 oa_svpg_0.vpg.n1 vss 0.32765f
C106 oa_svpg_0.vpg.n2 vss 0.21898f
C107 oa_svpg_0.vpg.t2 vss 0.23222f
C108 oa_svpg_0.vpg.n3 vss 0.57496f
C109 oa_svpg_0.vpg.n4 vss 0.21551f
C110 oa_svpg_0.vpg.t0 vss 0.15261f
C111 vss.t4 vss 46.4582f
C112 vss.t1 vss 17.58957f
.ends
