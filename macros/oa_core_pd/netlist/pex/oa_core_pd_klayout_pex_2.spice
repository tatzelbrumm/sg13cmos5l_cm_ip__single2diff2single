* NGSPICE file created from oa_core_pd_pex.ext - technology: ihp-sg13cmos5l

.subckt oa_core_pd_pex vdd vss iout en_3v3 en_3v3_b
X0 vss oa_n10_0.vnc vss vss sg13_hv_nmos ad=0.68p pd=4.68u as=0.13424n ps=0.53061m w=2u l=1u
X1 oa_pcas_c_0.co oa_n10_0.vpc iout vdd sg13_hv_pmos ad=0.68p pd=4.68u as=0.68p ps=4.68u w=2u l=2u
X2 oa_pcas_c_0.c2 oa_svpg_0.vpg vdd vdd sg13_hv_pmos ad=0.68p pd=4.68u as=0.68p ps=4.68u w=2u l=8u
X3 vdd oa_svpg_0.vpg oa_pcas_c_0.co vdd sg13_hv_pmos ad=0.68p pd=4.68u as=0.68p ps=4.68u w=2u l=8u
X4 oa_pcas_c_0.co oa_svpg_0.vpg vdd vdd sg13_hv_pmos ad=0.68p pd=4.68u as=0.68p ps=4.68u w=2u l=8u
X5 oa_n10_0.vpc oa_n10_0.ks vss vss sg13_hv_nmos ad=0.17p pd=1.68u as=0.17p ps=1.68u w=0.5u l=2u
X6 a_724_2272# oa_n10_0.vnc oa_mcs_c_0.vres vss sg13_hv_nmos ad=3.4p pd=20.68u as=3.4p ps=20.68u w=10u l=1u
X7 oa_pcas_c_0.co oa_n10_0.vpc iout vdd sg13_hv_pmos ad=0.68p pd=4.68u as=0.68p ps=4.68u w=2u l=2u
X8 oa_svpg_0.vpg oa_svpg_0.vpg vdd vdd sg13_hv_pmos ad=0.68p pd=4.68u as=0.68p ps=4.68u w=2u l=8u
X9 a_724_2272# oa_n10_0.vnc oa_mcs_c_0.vres vss sg13_hv_nmos ad=3.4p pd=20.68u as=3.4p ps=20.68u w=10u l=1u
X10 oa_pcas_c_0.co oa_svpg_0.vpg vdd vdd sg13_hv_pmos ad=0.68p pd=4.68u as=0.68p ps=4.68u w=2u l=8u
X11 oa_n10_0.ks oa_mcs_c_0.vbr vss vss sg13_hv_nmos ad=3.4p pd=20.68u as=3.4p ps=20.68u w=10u l=1u
X12 vdd oa_svpg_0.vpg vdd vdd sg13_hv_pmos ad=0.102p pd=1.28u as=0.13884n ps=0.38488m w=0.3u l=8u
X13 vdd oa_svpg_0.vpg oa_pcas_c_0.co vdd sg13_hv_pmos ad=0.68p pd=4.68u as=0.68p ps=4.68u w=2u l=8u
X14 vdd oa_svpg_0.vpg vdd vdd sg13_hv_pmos ad=0.102p pd=1.28u as=0 ps=0 w=0.3u l=8u
X15 oa_mcs_c_0.vbr oa_mcs_c_0.vbr vss vss sg13_hv_nmos ad=1.156p pd=7.48u as=1.156p ps=7.48u w=3.4u l=30u
X16 oa_pcas_c_0.co oa_n10_0.vpc iout vdd sg13_hv_pmos ad=0.68p pd=4.68u as=0.68p ps=4.68u w=2u l=2u
X17 vdd oa_svpg_0.vpg vdd vdd sg13_hv_pmos ad=0.102p pd=1.28u as=0 ps=0 w=0.3u l=8u
X18 oa_n10_0.vpc oa_mcs_c_0.vbr a_724_2272# vss sg13_hv_nmos ad=3.4p pd=20.68u as=3.4p ps=20.68u w=10u l=1u
X19 vss oa_n10_0.vnc vss vss sg13_hv_nmos ad=0.68p pd=4.68u as=0 ps=0 w=2u l=1u
X20 vss oa_n10_0.vnc vss vss sg13_hv_nmos ad=0.68p pd=4.68u as=0 ps=0 w=2u l=1u
X21 vss oa_n10_0.vnc vss vss sg13_hv_nmos ad=0.68p pd=4.68u as=0 ps=0 w=2u l=1u
X22 vss oa_mcs_c_0.vbr vss vss sg13_hv_nmos ad=0.68p pd=4.68u as=0 ps=0 w=2u l=1u
X23 oa_pcas_c_0.co oa_n10_0.vpc iout vdd sg13_hv_pmos ad=0.68p pd=4.68u as=0.68p ps=4.68u w=2u l=2u
X24 oa_pcas_c_0.c8 oa_svpg_0.vpg vdd vdd sg13_hv_pmos ad=0.68p pd=4.68u as=0.68p ps=4.68u w=2u l=8u
X25 vdd oa_svpg_0.vpg oa_pcas_c_0.co vdd sg13_hv_pmos ad=0.68p pd=4.68u as=0.68p ps=4.68u w=2u l=8u
X26 vss oa_n10_0.vnc vss vss sg13_hv_nmos ad=0.68p pd=4.68u as=0 ps=0 w=2u l=1u
X27 vdd oa_svpg_0.vpg vdd vdd sg13_hv_pmos ad=0.102p pd=1.28u as=0 ps=0 w=0.3u l=8u
X28 vdd oa_svpg_0.vpg oa_pcas_c_0.co vdd sg13_hv_pmos ad=0.68p pd=4.68u as=0.68p ps=4.68u w=2u l=8u
X29 vss oa_n10_0.vnc vss vss sg13_hv_nmos ad=0.68p pd=4.68u as=0 ps=0 w=2u l=1u
X30 a_724_2272# oa_n10_0.vnc oa_mcs_c_0.vres vss sg13_hv_nmos ad=3.4p pd=20.68u as=3.4p ps=20.68u w=10u l=1u
X31 oa_pcas_c_0.co oa_svpg_0.vpg vdd vdd sg13_hv_pmos ad=0.68p pd=4.68u as=0.68p ps=4.68u w=2u l=8u
X32 oa_pcas_c_0.co oa_svpg_0.vpg vdd vdd sg13_hv_pmos ad=0.68p pd=4.68u as=0.68p ps=4.68u w=2u l=8u
X33 a_724_2272# oa_n10_0.vnc oa_mcs_c_0.vres vss sg13_hv_nmos ad=3.4p pd=20.68u as=3.4p ps=20.68u w=10u l=1u
X34 vss oa_n10_0.vnc vss vss sg13_hv_nmos ad=0.68p pd=4.68u as=0 ps=0 w=2u l=1u
X35 a_724_2272# oa_n10_0.vnc oa_mcs_c_0.vres vss sg13_hv_nmos ad=3.4p pd=20.68u as=3.4p ps=20.68u w=10u l=1u
X36 oa_pcas_c_0.co oa_n10_0.vpc iout vdd sg13_hv_pmos ad=0.68p pd=4.68u as=0.68p ps=4.68u w=2u l=2u
X37 vdd oa_svpg_0.vpg oa_pcas_c_0.c8 vdd sg13_hv_pmos ad=0.68p pd=4.68u as=0.68p ps=4.68u w=2u l=8u
X38 vss oa_n10_0.vnc vss vss sg13_hv_nmos ad=0.68p pd=4.68u as=0 ps=0 w=2u l=1u
X39 vdd oa_svpg_0.vpg oa_pcas_c_0.co vdd sg13_hv_pmos ad=0.68p pd=4.68u as=0.68p ps=4.68u w=2u l=8u
X40 vss oa_n10_0.vnc vss vss sg13_hv_nmos ad=0.68p pd=4.68u as=0 ps=0 w=2u l=1u
X41 a_724_2272# oa_n10_0.vnc oa_mcs_c_0.vres vss sg13_hv_nmos ad=3.4p pd=20.68u as=3.4p ps=20.68u w=10u l=1u
X42 oa_n10_0.vnc oa_n10_0.vnc vss vss sg13_hv_nmos ad=3.4p pd=20.68u as=3.4p ps=20.68u w=10u l=1u
X43 oa_pcas_c_0.co oa_svpg_0.vpg vdd vdd sg13_hv_pmos ad=0.68p pd=4.68u as=0.68p ps=4.68u w=2u l=8u
X44 a_724_2272# oa_n10_0.vnc oa_mcs_c_0.vres vss sg13_hv_nmos ad=3.4p pd=20.68u as=3.4p ps=20.68u w=10u l=1u
X45 oa_n10_0.vnc oa_n10_0.vnc vss vss sg13_hv_nmos ad=3.4p pd=20.68u as=3.4p ps=20.68u w=10u l=1u
X46 vdd oa_svpg_0.vpg vdd vdd sg13_hv_pmos ad=0.102p pd=1.28u as=0 ps=0 w=0.3u l=8u
X47 oa_n10_0.vnc oa_n10_0.vnc vss vss sg13_hv_nmos ad=3.4p pd=20.68u as=3.4p ps=20.68u w=10u l=1u
X48 a_724_2272# oa_n10_0.vnc oa_mcs_c_0.vres vss sg13_hv_nmos ad=3.4p pd=20.68u as=3.4p ps=20.68u w=10u l=1u
X49 oa_n10_0.vnc oa_n10_0.vnc vss vss sg13_hv_nmos ad=3.4p pd=20.68u as=3.4p ps=20.68u w=10u l=1u
X50 vdd oa_svpg_0.vpg oa_pcas_c_0.c8 vdd sg13_hv_pmos ad=0.68p pd=4.68u as=0.68p ps=4.68u w=2u l=8u
X51 oa_pcas_c_0.co oa_svpg_0.vpg vdd vdd sg13_hv_pmos ad=0.68p pd=4.68u as=0.68p ps=4.68u w=2u l=8u
X52 oa_n10_0.vnc oa_n10_0.vnc vss vss sg13_hv_nmos ad=3.4p pd=20.68u as=3.4p ps=20.68u w=10u l=1u
X53 a_7002_5993# en_3v3_b a_4434_6143# vdd sg13_hv_pmos ad=0.17p pd=1.68u as=0.17p ps=1.68u w=0.5u l=12.5u
X54 vss oa_n10_0.vnc vss vss sg13_hv_nmos ad=0.68p pd=4.68u as=0 ps=0 w=2u l=1u
X55 oa_pcas_c_0.co oa_svpg_0.vpg vdd vdd sg13_hv_pmos ad=0.68p pd=4.68u as=0.68p ps=4.68u w=2u l=8u
X56 vdd oa_svpg_0.vpg oa_pcas_c_0.co vdd sg13_hv_pmos ad=0.68p pd=4.68u as=0.68p ps=4.68u w=2u l=8u
X57 oa_n10_0.vnc oa_n10_0.vnc vss vss sg13_hv_nmos ad=3.4p pd=20.68u as=3.4p ps=20.68u w=10u l=1u
X58 a_7002_5993# en_3v3_b vdd vdd sg13_hv_pmos ad=0.17p pd=1.68u as=0.17p ps=1.68u w=0.5u l=12.5u
X59 oa_n10_0.vnc oa_n10_0.vnc vss vss sg13_hv_nmos ad=3.4p pd=20.68u as=3.4p ps=20.68u w=10u l=1u
X60 a_7002_6293# en_3v3_b a_4434_6443# vdd sg13_hv_pmos ad=0.17p pd=1.68u as=0.17p ps=1.68u w=0.5u l=12.5u
X61 oa_n10_0.vnc oa_n10_0.vnc vss vss sg13_hv_nmos ad=3.4p pd=20.68u as=3.4p ps=20.68u w=10u l=1u
X62 a_724_2272# oa_n10_0.vnc oa_mcs_c_0.vres vss sg13_hv_nmos ad=3.4p pd=20.68u as=3.4p ps=20.68u w=10u l=1u
X63 vdd oa_svpg_0.vpg vdd vdd sg13_hv_pmos ad=0.68p pd=4.68u as=0 ps=0 w=2u l=8u
X64 vss oa_n10_0.vnc vss vss sg13_hv_nmos ad=0.68p pd=4.68u as=0 ps=0 w=2u l=1u
X65 oa_n10_0.vnc oa_n10_0.vnc vss vss sg13_hv_nmos ad=3.4p pd=20.68u as=3.4p ps=20.68u w=10u l=1u
X66 vdd oa_svpg_0.vpg oa_pcas_c_0.co vdd sg13_hv_pmos ad=0.68p pd=4.68u as=0.68p ps=4.68u w=2u l=8u
X67 oa_mcs_c_0.vres oa_mcs_c_0.vbr vss vss sg13_hv_nmos ad=1.156p pd=7.48u as=1.156p ps=7.48u w=3.4u l=30u
X68 oa_pcas_c_0.c8 oa_n10_0.vpc oa_n10_0.vnc vdd sg13_hv_pmos ad=0.68p pd=4.68u as=0.68p ps=4.68u w=2u l=2u
X69 vss oa_n10_0.vnc vss vss sg13_hv_nmos ad=0.68p pd=4.68u as=0 ps=0 w=2u l=1u
X70 a_724_2272# oa_n10_0.vnc oa_mcs_c_0.vres vss sg13_hv_nmos ad=3.4p pd=20.68u as=3.4p ps=20.68u w=10u l=1u
X71 a_7002_6593# en_3v3_b a_4434_6743# vdd sg13_hv_pmos ad=0.17p pd=1.68u as=0.17p ps=1.68u w=0.5u l=12.5u
X72 vdd oa_svpg_0.vpg oa_pcas_c_0.c2 vdd sg13_hv_pmos ad=0.68p pd=4.68u as=0.68p ps=4.68u w=2u l=8u
X73 a_7002_6293# en_3v3_b a_4434_6143# vdd sg13_hv_pmos ad=0.17p pd=1.68u as=0.17p ps=1.68u w=0.5u l=12.5u
X74 a_724_2272# oa_n10_0.vnc oa_mcs_c_0.vres vss sg13_hv_nmos ad=3.4p pd=20.68u as=3.4p ps=20.68u w=10u l=1u
X75 oa_n10_0.ks en_3v3_b vss vss sg13_hv_nmos ad=0.34p pd=2.68u as=0.34p ps=2.68u w=1u l=0.45u
X76 vdd oa_svpg_0.vpg vdd vdd sg13_hv_pmos ad=0.102p pd=1.28u as=0 ps=0 w=0.3u l=8u
X77 oa_pcas_c_0.co oa_svpg_0.vpg vdd vdd sg13_hv_pmos ad=0.68p pd=4.68u as=0.68p ps=4.68u w=2u l=8u
X78 a_7002_6593# en_3v3_b a_4434_6443# vdd sg13_hv_pmos ad=0.17p pd=1.68u as=0.17p ps=1.68u w=0.5u l=12.5u
X79 oa_pcas_c_0.co oa_svpg_0.vpg vdd vdd sg13_hv_pmos ad=0.68p pd=4.68u as=0.68p ps=4.68u w=2u l=8u
X80 vdd oa_svpg_0.vpg oa_pcas_c_0.co vdd sg13_hv_pmos ad=0.68p pd=4.68u as=0.68p ps=4.68u w=2u l=8u
X81 a_724_2272# oa_n10_0.vnc oa_mcs_c_0.vres vss sg13_hv_nmos ad=3.4p pd=20.68u as=3.4p ps=20.68u w=10u l=1u
X82 oa_pcas_c_0.co oa_svpg_0.vpg vdd vdd sg13_hv_pmos ad=0.68p pd=4.68u as=0.68p ps=4.68u w=2u l=8u
X83 vss oa_n10_0.vnc vss vss sg13_hv_nmos ad=0.68p pd=4.68u as=0 ps=0 w=2u l=1u
X84 a_7002_6893# en_3v3_b oa_n10_0.ks vdd sg13_hv_pmos ad=0.17p pd=1.68u as=0.17p ps=1.68u w=0.5u l=12.5u
X85 vss oa_n10_0.vnc vss vss sg13_hv_nmos ad=0.68p pd=4.68u as=0 ps=0 w=2u l=1u
X86 oa_pcas_c_0.c8 oa_svpg_0.vpg vdd vdd sg13_hv_pmos ad=0.68p pd=4.68u as=0.68p ps=4.68u w=2u l=8u
X87 vdd oa_svpg_0.vpg oa_pcas_c_0.c8 vdd sg13_hv_pmos ad=0.68p pd=4.68u as=0.68p ps=4.68u w=2u l=8u
X88 a_724_2272# oa_n10_0.vnc oa_mcs_c_0.vres vss sg13_hv_nmos ad=3.4p pd=20.68u as=3.4p ps=20.68u w=10u l=1u
X89 vss oa_n10_0.vnc vss vss sg13_hv_nmos ad=0.68p pd=4.68u as=0 ps=0 w=2u l=1u
X90 a_7002_6893# en_3v3_b a_4434_6743# vdd sg13_hv_pmos ad=0.17p pd=1.68u as=0.17p ps=1.68u w=0.5u l=12.5u
X91 a_724_2272# oa_n10_0.vnc oa_mcs_c_0.vres vss sg13_hv_nmos ad=3.4p pd=20.68u as=3.4p ps=20.68u w=10u l=1u
X92 oa_pcas_c_0.c8 oa_n10_0.vpc oa_n10_0.vnc vdd sg13_hv_pmos ad=0.68p pd=4.68u as=0.68p ps=4.68u w=2u l=2u
X93 oa_pcas_c_0.c8 oa_svpg_0.vpg vdd vdd sg13_hv_pmos ad=0.68p pd=4.68u as=0.68p ps=4.68u w=2u l=8u
X94 vdd oa_svpg_0.vpg oa_pcas_c_0.co vdd sg13_hv_pmos ad=0.68p pd=4.68u as=0.68p ps=4.68u w=2u l=8u
X95 vss oa_n10_0.vnc vss vss sg13_hv_nmos ad=0.68p pd=4.68u as=0 ps=0 w=2u l=1u
X96 a_724_2272# oa_n10_0.vnc oa_mcs_c_0.vres vss sg13_hv_nmos ad=3.4p pd=20.68u as=3.4p ps=20.68u w=10u l=1u
X97 vss oa_mcs_c_0.vbr vss vss sg13_hv_nmos ad=0.68p pd=4.68u as=0 ps=0 w=2u l=1u
X98 vdd oa_svpg_0.vpg vdd vdd sg13_hv_pmos ad=0.102p pd=1.28u as=0 ps=0 w=0.3u l=8u
X99 vdd en_3v3 oa_svpg_0.vpg vdd sg13_hv_pmos ad=0.34p pd=2.68u as=0.34p ps=2.68u w=1u l=0.45u
X100 vdd oa_svpg_0.vpg oa_pcas_c_0.c8 vdd sg13_hv_pmos ad=0.68p pd=4.68u as=0.68p ps=4.68u w=2u l=8u
X101 vdd oa_svpg_0.vpg vdd vdd sg13_hv_pmos ad=0.102p pd=1.28u as=0 ps=0 w=0.3u l=8u
X102 a_724_2272# oa_n10_0.vnc oa_mcs_c_0.vres vss sg13_hv_nmos ad=3.4p pd=20.68u as=3.4p ps=20.68u w=10u l=1u
X103 a_724_2272# oa_n10_0.vnc oa_mcs_c_0.vres vss sg13_hv_nmos ad=3.4p pd=20.68u as=3.4p ps=20.68u w=10u l=1u
X104 vss oa_n10_0.vnc vss vss sg13_hv_nmos ad=0.68p pd=4.68u as=0 ps=0 w=2u l=1u
X105 vdd oa_svpg_0.vpg oa_pcas_c_0.co vdd sg13_hv_pmos ad=0.68p pd=4.68u as=0.68p ps=4.68u w=2u l=8u
X106 oa_svpg_0.vpg oa_n10_0.vpc oa_n10_0.vpc vdd sg13_hv_pmos ad=0.17p pd=1.68u as=0.17p ps=1.68u w=0.5u l=2u
X107 oa_pcas_c_0.c8 oa_svpg_0.vpg vdd vdd sg13_hv_pmos ad=0.68p pd=4.68u as=0.68p ps=4.68u w=2u l=8u
X108 vss oa_n10_0.vnc vss vss sg13_hv_nmos ad=0.68p pd=4.68u as=0 ps=0 w=2u l=1u
X109 a_724_2272# oa_n10_0.vnc oa_mcs_c_0.vres vss sg13_hv_nmos ad=3.4p pd=20.68u as=3.4p ps=20.68u w=10u l=1u
X110 oa_pcas_c_0.c2 oa_n10_0.vpc oa_mcs_c_0.vbr vdd sg13_hv_pmos ad=0.34p pd=2.68u as=0.34p ps=2.68u w=1u l=2u
C0 oa_pcas_c_0.co oa_svpg_0.vpg 4.70797f
C1 oa_svpg_0.vpg en_3v3_b 0.34154f
C2 oa_pcas_c_0.c8 oa_n10_0.vpc 0.14406f
C3 iout oa_n10_0.vpc 0.90163f
C4 a_7002_6293# a_7002_6593# 0.01385f
C5 en_3v3_b a_724_2272# 0.07181f
C6 vdd oa_mcs_c_0.vbr 0.53382f
C7 en_3v3_b a_7002_5993# 0.05585f
C8 oa_pcas_c_0.co oa_pcas_c_0.c2 1.15185f
C9 oa_pcas_c_0.co oa_n10_0.ks 0.06724f
C10 vdd a_4434_6443# 0.03217f
C11 oa_n10_0.ks en_3v3_b 0.29422f
C12 oa_mcs_c_0.vres a_724_2272# 19.7416f
C13 en_3v3_b a_4434_6143# 0.02989f
C14 oa_pcas_c_0.co a_4434_6743# 0.01899f
C15 en_3v3_b a_4434_6743# 0.05267f
C16 oa_svpg_0.vpg oa_n10_0.vpc 0.06591f
C17 oa_mcs_c_0.vbr iout 0.09979f
C18 a_7002_6593# a_7002_6893# 0.01385f
C19 en_3v3_b oa_n10_0.vnc 0.61168f
C20 a_724_2272# oa_n10_0.vpc 0.4516f
C21 a_7002_6293# en_3v3_b 0.04511f
C22 oa_mcs_c_0.vres oa_n10_0.vnc 26.6334f
C23 oa_pcas_c_0.c2 oa_n10_0.vpc 0.03777f
C24 oa_n10_0.ks oa_n10_0.vpc 2.13117f
C25 vdd en_3v3 0.22312f
C26 a_7002_6593# en_3v3_b 0.05295f
C27 vdd oa_pcas_c_0.c8 2.2607f
C28 vdd iout 0.668f
C29 oa_n10_0.vnc oa_n10_0.vpc 0.27426f
C30 oa_mcs_c_0.vbr a_724_2272# 0.43868f
C31 a_7002_6893# en_3v3_b 0.05282f
C32 iout en_3v3 0.0625f
C33 oa_mcs_c_0.vbr a_7002_5993# 0.02588f
C34 oa_pcas_c_0.c8 iout 0.04318f
C35 oa_mcs_c_0.vbr oa_pcas_c_0.c2 0.01084f
C36 oa_mcs_c_0.vbr oa_n10_0.ks 0.46712f
C37 oa_mcs_c_0.vbr a_4434_6143# 0.02219f
C38 vdd oa_svpg_0.vpg 83.1487f
C39 oa_n10_0.ks a_4434_6443# 0.05634f
C40 a_4434_6143# a_4434_6443# 0.01385f
C41 a_4434_6443# a_4434_6743# 0.01385f
C42 oa_pcas_c_0.co en_3v3_b 0.03362f
C43 oa_mcs_c_0.vbr oa_n10_0.vnc 4.3164f
C44 vdd a_7002_5993# 0.02714f
C45 oa_svpg_0.vpg en_3v3 0.21614f
C46 vdd oa_pcas_c_0.c2 1.75044f
C47 vdd oa_n10_0.ks 0.40956f
C48 vdd a_4434_6143# 0.03829f
C49 oa_pcas_c_0.c8 oa_svpg_0.vpg 2.58548f
C50 oa_svpg_0.vpg iout 0.02944f
C51 vdd a_4434_6743# 0.0303f
C52 vdd oa_n10_0.vnc 0.49458f
C53 oa_pcas_c_0.co oa_n10_0.vpc 0.67601f
C54 en_3v3_b oa_n10_0.vpc 0.25154f
C55 oa_pcas_c_0.c8 oa_pcas_c_0.c2 8.61381f
C56 oa_pcas_c_0.c8 oa_n10_0.ks 0.13124f
C57 oa_n10_0.ks iout 0.05455f
C58 a_4434_6143# iout 0.02926f
C59 vdd a_7002_6293# 0.02334f
C60 oa_pcas_c_0.c8 oa_n10_0.vnc 0.04328f
C61 oa_n10_0.vnc iout 4.41184f
C62 vdd a_7002_6593# 0.02964f
C63 a_7002_6293# iout 0.03781f
C64 oa_svpg_0.vpg oa_pcas_c_0.c2 8.0679f
C65 oa_mcs_c_0.vbr en_3v3_b 1.17328f
C66 vdd a_7002_6893# 0.04225f
C67 oa_n10_0.ks a_724_2272# 0.09645f
C68 en_3v3_b a_4434_6443# 0.05267f
C69 oa_mcs_c_0.vbr oa_mcs_c_0.vres 1.46031f
C70 oa_n10_0.ks oa_pcas_c_0.c2 0.02865f
C71 oa_n10_0.ks a_4434_6143# 0.05206f
C72 a_724_2272# oa_n10_0.vnc 9.367f
C73 a_7002_6893# en_3v3 0.0162f
C74 oa_n10_0.ks a_4434_6743# 0.07134f
C75 vdd oa_pcas_c_0.co 5.61286f
C76 vdd en_3v3_b 8.08073f
C77 oa_n10_0.vnc a_7002_5993# 0.02184f
C78 oa_mcs_c_0.vbr oa_n10_0.vpc 3.13174f
C79 oa_n10_0.ks oa_n10_0.vnc 0.055f
C80 a_4434_6143# oa_n10_0.vnc 0.02916f
C81 a_7002_6293# a_7002_5993# 0.01385f
C82 en_3v3_b en_3v3 0.03489f
C83 oa_pcas_c_0.co oa_pcas_c_0.c8 10.9656f
C84 oa_pcas_c_0.co iout 0.37673f
C85 oa_pcas_c_0.c8 en_3v3_b 0.34029f
C86 en_3v3_b iout 0.98519f
C87 oa_svpg_0.vpg a_7002_6893# 0.01391f
C88 vdd oa_n10_0.vpc 4.40193f
C89 iout vss 0.27848f
C90 en_3v3 vss 0.20609f
C91 en_3v3_b vss 1.31451f
C92 oa_mcs_c_0.vres vss 6.31088f ; **FLOATING
C93 a_724_2272# vss 23.8683f ; **FLOATING
C94 a_7002_5993# vss 0.03908f ; **FLOATING
C95 a_7002_6293# vss 0.03948f ; **FLOATING
C96 oa_mcs_c_0.vbr vss 32.9406f ; **FLOATING
C97 oa_n10_0.vnc vss 45.6206f ; **FLOATING
C98 a_7002_6593# vss 0.03372f ; **FLOATING
C99 oa_n10_0.vpc vss 1.21878f ; **FLOATING
C100 a_7002_6893# vss 0.01023f ; **FLOATING
C101 oa_n10_0.ks vss 1.69416f ; **FLOATING
C102 oa_pcas_c_0.c2 vss 0.62247f ; **FLOATING
C103 oa_pcas_c_0.c8 vss 0.09881f ; **FLOATING
C104 oa_pcas_c_0.co vss 0.51113f ; **FLOATING
C105 oa_svpg_0.vpg vss 0.93387f ; **FLOATING
.ends
