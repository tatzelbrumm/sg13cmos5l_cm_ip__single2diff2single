** sch_path: /foss/designs/sg13cmos5l_cm_ip__single2diff2single/macros/slot/schematic/xschem/slot.sch
.subckt slot vss_1v2 s7_an[0] s7_an[1] s7_an_0_esd vbias dig_in[23] dig_in[22] dig_in[21] dig_in[20] dig_in[19] dig_in[18]
+ dig_in[17] dig_in[16] dig_in[15] dig_in[14] dig_in[13] dig_in[12] dig_in[11] dig_in[10] dig_in[9] dig_in[8] dig_in[7] dig_in[6] dig_in[5]
+ dig_in[4] dig_in[3] dig_in[2] dig_in[1] dig_in[0] dig_out[11] dig_out[10] dig_out[9] dig_out[8] dig_out[7] dig_out[6] dig_out[5] dig_out[4]
+ dig_out[3] dig_out[2] dig_out[1] dig_out[0] ibias0 ibias1 analog_bus3 analog_bus2 analog_bus1 analog_bus0 vdd_1v2 vss_3v3 vdd_3v3 enable clk
+ reset
*.PININFO dig_in[23:0]:I enable:I clk:I reset:I dig_out[11:0]:O vss_1v2:B s7_an[0:1]:B s7_an_0_esd:B vbias:B ibias0:B ibias1:B
*+ analog_bus3:B analog_bus2:B analog_bus1:B analog_bus0:B vdd_1v2:B vss_3v3:B vdd_3v3:B
.ends
