* SPDX-FileCopyrightText: 2026 Christoph Maier
* SPDX-License-Identifier: Apache-2.0
* en_ctrl_3v3 (v2, 2026-11-08): fail-safe enable and select bits for the 3.3 V circuits of slot 7 and its pads.
* v1 (pg_det supply detectors, ls_up_1v2_3v3 shifters; in git history up to 2026-11-08) drew 2-5 uA while enabled
* from its ratioed detectors, and up to 152 uA when the slot's 1.2 V was off with en_1v2 high.
* v2 principle: the inputs are valid 1.2 V levels from the harness's always-on rail (enable, dig_in), also while the
* slot's own vdd_1v2 is off. Each bit is shifted without a 1.2 V supply (ls_up_fs); the cell sits on the slot's switched
* vdd_3v3 and is unpowered with it. No supply sensing: with the slot's 3.3 V off, nothing in the slot is powered and the
* pads on the ring get no iref, so they draw leakage only whatever the enable lines float to (testbenches/spice).
* Ports unchanged from v1 so that the sheets placing the symbol stay valid; vddl and the two sense inputs are no longer
* connected inside.

* ls_up_fs: fail-safe 1.2 V -> 3.3 V level shifter that needs no 1.2 V supply (for inputs that are valid 1.2 V levels
* from the harness's always-on rail: enable, dig_in).
*   x = NOT in: XN1 (gate in) pulls x low; the leaker chain XPL1..10 (10 x hv PMOS 0.3u/20u in series, gates on in)
*       pulls x high when in = 0 (full gate drive) and is 2 ... 5 x weaker while in = 1 (gate at 1.2 V).
*   XPF (gate y) latches x high once y is low: hysteresis, and it holds x against XN1's leakage.
*   y = in at 3.3 V; out = y buffered; out_b = NOT out.
*   Static current: in = 1: the chain, 28 ... 92 nA over corners and 3.0 ... 3.6 V; in = 0: leakage.
.subckt ls_up_fs vddh vss in out out_b
XN1 x in vss vss sg13_hv_nmos w=1u l=0.45u ng=1
XPL10 l9 in vddh vddh sg13_hv_pmos w=0.3u l=20u ng=1
XPL9 l8 in l9 vddh sg13_hv_pmos w=0.3u l=20u ng=1
XPL8 l7 in l8 vddh sg13_hv_pmos w=0.3u l=20u ng=1
XPL7 l6 in l7 vddh sg13_hv_pmos w=0.3u l=20u ng=1
XPL6 l5 in l6 vddh sg13_hv_pmos w=0.3u l=20u ng=1
XPL5 l4 in l5 vddh sg13_hv_pmos w=0.3u l=20u ng=1
XPL4 l3 in l4 vddh sg13_hv_pmos w=0.3u l=20u ng=1
XPL3 l2 in l3 vddh sg13_hv_pmos w=0.3u l=20u ng=1
XPL2 l1 in l2 vddh sg13_hv_pmos w=0.3u l=20u ng=1
XPL1 x in l1 vddh sg13_hv_pmos w=0.3u l=20u ng=1
XPF x y vddh vddh sg13_hv_pmos w=0.3u l=5u ng=1
XI1 vddh vss x y inv_hv
XI2 vddh vss y out_b inv_hv
XI3 vddh vss out_b out inv_hv
.ends ls_up_fs

* en_ctrl_3v3 v2: fail-safe enable and select bits, three ls_up_fs. No supply detector, no 1.2 V supply needed.
*   en_3v3 = en_1v2 at 3.3 V, en_3v3_b = NOT en_3v3; sel*_3v3 = sel*_1v2 at 3.3 V (gated by en_3v3 downstream).
*   vddl, vdd1v2_sense, vdd3v3_sense: kept as ports so the sheets that place the symbol stay valid; not connected.
.subckt en_ctrl_3v3 vddh vddl vss en_1v2 sel0_1v2 sel1_1v2 vdd1v2_sense vdd3v3_sense en_3v3 sel0_3v3 sel1_3v3 en_3v3_b
XE vddh vss en_1v2 en_3v3 en_3v3_b ls_up_fs
XS0 vddh vss sel0_1v2 sel0_3v3 sel0_b ls_up_fs
XS1 vddh vss sel1_1v2 sel1_3v3 sel1_b ls_up_fs
.ends en_ctrl_3v3
