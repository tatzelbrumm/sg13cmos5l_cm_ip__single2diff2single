* SPDX-FileCopyrightText: 2026 Christoph Maier
* SPDX-License-Identifier: Apache-2.0
* slot_7: the slot-7 circuit (tier 1) with with the custom pads (proposal, 2026-11-08; docs/slot7_hookup/CONCEPT.md).
*   Harness enable -> ls_up_fs (en_ctrl_3v3 v2's shifter) -> en_3v3 / en_3v3_b for everything; s7_ctrl (above): loop
*   S2D -> D2S direct or crossed, S2D outputs to bus0/1, bus0/1 to the D2S inputs; bandgap core -> bias_dist_pd input 0 -> iout0 pad_ref_rb, iout1 S2D iref, iout2 D2S iref (iout3 spare,
*   off); pad_ref_rb (on the slot's vdd_3v3: the pad ring is not reachable inside the slot) -> vcm to S2D vcm and D2S
*   vref, vref to S2D vref; analog_bus2 / 3 = vcm / vref, isolated by the harness's own per-slot bus switches (reg 0x51 bits 6 / 7).
* Ports: the slot's harness ports used here, then the 13 custom-pad nets (names as in the harness's custom-io route).
* dig_out0..11 are held low by s7_doutpd (needs the slot's vdd_1v2 on); unused, not listed: dig_in6..23, clk, reset,
* ibias0/1, vbias.
* s7_ctrl: mode control and switch matrix of slot 7 (tier 1, 2026-11-08, Christoph's spec):
*   dig_in0 = swap (loop crossed), dig_in1 = mon (S2D outputs -> analog_bus0/1, loop stays on),
*   dig_in2 = feed (analog_bus0/1 -> D2S inputs, loop off), dig_in5 = ext (pad_ref_rb's vcm / vref disconnected
*   from the pads, which then take vcm / vref from analog_bus2 / 3), active only with the key dig_in3 = 1, dig_in4 = 0;
*   any other key (e.g. all dig_in equal after a harness reset) = default: loop direct, bus0/1 disconnected, pad_ref_rb
*   drives vcm / vref (monitored on analog_bus2 / 3).
*   All switches off while enable = 0. Every bit through ls_up_fs (no 1.2 V supply; ~50 nA while its input is 1).
.subckt s7_ctrl vddh vss enable d0 d1 d2 d3 d4 d5 en en_b outp outn vinp vinn bus0 bus1 vcm_rb vref_rb vcm_pad vref_pad
XLE vddh vss enable en en_b ls_up_fs
XL0 vddh vss d0 sw sw_b ls_up_fs
XL1 vddh vss d1 mon mon_b ls_up_fs
XL2 vddh vss d2 fd fd_b ls_up_fs
XL3 vddh vss d3 k1 k1_b ls_up_fs
XL4 vddh vss d4 k0 k0_b ls_up_fs
XL5 vddh vss d5 ex ex_b ls_up_fs
* key valid = k1 AND NOT k0
XNV vddh vss k1 k0_b valid_b nand2_hv
XIV vddh vss valid_b valid inv_hv
* qualified bits
XNS vddh vss sw valid s_b nand2_hv
XIS vddh vss s_b s inv_hv
XNF vddh vss fd valid f_b nand2_hv
XIF vddh vss f_b f inv_hv
XNM vddh vss mon valid m_b nand2_hv
XIM vddh vss m_b m inv_hv
* loop direct: en AND NOT f AND NOT s
XN1 vddh vss f_b s_b x1_b nand2_hv
XI1 vddh vss x1_b x1 inv_hv
XNLD vddh vss en x1 ld_b nand2_hv
XILD vddh vss ld_b ld inv_hv
* loop crossed: en AND NOT f AND s
XN2 vddh vss f_b s x2_b nand2_hv
XI2 vddh vss x2_b x2 inv_hv
XNLX vddh vss en x2 lx_b nand2_hv
XILX vddh vss lx_b lx inv_hv
* S2D outputs to bus0/1: en AND m AND NOT f
XN3 vddh vss m f_b x3_b nand2_hv
XI3 vddh vss x3_b x3 inv_hv
XNSB vddh vss en x3 sb_b nand2_hv
XISB vddh vss sb_b sb inv_hv
* bus0/1 to D2S inputs: en AND f
XNBD vddh vss en f bd_b nand2_hv
XIBD vddh vss bd_b bd inv_hv
* replica bias connected: en AND NOT (ext AND valid)
XNE vddh vss ex valid e_b nand2_hv
XNRC vddh vss en e_b rc_b nand2_hv
XIRC vddh vss rc_b rc inv_hv
* switch matrix (tg_hv: vdd vss en en_b a b)
XT1 vddh vss ld ld_b outp vinp tg_hv
XT2 vddh vss ld ld_b outn vinn tg_hv
XT3 vddh vss lx lx_b outp vinn tg_hv
XT4 vddh vss lx lx_b outn vinp tg_hv
XT5 vddh vss sb sb_b outp bus0 tg_hv
XT6 vddh vss sb sb_b outn bus1 tg_hv
XT7 vddh vss bd bd_b bus0 vinp tg_hv
XT8 vddh vss bd bd_b bus1 vinn tg_hv
XT9 vddh vss rc rc_b vcm_rb vcm_pad tg_hv
XT10 vddh vss rc rc_b vref_rb vref_pad tg_hv
.ends s7_ctrl

* s7_doutpd: holds the unused dig_out[11:0] low while the slot's vdd_1v2 is on, as the fallback slot did (hv NMOS 0.5u /
* 0.45u per output, gate vdd_1v2, source vss_1v2, bulk = substrate vss_3v3). Back-annotated from agent A's layout.
.subckt s7_doutpd d0 d1 d2 d3 d4 d5 d6 d7 d8 d9 d10 d11 vdd_1v2 vss_1v2 vss_3v3
XM0 d0 vdd_1v2 vss_1v2 vss_3v3 sg13_hv_nmos w=0.5u l=0.45u ng=1 m=1
XM1 d1 vdd_1v2 vss_1v2 vss_3v3 sg13_hv_nmos w=0.5u l=0.45u ng=1 m=1
XM2 d2 vdd_1v2 vss_1v2 vss_3v3 sg13_hv_nmos w=0.5u l=0.45u ng=1 m=1
XM3 d3 vdd_1v2 vss_1v2 vss_3v3 sg13_hv_nmos w=0.5u l=0.45u ng=1 m=1
XM4 d4 vdd_1v2 vss_1v2 vss_3v3 sg13_hv_nmos w=0.5u l=0.45u ng=1 m=1
XM5 d5 vdd_1v2 vss_1v2 vss_3v3 sg13_hv_nmos w=0.5u l=0.45u ng=1 m=1
XM6 d6 vdd_1v2 vss_1v2 vss_3v3 sg13_hv_nmos w=0.5u l=0.45u ng=1 m=1
XM7 d7 vdd_1v2 vss_1v2 vss_3v3 sg13_hv_nmos w=0.5u l=0.45u ng=1 m=1
XM8 d8 vdd_1v2 vss_1v2 vss_3v3 sg13_hv_nmos w=0.5u l=0.45u ng=1 m=1
XM9 d9 vdd_1v2 vss_1v2 vss_3v3 sg13_hv_nmos w=0.5u l=0.45u ng=1 m=1
XM10 d10 vdd_1v2 vss_1v2 vss_3v3 sg13_hv_nmos w=0.5u l=0.45u ng=1 m=1
XM11 d11 vdd_1v2 vss_1v2 vss_3v3 sg13_hv_nmos w=0.5u l=0.45u ng=1 m=1
.ends s7_doutpd

.subckt slot_7 vdd_3v3 vss_3v3 enable dig_in0 dig_in1 dig_in2 dig_in3 dig_in4 dig_in5 analog_bus0 analog_bus1 analog_bus2 analog_bus3
+ s7_an_0_vref s7_an_0_outp s7_an_0_outn s7_an_0_vcm s7_an_0_en_3v3 s7_an_0_en_3v3_b s7_an_0_iref
+ s7_an_1_vinp s7_an_1_vinn s7_an_1_vref s7_an_1_iref s7_an_1_en_3v3_b s7_an_1_en_3v3
+ dig_out0 dig_out1 dig_out2 dig_out3 dig_out4 dig_out5 dig_out6 dig_out7 dig_out8 dig_out9 dig_out10 dig_out11
+ vdd_1v2 vss_1v2
* master enable, mode decode and the switch matrix S2D -> D2S / bus0/1
XC vdd_3v3 vss_3v3 enable dig_in0 dig_in1 dig_in2 dig_in3 dig_in4 dig_in5 en en_b s7_an_0_outp s7_an_0_outn
+ s7_an_1_vinp s7_an_1_vinn analog_bus0 analog_bus1 vcm_rb vref_rb vcm vref s7_ctrl
* reference current: bandgap core, 5 uA sourced into bias_dist_pd input 0
XBG vdd_3v3 vss_3v3 ibg en en_b bg_core_pd
* distribution: input 0 on, inputs 1..3 off (tied to vss); outputs 0..2 on, 3 off
XD vdd_3v3 vss_3v3 en en_b ibg vss_3v3 vss_3v3 vss_3v3 vdd_3v3 vss_3v3 vss_3v3 vss_3v3 iprb s7_an_0_iref s7_an_1_iref
+ isp vdd_3v3 vdd_3v3 vdd_3v3 vss_3v3 bias_dist_pd
* replica bias: vcm (S2D vcm = D2S vref) and the S2D vref
XR vdd_3v3 vss_3v3 iprb vcm_rb vref_rb en en_b pad_ref_rb
* same-net joins, written as 0 V sources for simulation (one net each in the layout)
* pad enables and references
Vse0 en s7_an_0_en_3v3 0
Vse1 en s7_an_1_en_3v3 0
Vseb0 en_b s7_an_0_en_3v3_b 0
Vseb1 en_b s7_an_1_en_3v3_b 0
Vsv0 vcm s7_an_0_vcm 0
Vsv1 vcm s7_an_1_vref 0
Vsr0 vref s7_an_0_vref 0
* bus taps 2 / 3 on the pads' vcm / vref (monitor, or external feed with ext; the harness's per-slot switch is the off switch)
Vsb2 vcm analog_bus2 0
Vsb3 vref analog_bus3 0
* unused digital outputs held low
XDO dig_out0 dig_out1 dig_out2 dig_out3 dig_out4 dig_out5 dig_out6 dig_out7 dig_out8 dig_out9 dig_out10 dig_out11
+ vdd_1v2 vss_1v2 vss_3v3 s7_doutpd
.ends slot_7
