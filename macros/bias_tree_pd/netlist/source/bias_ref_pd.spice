* SPDX-FileCopyrightText: 2026 Christoph Maier
* SPDX-License-Identifier: Apache-2.0
* bias_ref_pd: the four bias variants of ../../improvements/sim/d2s_bias_ref.spice with a digital
* enable. Ports as there, plus en_3v3 at the end (0 ... 3.3 V on vdd / vss, active high).
* Disabled (en_3v3 = 0), the root of every current is switched off:
*   - _in / _out: a transmission gate cuts iref off from the input diode NI / PI, and the diode's
*     gate line is pulled to its rail. The external reference is not relied on to switch off.
*   - oa_core / bg_core: MS1, the always-on start-up pull-up, is gated by en_3v3_b; the PMOS mirror
*     gate line vpg is pulled to vdd, and ks to vss.
*   - The other bias lines only carry leakage then; they get no switch of their own.
* Enabled: the switches are off; everything else is d2s_bias_ref unchanged.
* bias_diodes: the four bias diodes BP, BN, BNC, BPC of bias_ref.spice's d2s_bias_diodes. Its class-AB stacks
* RP1 + RP2 / RN1 + RN2 are in the pad since 2026-10-27 (RP2 / RN2 in d2s_mpdda_pd, RP1 / RN1 in d2s_out_p / d2s_out_n since 2026-10-28) (with the replica nets n1 / n2 renamed
* dabp / dabn); so the tree and the cells below have no vddo / vsso, and vabp / vabn are current outputs
* (NABP sinks, PABN sources 5 uA).

* --- the four bias diodes (d2s_bias_lp's six without the class-AB stacks)
.subckt bias_diodes vdd vss vbp vbn vbpc vbnc
XBP vbp vbp vdd vdd sg13_hv_pmos w=5u l=6u ng=1
XBN vbn vbn vss vss sg13_hv_nmos w=6u l=6u ng=1
XBNC vbnc vbnc vss vss sg13_hv_nmos w=1u l=8u ng=1
XBPC vbpc vbpc vdd vdd sg13_hv_pmos w=1u l=4u ng=1
.ends bias_diodes

* --- en_3v3_b for the cells below
.subckt inv_3v3_pd vdd vss en_3v3 en_3v3_b
XIP en_3v3_b en_3v3 vdd vdd sg13_hv_pmos w=1u l=0.45u ng=1
XIN en_3v3_b en_3v3 vss vss sg13_hv_nmos w=1u l=0.45u ng=1
.ends inv_3v3_pd

* --- 1 tree: NI's gate line ni drives the three sinks; BP's gate line the three sources.
*     The transmission gate TGN / TGP sits between the port iref and ni; TDN pulls ni to vss.
.subckt bias_tree_pd vdd vss iref vbp vbn vbpc vbnc vabp vabn en_3v3 en_3v3_b
XTGN iref en_3v3 ni vss sg13_hv_nmos w=1u l=0.45u ng=1
XTGP iref en_3v3_b ni vdd sg13_hv_pmos w=1u l=0.45u ng=1
XTDN ni en_3v3_b vss vss sg13_hv_nmos w=1u l=0.45u ng=1
XNI ni ni vss vss sg13_hv_nmos w=6u l=6u ng=1
XNBP vbp ni vss vss sg13_hv_nmos w=6u l=6u ng=1
XNBPC vbpc ni vss vss sg13_hv_nmos w=2.4u l=6u ng=1
XNABP vabp ni vss vss sg13_hv_nmos w=6u l=6u ng=1
XPBN vbn vbp vdd vdd sg13_hv_pmos w=5u l=6u ng=1
XPBNC vbnc vbp vdd vdd sg13_hv_pmos w=2u l=6u ng=1
XPABN vabn vbp vdd vdd sg13_hv_pmos w=5u l=6u ng=1
Xd vdd vss vbp vbn vbpc vbnc bias_diodes
.ends bias_tree_pd

* --- 1: I_ref into iref (external PMOS source)
.subckt bias_in_pd vdd vss iref vbp vbn vbpc vbnc vabp vabn en_3v3
Xi vdd vss en_3v3 en_3v3_b inv_3v3_pd
Xt vdd vss iref vbp vbn vbpc vbnc vabp vabn en_3v3 en_3v3_b bias_tree_pd
.ends bias_in_pd

* --- 2: I_ref out of iref (external NMOS sink); TG between iref and pi, TDP pulls pi to vdd
.subckt bias_out_pd vdd vss iref vbp vbn vbpc vbnc vabp vabn en_3v3
Xi vdd vss en_3v3 en_3v3_b inv_3v3_pd
XTGN iref en_3v3 pi vss sg13_hv_nmos w=1u l=0.45u ng=1
XTGP iref en_3v3_b pi vdd sg13_hv_pmos w=1u l=0.45u ng=1
XTDP pi en_3v3 vdd vdd sg13_hv_pmos w=1u l=0.45u ng=1
XPI pi pi vdd vdd sg13_hv_pmos w=5u l=6u ng=1
XPBN vbn pi vdd vdd sg13_hv_pmos w=5u l=6u ng=1
XPBNC vbnc pi vdd vdd sg13_hv_pmos w=2u l=6u ng=1
XPABN vabn pi vdd vdd sg13_hv_pmos w=5u l=6u ng=1
XNBP vbp vbn vss vss sg13_hv_nmos w=6u l=6u ng=1
XNBPC vbpc vbn vss vss sg13_hv_nmos w=2.4u l=6u ng=1
XNABP vabp vbn vss vss sg13_hv_nmos w=6u l=6u ng=1
Xd vdd vss vbp vbn vbpc vbnc bias_diodes
.ends bias_out_pd

* --- 3: Oguey-Aebischer core as in bias_ref.spice. Changed: MS1's gate (vss -> en_3v3_b);
*     added SVPG (vpg to vdd) and SKS (ks to vss), both on while disabled.
.subckt oa_core_pd vdd vss iout en_3v3 en_3v3_b
XP0 vpg vpg vdd vdd sg13_hv_pmos w=2u l=8u ng=1
XP0C vpc vpc vpg vdd sg13_hv_pmos w=0.5u l=2u ng=1
XP8 c8 vpg vdd vdd sg13_hv_pmos w=16u l=8u ng=8
XP8C vnc vpc c8 vdd sg13_hv_pmos w=4u l=2u ng=2
XP2 c2 vpg vdd vdd sg13_hv_pmos w=4u l=8u ng=2
XP2C vbr vpc c2 vdd sg13_hv_pmos w=1u l=2u ng=1
XPO co vpg vdd vdd sg13_hv_pmos w=40u l=8u ng=20
XPOC iout vpc co vdd sg13_hv_pmos w=10u l=2u ng=5
XM11 vnc vnc vss vss sg13_hv_nmos w=90u l=1u ng=9
XM10 d10 vnc vres vss sg13_hv_nmos w=180u l=1u ng=18
XMC10 vpc vbr d10 vss sg13_hv_nmos w=10u l=1u ng=1
XMCS vbr vbr vss vss sg13_hv_nmos w=3.4u l=30u ng=1
XMCL vres vbr vss vss sg13_hv_nmos w=3.4u l=30u ng=1
* MS1 (0.5u / 100u) as drawn: 8 x 0.5u / 12.5u in series (compact layout v2, 2026-10-28)
XMS1_0 ms1_1 en_3v3_b vdd vdd sg13_hv_pmos w=0.5u l=12.5u ng=1
XMS1_1 ms1_2 en_3v3_b ms1_1 vdd sg13_hv_pmos w=0.5u l=12.5u ng=1
XMS1_2 ms1_3 en_3v3_b ms1_2 vdd sg13_hv_pmos w=0.5u l=12.5u ng=1
XMS1_3 ms1_4 en_3v3_b ms1_3 vdd sg13_hv_pmos w=0.5u l=12.5u ng=1
XMS1_4 ms1_5 en_3v3_b ms1_4 vdd sg13_hv_pmos w=0.5u l=12.5u ng=1
XMS1_5 ms1_6 en_3v3_b ms1_5 vdd sg13_hv_pmos w=0.5u l=12.5u ng=1
XMS1_6 ms1_7 en_3v3_b ms1_6 vdd sg13_hv_pmos w=0.5u l=12.5u ng=1
XMS1_7 ks en_3v3_b ms1_7 vdd sg13_hv_pmos w=0.5u l=12.5u ng=1
XMS2 ks vbr vss vss sg13_hv_nmos w=10u l=1u ng=1
XMS3 vpc ks vss vss sg13_hv_nmos w=0.5u l=2u ng=1
XSVPG vpg en_3v3 vdd vdd sg13_hv_pmos w=1u l=0.45u ng=1
XSKS ks en_3v3_b vss vss sg13_hv_nmos w=1u l=0.45u ng=1
* dummies of the compact layout v2 (2026-10-28): D = S = bulk, gates on vpg / vnc / vbr
XMDUM0 vdd vpg vdd vdd sg13_hv_pmos w=4.4u l=8u ng=9
XMDUM1 vss vnc vss vss sg13_hv_nmos w=36u l=1u ng=18
XMDUM2 vss vbr vss vss sg13_hv_nmos w=4u l=1u ng=2
.ends oa_core_pd
.subckt bias_oa_pd vdd vss vbp vbn vbpc vbnc vabp vabn en_3v3
Xi vdd vss en_3v3 en_3v3_b inv_3v3_pd
Xc vdd vss iref en_3v3 en_3v3_b oa_core_pd
Xt vdd vss iref vbp vbn vbpc vbnc vabp vabn en_3v3 en_3v3_b bias_tree_pd
.ends bias_oa_pd

* --- 4: bandgap core as in bias_ref.spice, with the same three changes as oa_core_pd.
.subckt bg_core_pd vdd vss iout en_3v3 en_3v3_b
XPB vpg vpg vdd vdd sg13_hv_pmos w=40u l=1u ng=4
XPBC vpc vpc vpg vdd sg13_hv_pmos w=40u l=1u ng=4
XPA ca vpg vdd vdd sg13_hv_pmos w=40u l=1u ng=4
XPAC g vpc ca vdd sg13_hv_pmos w=40u l=1u ng=4
XPO co vpg vdd vdd sg13_hv_pmos w=80u l=1u ng=8
XPOC iout vpc co vdd sg13_hv_pmos w=80u l=1u ng=8
XNA g g ea vss sg13_hv_nmos w=20u l=4u ng=2
XNB vpc g eb vss sg13_hv_nmos w=20u l=4u ng=2
XQ1 vss vss ea pnpMPA a=4p p=8u
* R1A (0.5u / 109.3u) as drawn: 11 x 0.5u / 9.94u in series (compact layout, 2026-10-28)
XR1A[10] ea n1a[9] vss rhigh w=0.5u l=9.94u
XR1A[9] n1a[9] n1a[8] vss rhigh w=0.5u l=9.94u
XR1A[8] n1a[8] n1a[7] vss rhigh w=0.5u l=9.94u
XR1A[7] n1a[7] n1a[6] vss rhigh w=0.5u l=9.94u
XR1A[6] n1a[6] n1a[5] vss rhigh w=0.5u l=9.94u
XR1A[5] n1a[5] n1a[4] vss rhigh w=0.5u l=9.94u
XR1A[4] n1a[4] n1a[3] vss rhigh w=0.5u l=9.94u
XR1A[3] n1a[3] n1a[2] vss rhigh w=0.5u l=9.94u
XR1A[2] n1a[2] n1a[1] vss rhigh w=0.5u l=9.94u
XR1A[1] n1a[1] n1a[0] vss rhigh w=0.5u l=9.94u
XR1A[0] n1a[0] vss vss rhigh w=0.5u l=9.94u
* R0 (0.5u / 179.5u) as drawn: 18 x 0.5u / 9.94u in series
XR0[17] eb n0[16] vss rhigh w=0.5u l=9.94u
XR0[16] n0[16] n0[15] vss rhigh w=0.5u l=9.94u
XR0[15] n0[15] n0[14] vss rhigh w=0.5u l=9.94u
XR0[14] n0[14] n0[13] vss rhigh w=0.5u l=9.94u
XR0[13] n0[13] n0[12] vss rhigh w=0.5u l=9.94u
XR0[12] n0[12] n0[11] vss rhigh w=0.5u l=9.94u
XR0[11] n0[11] n0[10] vss rhigh w=0.5u l=9.94u
XR0[10] n0[10] n0[9] vss rhigh w=0.5u l=9.94u
XR0[9] n0[9] n0[8] vss rhigh w=0.5u l=9.94u
XR0[8] n0[8] n0[7] vss rhigh w=0.5u l=9.94u
XR0[7] n0[7] n0[6] vss rhigh w=0.5u l=9.94u
XR0[6] n0[6] n0[5] vss rhigh w=0.5u l=9.94u
XR0[5] n0[5] n0[4] vss rhigh w=0.5u l=9.94u
XR0[4] n0[4] n0[3] vss rhigh w=0.5u l=9.94u
XR0[3] n0[3] n0[2] vss rhigh w=0.5u l=9.94u
XR0[2] n0[2] n0[1] vss rhigh w=0.5u l=9.94u
XR0[1] n0[1] n0[0] vss rhigh w=0.5u l=9.94u
XR0[0] n0[0] e2 vss rhigh w=0.5u l=9.94u
XQ2 vss vss e2 pnpMPA a=4p p=8u m=8
* R1B (0.5u / 99.36u) as drawn: 10 x 0.5u / 9.94u in series
XR1B[9] eb n1b[8] vss rhigh w=0.5u l=9.94u
XR1B[8] n1b[8] n1b[7] vss rhigh w=0.5u l=9.94u
XR1B[7] n1b[7] n1b[6] vss rhigh w=0.5u l=9.94u
XR1B[6] n1b[6] n1b[5] vss rhigh w=0.5u l=9.94u
XR1B[5] n1b[5] n1b[4] vss rhigh w=0.5u l=9.94u
XR1B[4] n1b[4] n1b[3] vss rhigh w=0.5u l=9.94u
XR1B[3] n1b[3] n1b[2] vss rhigh w=0.5u l=9.94u
XR1B[2] n1b[2] n1b[1] vss rhigh w=0.5u l=9.94u
XR1B[1] n1b[1] n1b[0] vss rhigh w=0.5u l=9.94u
XR1B[0] n1b[0] vss vss rhigh w=0.5u l=9.94u
* MS1 (0.5u / 100u) as drawn: 8 x 0.5u / 12.5u in series
XMS1_0 ms1_1 en_3v3_b vdd vdd sg13_hv_pmos w=0.5u l=12.5u ng=1
XMS1_1 ms1_2 en_3v3_b ms1_1 vdd sg13_hv_pmos w=0.5u l=12.5u ng=1
XMS1_2 ms1_3 en_3v3_b ms1_2 vdd sg13_hv_pmos w=0.5u l=12.5u ng=1
XMS1_3 ms1_4 en_3v3_b ms1_3 vdd sg13_hv_pmos w=0.5u l=12.5u ng=1
XMS1_4 ms1_5 en_3v3_b ms1_4 vdd sg13_hv_pmos w=0.5u l=12.5u ng=1
XMS1_5 ms1_6 en_3v3_b ms1_5 vdd sg13_hv_pmos w=0.5u l=12.5u ng=1
XMS1_6 ms1_7 en_3v3_b ms1_6 vdd sg13_hv_pmos w=0.5u l=12.5u ng=1
XMS1_7 ks en_3v3_b ms1_7 vdd sg13_hv_pmos w=0.5u l=12.5u ng=1
XMS2 ks g vss vss sg13_hv_nmos w=10u l=1u ng=1
XMS3 vpc ks vss vss sg13_hv_nmos w=0.5u l=2u ng=1
XSVPG vpg en_3v3 vdd vdd sg13_hv_pmos w=1u l=0.45u ng=1
XSKS ks en_3v3_b vss vss sg13_hv_nmos w=1u l=0.45u ng=1
* dummies of the compact layout (2026-10-28): PMOS D = S = bulk = vdd on vpg / vpc; NMOS D = S = G = g; rhigh on vss
XMDUM0 vdd vpg vdd vdd sg13_hv_pmos w=2.4u l=1u ng=8
XMDUM1 vdd vpc vdd vdd sg13_hv_pmos w=2.4u l=1u ng=8
XMDUM2 g g g vss sg13_hv_nmos w=2u l=1u ng=1
XMDUM3 g g g vss sg13_hv_nmos w=16u l=4u ng=8
XRDUM[1] vss vss vss rhigh w=0.5u l=9.94u
XRDUM[0] vss vss vss rhigh w=0.5u l=9.94u
.ends bg_core_pd
.subckt bias_bg_pd vdd vss vbp vbn vbpc vbnc vabp vabn en_3v3
Xi vdd vss en_3v3 en_3v3_b inv_3v3_pd
Xc vdd vss iref en_3v3 en_3v3_b bg_core_pd
Xt vdd vss iref vbp vbn vbpc vbnc vabp vabn en_3v3 en_3v3_b bias_tree_pd
.ends bias_bg_pd
