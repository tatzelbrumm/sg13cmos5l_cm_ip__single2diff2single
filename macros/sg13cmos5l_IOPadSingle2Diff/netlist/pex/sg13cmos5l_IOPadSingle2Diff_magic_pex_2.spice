* PEX produced on Thu Nov  5 00:57:07 UTC 2026 using /usr/local/bin/sak-pex.sh with m=2 and s=1
* NGSPICE file created from sg13cmos5l_IOPadSingle2Diff_pex.ext - technology: ihp-sg13cmos5l

.subckt sg13cmos5l_IOPadSingle2Diff_pex iovdd iovss vdd vss pad outp outn vcm
+ vref iref en_3v3 en_3v3_b
X0 iovdd s2d_block_0.s2d_tails_hi_f_0.vbp iovdd iovdd sg13_hv_pmos ad=1.7p pd=10.68u as=0.65663n ps=2.66142m w=5u l=6u
X1 iovss iovss iovss rhigh l=12.65u w=0.5u
X2 s2d_block_0.s2d_loads_f_0.ln s2d_block_0.s2d_loads_f_0.vcmfb iovdd iovdd sg13_hv_pmos ad=2.04p pd=12.68u as=2.04p ps=12.68u w=6u l=4u
X3 s2d_block_0.s2d_loads_f_0.ln s2d_block_0.s2d_casc_p_f_0.vbpc outn iovdd sg13_hv_pmos ad=5.1p pd=30.68u as=5.1p ps=30.68u w=15u l=3u
X4 s2d_block_0.s2d_tails_hi_f_0.sa_A2 a_14374_25646# iovss rhigh l=12.65u w=0.5u
X5 s2d_block_0.s2d_casc_n_f_0.xc s2d_block_0.sinks_6x6_s2d_c3_core_0.vbn iovss iovss sg13_hv_nmos ad=2.04p pd=12.68u as=2.04p ps=12.68u w=6u l=6u
X6 iovdd s2d_block_0.s2d_casc_n_f_0.vbnc s2d_block_0.s2d_casc_n_f_0.yc iovss sg13_hv_nmos ad=5.1p pd=30.68u as=5.1p ps=30.68u w=15u l=3u
X7 Clamp_P_M1_0.gate iovdd iovss rppd l=12.9u w=0.5u
X8 s2d_block_0.s2d_loads_f_0.ln s2d_block_0.s2d_loads_f_0.vcmfb iovdd iovdd sg13_hv_pmos ad=2.04p pd=12.68u as=2.04p ps=12.68u w=6u l=4u
X9 s2d_block_0.s2d_casc_p_f_0.vbpc s2d_block_0.bias_tree_noab_n_c3_0.ni iovss iovss sg13_hv_nmos ad=0.816p pd=5.48u as=0.816p ps=5.48u w=2.4u l=6u
X10 a_11758_27006# a_14374_25510# iovss rhigh l=12.65u w=0.5u
X11 s2d_block_0.s2d_tails_lo_f_0.sa_F1 vcm s2d_block_0.s2d_casc_n_f_0.y s2d_block_0.s2d_tails_lo_f_0.sa_F1 sg13_hv_pmos ad=3.4p pd=20.68u as=1.9p ps=10.38u w=10u l=1u
X12 iovss s2d_block_0.sinks_6x6_s2d_c3_core_0.vbn iovss iovss sg13_hv_nmos ad=0.68p pd=4.68u as=0.75674n ps=2.78086m w=2u l=6u
X13 iovdd Clamp_P_M1_0.gate pad iovdd sg13_hv_pmos ad=2.1312p pd=7.3u as=3.9294p ps=7.84u w=6.66u l=0.6u
X14 iovss s2d_block_0.sinks_6x6_s2d_c3_core_0.vbn s2d_block_0.s2d_casc_n_f_0.xc iovss sg13_hv_nmos ad=2.04p pd=12.68u as=2.04p ps=12.68u w=6u l=6u
X15 s2d_block_0.bias_tree_noab_n_c3_0.ni en_3v3_b iovss iovss sg13_hv_nmos ad=0.34p pd=2.68u as=0.34p ps=2.68u w=1u l=0.45u
X16 iovdd Clamp_P_M1_0.gate pad iovdd sg13_hv_pmos ad=2.1312p pd=7.3u as=3.9294p ps=7.84u w=6.66u l=0.6u
X17 iovss s2d_block_0.sinks_6x6_s2d_c3_core_0.vbn iovss iovss sg13_hv_nmos ad=2.04p pd=12.68u as=0 ps=0 w=6u l=6u
X18 s2d_block_0.s2d_casc_n_f_0.x s2d_block_0.s2d_casc_n_f_0.vbnc outp iovss sg13_hv_nmos ad=5.1p pd=30.68u as=5.1p ps=30.68u w=15u l=3u
X19 s2d_block_0.s2d_casc_n_f_0.x vref s2d_block_0.s2d_tails_lo_f_0.sb_A2 s2d_block_0.s2d_tails_lo_f_0.sb_A2 sg13_hv_pmos ad=1.9p pd=10.38u as=3.4p ps=20.68u w=10u l=1u
X20 iovdd Clamp_P_M1_0.gate pad iovdd sg13_hv_pmos ad=2.1312p pd=7.3u as=3.9294p ps=7.84u w=6.66u l=0.6u
X21 s2d_block_0.s2d_tails_hi_f_0.sb_F1 outp s2d_block_0.s2d_casc_n_f_0.x s2d_block_0.s2d_tails_hi_f_0.sb_F1 sg13_hv_pmos ad=3.4p pd=20.68u as=1.9p ps=10.38u w=10u l=1u
X22 iovdd iovdd iovdd iovdd sg13_hv_pmos ad=1.9p pd=10.38u as=0 ps=0 w=10u l=1u
X23 iovdd s2d_block_0.s2d_tails_hi_f_0.vbp iovdd iovdd sg13_hv_pmos ad=1.7p pd=10.68u as=0 ps=0 w=5u l=6u
X24 s2d_block_0.s2d_casc_n_f_0.y s2d_block_0.sinks_6x6_s2d_c3_core_0.vbn iovss iovss sg13_hv_nmos ad=2.04p pd=12.68u as=2.04p ps=12.68u w=6u l=6u
X25 s2d_block_0.s2d_tails_lo_f_0.sb_A2 a_14374_27278# iovss rhigh l=12.65u w=0.5u
X26 iovdd s2d_block_0.s2d_loads_f_0.vcmfb s2d_block_0.s2d_loads_f_0.dd iovdd sg13_hv_pmos ad=2.04p pd=12.68u as=2.04p ps=12.68u w=6u l=4u
X27 pad Clamp_N_M1_0.gate iovss iovss sg13_hv_nmos ad=2.596p pd=5.58u as=1.408p ps=5.04u w=4.4u l=0.6u
X28 pad Clamp_N_M1_0.gate iovss iovss sg13_hv_nmos ad=2.596p pd=5.58u as=2.068p ps=9.74u w=4.4u l=0.6u
X29 iovdd s2d_block_0.s2d_loads_f_0.vcmfb s2d_block_0.s2d_loads_f_0.lp iovdd sg13_hv_pmos ad=2.04p pd=12.68u as=2.04p ps=12.68u w=6u l=4u
X30 pad Clamp_N_M1_0.gate iovss iovss sg13_hv_nmos ad=2.596p pd=5.58u as=1.408p ps=5.04u w=4.4u l=0.6u
X31 vcm en_3v3_b outp iovss sg13_hv_nmos ad=0.19p pd=1.38u as=0.34p ps=2.68u w=1u l=0.45u
X32 s2d_block_0.s2d_tails_lo_f_0.sa_F1 a_14374_25782# iovss rhigh l=12.65u w=0.5u
X33 a_11758_27006# a_14374_27142# iovss rhigh l=12.65u w=0.5u
X34 iovdd iovdd iovdd iovdd sg13_hv_pmos ad=3.4p pd=20.68u as=0 ps=0 w=10u l=1u
X35 pad Clamp_P_M1_0.gate iovdd iovdd sg13_hv_pmos ad=3.9294p pd=7.84u as=2.1312p ps=7.3u w=6.66u l=0.6u
X36 s2d_block_0.s2d_loads_f_0.lp s2d_block_0.s2d_casc_p_f_0.vbpc outp iovdd sg13_hv_pmos ad=5.1p pd=30.68u as=5.1p ps=30.68u w=15u l=3u
X37 iovdd s2d_block_0.s2d_tails_hi_f_0.vbp s2d_block_0.s2d_tails_hi_f_0.sa_M1 iovdd sg13_hv_pmos ad=1.7p pd=10.68u as=1.7p ps=10.68u w=5u l=6u
X38 s2d_block_0.s2d_casc_n_f_0.y s2d_block_0.sinks_6x6_s2d_c3_core_0.vbn iovss iovss sg13_hv_nmos ad=2.04p pd=12.68u as=2.04p ps=12.68u w=6u l=6u
X39 iovdd Clamp_P_M1_0.gate pad iovdd sg13_hv_pmos ad=2.1312p pd=7.3u as=3.9294p ps=7.84u w=6.66u l=0.6u
X40 iovdd Clamp_P_M1_0.gate pad iovdd sg13_hv_pmos ad=2.1312p pd=7.3u as=3.9294p ps=7.84u w=6.66u l=0.6u
X41 iref en_3v3 s2d_block_0.bias_tree_noab_n_c3_0.ni iovss sg13_hv_nmos ad=0.34p pd=2.68u as=0.34p ps=2.68u w=1u l=0.45u
X42 iovdd Clamp_P_M1_0.gate pad iovdd sg13_hv_pmos ad=2.1312p pd=7.3u as=3.9294p ps=7.84u w=6.66u l=0.6u
X43 pad iovdd dpantenna l=1.26u w=27.78u
X44 pad Clamp_P_M1_0.gate iovdd iovdd sg13_hv_pmos ad=3.9294p pd=7.84u as=2.1312p ps=7.3u w=6.66u l=0.6u
X45 s2d_block_0.s2d_casc_n_f_0.x vcm s2d_block_0.s2d_tails_hi_f_0.sb_F2 s2d_block_0.s2d_tails_hi_f_0.sb_F2 sg13_hv_pmos ad=1.9p pd=10.38u as=3.4p ps=20.68u w=10u l=1u
X46 s2d_block_0.s2d_tails_hi_f_0.sa_A1 a_14374_25510# iovss rhigh l=12.65u w=0.5u
X47 iovss s2d_block_0.sinks_6x6_s2d_c3_core_0.vbn s2d_block_0.s2d_casc_n_f_0.y iovss sg13_hv_nmos ad=2.04p pd=12.68u as=2.04p ps=12.68u w=6u l=6u
X48 s2d_block_0.s2d_tails_hi_f_0.sb_F1 a_14374_27414# iovss rhigh l=12.65u w=0.5u
X49 s2d_block_0.s2d_tails_lo_f_0.sa_F2 outn s2d_block_0.s2d_casc_n_f_0.y s2d_block_0.s2d_tails_lo_f_0.sa_F2 sg13_hv_pmos ad=3.4p pd=20.68u as=1.9p ps=10.38u w=10u l=1u
X50 iovss s2d_block_0.bias_tree_noab_n_c3_0.ni iovss iovss sg13_hv_nmos ad=0.816p pd=5.48u as=0 ps=0 w=2.4u l=6u
X51 s2d_block_0.s2d_casc_n_f_0.y s2d_block_0.s2d_casc_n_f_0.vbnc outn iovss sg13_hv_nmos ad=5.1p pd=30.68u as=5.1p ps=30.68u w=15u l=3u
X52 pad Clamp_N_M1_0.gate iovss iovss sg13_hv_nmos ad=2.596p pd=5.58u as=1.408p ps=5.04u w=4.4u l=0.6u
X53 iovss s2d_block_0.s2d_casc_n_f_0.vbnc iovss iovss sg13_hv_nmos ad=0.68p pd=4.68u as=0 ps=0 w=2u l=3u
X54 iovss pad dantenna l=1.26u w=27.78u
X55 pad Clamp_N_M1_0.gate iovss iovss sg13_hv_nmos ad=2.596p pd=5.58u as=1.408p ps=5.04u w=4.4u l=0.6u
X56 vcm en_3v3 outp iovdd sg13_hv_pmos ad=0.19p pd=1.38u as=0.34p ps=2.68u w=1u l=0.45u
X57 outn en_3v3 vcm iovdd sg13_hv_pmos ad=0.34p pd=2.68u as=0.19p ps=1.38u w=1u l=0.45u
X58 iovdd s2d_block_0.s2d_tails_hi_f_0.vbp s2d_block_0.s2d_tails_hi_f_0.sb_M2 iovdd sg13_hv_pmos ad=1.7p pd=10.68u as=1.7p ps=10.68u w=5u l=6u
X59 iovss s2d_block_0.sinks_6x6_s2d_c3_core_0.vbn s2d_block_0.s2d_casc_n_f_0.y iovss sg13_hv_nmos ad=2.04p pd=12.68u as=2.04p ps=12.68u w=6u l=6u
X60 pad Clamp_P_M1_0.gate iovdd iovdd sg13_hv_pmos ad=3.9294p pd=7.84u as=2.1312p ps=7.3u w=6.66u l=0.6u
X61 iovdd s2d_block_0.s2d_tails_hi_f_0.vbp s2d_block_0.s2d_tails_hi_f_0.sb_F1 iovdd sg13_hv_pmos ad=1.7p pd=10.68u as=1.7p ps=10.68u w=5u l=6u
X62 iovdd s2d_block_0.s2d_loads_f_0.vcmfb s2d_block_0.s2d_loads_f_0.lp iovdd sg13_hv_pmos ad=2.04p pd=12.68u as=2.04p ps=12.68u w=6u l=4u
X63 iovdd Clamp_P_M1_0.gate pad iovdd sg13_hv_pmos ad=2.1312p pd=7.3u as=3.9294p ps=7.84u w=6.66u l=0.6u
X64 a_11758_26734# a_14374_25782# iovss rhigh l=12.65u w=0.5u
X65 pad Clamp_P_M1_0.gate iovdd iovdd sg13_hv_pmos ad=3.9294p pd=7.84u as=2.1312p ps=7.3u w=6.66u l=0.6u
X66 pad Clamp_P_M1_0.gate iovdd iovdd sg13_hv_pmos ad=3.9294p pd=7.84u as=2.1312p ps=7.3u w=6.66u l=0.6u
X67 pad Clamp_P_M1_0.gate iovdd iovdd sg13_hv_pmos ad=3.9294p pd=7.84u as=2.1312p ps=7.3u w=6.66u l=0.6u
X68 s2d_block_0.s2d_tails_hi_f_0.sb_M2 vcm s2d_block_0.s2d_casc_n_f_0.xc s2d_block_0.s2d_tails_hi_f_0.sb_M2 sg13_hv_pmos ad=3.4p pd=20.68u as=1.9p ps=10.38u w=10u l=1u
X69 pad Clamp_P_M1_0.gate iovdd iovdd sg13_hv_pmos ad=3.9294p pd=7.84u as=2.1312p ps=7.3u w=6.66u l=0.6u
X70 iovss Clamp_N_M1_0.gate pad iovss sg13_hv_nmos ad=1.408p pd=5.04u as=2.596p ps=5.58u w=4.4u l=0.6u
X71 iovss Clamp_N_M1_0.gate pad iovss sg13_hv_nmos ad=1.408p pd=5.04u as=2.596p ps=5.58u w=4.4u l=0.6u
X72 iovss iovss iovss rhigh l=12.65u w=0.5u
X73 s2d_block_0.s2d_casc_n_f_0.yc s2d_block_0.s2d_casc_n_f_0.vbnc iovdd iovss sg13_hv_nmos ad=5.1p pd=30.68u as=5.1p ps=30.68u w=15u l=3u
X74 iovdd s2d_block_0.s2d_casc_p_f_0.vbpc iovdd iovdd sg13_hv_pmos ad=0.34p pd=2.68u as=0 ps=0 w=1u l=4u
X75 s2d_block_0.s2d_casc_n_f_0.yc outp s2d_block_0.s2d_tails_hi_f_0.sa_M1 s2d_block_0.s2d_tails_hi_f_0.sa_M1 sg13_hv_pmos ad=1.9p pd=10.38u as=3.4p ps=20.68u w=10u l=1u
X76 s2d_block_0.s2d_casc_n_f_0.y vcm s2d_block_0.s2d_tails_lo_f_0.sa_F1 s2d_block_0.s2d_tails_lo_f_0.sa_F1 sg13_hv_pmos ad=1.9p pd=10.38u as=3.4p ps=20.68u w=10u l=1u
X77 iovdd s2d_block_0.s2d_tails_hi_f_0.vbp s2d_block_0.s2d_tails_hi_f_0.sa_A2 iovdd sg13_hv_pmos ad=1.7p pd=10.68u as=1.7p ps=10.68u w=5u l=6u
X78 s2d_block_0.s2d_tails_hi_f_0.sa_A2 pad s2d_block_0.s2d_casc_n_f_0.y s2d_block_0.s2d_tails_hi_f_0.sa_A2 sg13_hv_pmos ad=3.4p pd=20.68u as=1.9p ps=10.38u w=10u l=1u
X79 iovss s2d_block_0.sinks_6x6_s2d_c3_core_0.vbn s2d_block_0.s2d_casc_n_f_0.yc iovss sg13_hv_nmos ad=2.04p pd=12.68u as=2.04p ps=12.68u w=6u l=6u
X80 iovss s2d_block_0.sinks_6x6_s2d_c3_core_0.vbn iovss iovss sg13_hv_nmos ad=0.68p pd=4.68u as=0 ps=0 w=2u l=6u
X81 s2d_block_0.s2d_tails_hi_f_0.sb_M2 a_14374_27822# iovss rhigh l=12.65u w=0.5u
X82 s2d_block_0.s2d_casc_n_f_0.yc s2d_block_0.sinks_6x6_s2d_c3_core_0.vbn iovss iovss sg13_hv_nmos ad=2.04p pd=12.68u as=2.04p ps=12.68u w=6u l=6u
X83 iovss s2d_block_0.sinks_6x6_s2d_c3_core_0.vbn s2d_block_0.s2d_casc_n_f_0.y iovss sg13_hv_nmos ad=2.04p pd=12.68u as=2.04p ps=12.68u w=6u l=6u
X84 iovdd s2d_block_0.s2d_tails_hi_f_0.vbp s2d_block_0.s2d_tails_hi_f_0.sa_A1 iovdd sg13_hv_pmos ad=1.7p pd=10.68u as=1.7p ps=10.68u w=5u l=6u
X85 a_11758_26870# a_14374_25646# iovss rhigh l=12.65u w=0.5u
X86 s2d_block_0.s2d_casc_n_f_0.vbnc s2d_block_0.s2d_tails_hi_f_0.vbp iovdd iovdd sg13_hv_pmos ad=0.68p pd=4.68u as=0.68p ps=4.68u w=2u l=6u
X87 s2d_block_0.s2d_tails_hi_f_0.sb_F2 a_14374_27550# iovss rhigh l=12.65u w=0.5u
X88 iovdd s2d_block_0.s2d_tails_hi_f_0.vbp iovdd iovdd sg13_hv_pmos ad=1.7p pd=10.68u as=0 ps=0 w=5u l=6u
X89 pad Clamp_P_M1_0.gate iovdd iovdd sg13_hv_pmos ad=3.9294p pd=7.84u as=2.1312p ps=7.3u w=6.66u l=0.6u
X90 pad Clamp_P_M1_0.gate iovdd iovdd sg13_hv_pmos ad=3.9294p pd=7.84u as=2.1312p ps=7.3u w=6.66u l=0.6u
X91 a_11758_26598# a_14374_25918# iovss rhigh l=12.65u w=0.5u
X92 iovss s2d_block_0.sinks_6x6_s2d_c3_core_0.vbn s2d_block_0.s2d_casc_n_f_0.x iovss sg13_hv_nmos ad=2.04p pd=12.68u as=2.04p ps=12.68u w=6u l=6u
X93 s2d_block_0.s2d_loads_f_0.dd s2d_block_0.s2d_loads_f_0.vcmfb iovdd iovdd sg13_hv_pmos ad=2.04p pd=12.68u as=2.04p ps=12.68u w=6u l=4u
X94 pad Clamp_P_M1_0.gate iovdd iovdd sg13_hv_pmos ad=3.9294p pd=7.84u as=2.1312p ps=7.3u w=6.66u l=0.6u
X95 iovss Clamp_N_M1_0.gate pad iovss sg13_hv_nmos ad=1.408p pd=5.04u as=2.596p ps=5.58u w=4.4u l=0.6u
X96 iovdd s2d_block_0.s2d_loads_f_0.vcmfb iovdd iovdd sg13_hv_pmos ad=0.34p pd=2.68u as=0 ps=0 w=1u l=4u
X97 pad iovdd dpantenna l=1.26u w=27.78u
X98 pad Clamp_P_M1_0.gate iovdd iovdd sg13_hv_pmos ad=3.9294p pd=7.84u as=2.1312p ps=7.3u w=6.66u l=0.6u
X99 iovdd s2d_block_0.s2d_loads_f_0.vcmfb s2d_block_0.s2d_loads_f_0.ln iovdd sg13_hv_pmos ad=2.04p pd=12.68u as=2.04p ps=12.68u w=6u l=4u
X100 iovss Clamp_N_M1_0.gate pad iovss sg13_hv_nmos ad=2.068p pd=9.74u as=2.596p ps=5.58u w=4.4u l=0.6u
X101 s2d_block_0.s2d_loads_f_0.lp s2d_block_0.s2d_loads_f_0.vcmfb iovdd iovdd sg13_hv_pmos ad=2.04p pd=12.68u as=2.04p ps=12.68u w=6u l=4u
X102 iovdd s2d_block_0.s2d_loads_f_0.vcmfb s2d_block_0.s2d_loads_f_0.ln iovdd sg13_hv_pmos ad=2.04p pd=12.68u as=2.04p ps=12.68u w=6u l=4u
X103 iovdd s2d_block_0.s2d_casc_p_f_0.vbpc iovdd iovdd sg13_hv_pmos ad=0.34p pd=2.68u as=0 ps=0 w=1u l=4u
X104 pad Clamp_N_M1_0.gate iovss iovss sg13_hv_nmos ad=2.596p pd=5.58u as=1.408p ps=5.04u w=4.4u l=0.6u
X105 s2d_block_0.s2d_tails_lo_f_0.sa_M2 outn s2d_block_0.s2d_casc_n_f_0.yc s2d_block_0.s2d_tails_lo_f_0.sa_M2 sg13_hv_pmos ad=3.4p pd=20.68u as=1.9p ps=10.38u w=10u l=1u
X106 iovdd s2d_block_0.s2d_casc_p_f_0.vbpc s2d_block_0.s2d_casc_p_f_0.vbpc iovdd sg13_hv_pmos ad=0.34p pd=2.68u as=0.34p ps=2.68u w=1u l=4u
X107 iovdd s2d_block_0.s2d_loads_f_0.vcmfb iovdd iovdd sg13_hv_pmos ad=0.34p pd=2.68u as=0 ps=0 w=1u l=4u
X108 s2d_block_0.s2d_casc_n_f_0.y s2d_block_0.sinks_6x6_s2d_c3_core_0.vbn iovss iovss sg13_hv_nmos ad=2.04p pd=12.68u as=2.04p ps=12.68u w=6u l=6u
X109 iovss outp iovss iovss sg13_hv_nmos ad=4.08p pd=24.68u as=0 ps=0 w=12u l=12u
X110 iovss outn iovss iovss sg13_hv_nmos ad=4.08p pd=24.68u as=0 ps=0 w=12u l=12u
X111 iovdd s2d_block_0.s2d_tails_hi_f_0.vbp s2d_block_0.s2d_tails_hi_f_0.sb_F2 iovdd sg13_hv_pmos ad=1.7p pd=10.68u as=1.7p ps=10.68u w=5u l=6u
X112 s2d_block_0.s2d_casc_n_f_0.x outp s2d_block_0.s2d_tails_hi_f_0.sb_F1 s2d_block_0.s2d_tails_hi_f_0.sb_F1 sg13_hv_pmos ad=1.9p pd=10.38u as=3.4p ps=20.68u w=10u l=1u
X113 s2d_block_0.s2d_casc_n_f_0.xc vcm s2d_block_0.s2d_tails_lo_f_0.sb_M1 s2d_block_0.s2d_tails_lo_f_0.sb_M1 sg13_hv_pmos ad=1.9p pd=10.38u as=3.4p ps=20.68u w=10u l=1u
X114 iovss s2d_block_0.sinks_6x6_s2d_c3_core_0.vbn iovss iovss sg13_hv_nmos ad=0.68p pd=4.68u as=0 ps=0 w=2u l=6u
X115 iovdd s2d_block_0.s2d_casc_p_f_0.vbpc iovdd iovdd sg13_hv_pmos ad=0.34p pd=2.68u as=0 ps=0 w=1u l=4u
X116 a_11758_26326# a_14374_26190# iovss rhigh l=12.65u w=0.5u
X117 s2d_block_0.s2d_tails_lo_f_0.sb_A1 vref s2d_block_0.s2d_casc_n_f_0.x s2d_block_0.s2d_tails_lo_f_0.sb_A1 sg13_hv_pmos ad=3.4p pd=20.68u as=1.9p ps=10.38u w=10u l=1u
X118 s2d_block_0.s2d_casc_n_f_0.x s2d_block_0.sinks_6x6_s2d_c3_core_0.vbn iovss iovss sg13_hv_nmos ad=2.04p pd=12.68u as=2.04p ps=12.68u w=6u l=6u
X119 iovdd Clamp_P_M1_0.gate pad iovdd sg13_hv_pmos ad=2.1312p pd=7.3u as=3.9294p ps=7.84u w=6.66u l=0.6u
X120 s2d_block_0.s2d_tails_lo_f_0.sb_M1 a_14374_27686# iovss rhigh l=12.65u w=0.5u
X121 iovss s2d_block_0.sinks_6x6_s2d_c3_core_0.vbn iovss iovss sg13_hv_nmos ad=0.68p pd=4.68u as=0 ps=0 w=2u l=6u
X122 iovdd Clamp_P_M1_0.gate pad iovdd sg13_hv_pmos ad=2.1312p pd=7.3u as=3.9294p ps=7.84u w=6.66u l=0.6u
X123 s2d_block_0.s2d_tails_hi_f_0.sa_A1 pad s2d_block_0.s2d_casc_n_f_0.y s2d_block_0.s2d_tails_hi_f_0.sa_A1 sg13_hv_pmos ad=3.4p pd=20.68u as=1.9p ps=10.38u w=10u l=1u
X124 s2d_block_0.s2d_tails_lo_f_0.sb_M1 s2d_block_0.s2d_tails_hi_f_0.vbp iovdd iovdd sg13_hv_pmos ad=1.7p pd=10.68u as=1.7p ps=10.68u w=5u l=6u
X125 pad Clamp_P_M1_0.gate iovdd iovdd sg13_hv_pmos ad=3.9294p pd=7.84u as=2.1312p ps=7.3u w=6.66u l=0.6u
X126 iovdd iovdd iovdd iovdd sg13_hv_pmos ad=3.4p pd=20.68u as=0 ps=0 w=10u l=1u
X127 a_11758_26326# a_14374_27822# iovss rhigh l=12.65u w=0.5u
X128 s2d_block_0.s2d_casc_n_f_0.xc s2d_block_0.sinks_6x6_s2d_c3_core_0.vbn iovss iovss sg13_hv_nmos ad=2.04p pd=12.68u as=2.04p ps=12.68u w=6u l=6u
X129 pad Clamp_N_M1_0.gate iovss iovss sg13_hv_nmos ad=2.596p pd=5.58u as=1.408p ps=5.04u w=4.4u l=0.6u
X130 pad Clamp_N_M1_0.gate iovss iovss sg13_hv_nmos ad=2.596p pd=5.58u as=1.408p ps=5.04u w=4.4u l=0.6u
X131 iovdd Clamp_P_M1_0.gate pad iovdd sg13_hv_pmos ad=2.1312p pd=7.3u as=3.9294p ps=7.84u w=6.66u l=0.6u
X132 s2d_block_0.bias_tree_noab_n_c3_0.ni en_3v3_b iref iovdd sg13_hv_pmos ad=0.34p pd=2.68u as=0.34p ps=2.68u w=1u l=0.45u
X133 pad Clamp_P_M1_0.gate iovdd iovdd sg13_hv_pmos ad=3.9294p pd=7.84u as=3.1302p ps=14.26u w=6.66u l=0.6u
X134 pad Clamp_N_M1_0.gate iovss iovss sg13_hv_nmos ad=2.596p pd=5.58u as=1.408p ps=5.04u w=4.4u l=0.6u
X135 a_11758_26462# a_14374_26054# iovss rhigh l=12.65u w=0.5u
X136 s2d_block_0.s2d_loads_f_0.dd s2d_block_0.s2d_loads_f_0.vcmfb iovdd iovdd sg13_hv_pmos ad=2.04p pd=12.68u as=2.04p ps=12.68u w=6u l=4u
X137 iovss s2d_block_0.sinks_6x6_s2d_c3_core_0.vbn iovss iovss sg13_hv_nmos ad=0.68p pd=4.68u as=0 ps=0 w=2u l=6u
X138 iovdd iovdd iovdd iovdd sg13_hv_pmos ad=1.9p pd=10.38u as=0 ps=0 w=10u l=1u
X139 s2d_block_0.s2d_loads_f_0.vcmfb s2d_block_0.s2d_casc_p_f_0.vbpc s2d_block_0.s2d_loads_f_0.dd iovdd sg13_hv_pmos ad=5.1p pd=30.68u as=5.1p ps=30.68u w=15u l=3u
X140 iovdd s2d_block_0.s2d_tails_hi_f_0.vbp s2d_block_0.s2d_tails_hi_f_0.vbp iovdd sg13_hv_pmos ad=1.7p pd=10.68u as=1.7p ps=10.68u w=5u l=6u
X141 s2d_block_0.bias_tree_noab_n_c3_0.ni s2d_block_0.bias_tree_noab_n_c3_0.ni iovss iovss sg13_hv_nmos ad=2.04p pd=12.68u as=2.04p ps=12.68u w=6u l=6u
X142 iovdd Clamp_P_M1_0.gate pad iovdd sg13_hv_pmos ad=2.1312p pd=7.3u as=3.9294p ps=7.84u w=6.66u l=0.6u
X143 s2d_block_0.s2d_tails_lo_f_0.sa_M2 s2d_block_0.s2d_tails_hi_f_0.vbp iovdd iovdd sg13_hv_pmos ad=1.7p pd=10.68u as=1.7p ps=10.68u w=5u l=6u
X144 outn s2d_block_0.s2d_casc_n_f_0.vbnc s2d_block_0.s2d_casc_n_f_0.y iovss sg13_hv_nmos ad=5.1p pd=30.68u as=5.1p ps=30.68u w=15u l=3u
X145 iovdd Clamp_P_M1_0.gate pad iovdd sg13_hv_pmos ad=2.1312p pd=7.3u as=3.9294p ps=7.84u w=6.66u l=0.6u
X146 iovdd Clamp_P_M1_0.gate pad iovdd sg13_hv_pmos ad=2.1312p pd=7.3u as=3.9294p ps=7.84u w=6.66u l=0.6u
X147 s2d_block_0.s2d_casc_n_f_0.yc s2d_block_0.sinks_6x6_s2d_c3_core_0.vbn iovss iovss sg13_hv_nmos ad=2.04p pd=12.68u as=2.04p ps=12.68u w=6u l=6u
X148 s2d_block_0.s2d_casc_n_f_0.xc vcm s2d_block_0.s2d_tails_hi_f_0.sb_M2 s2d_block_0.s2d_tails_hi_f_0.sb_M2 sg13_hv_pmos ad=1.9p pd=10.38u as=3.4p ps=20.68u w=10u l=1u
X149 s2d_block_0.s2d_casc_n_f_0.y outn s2d_block_0.s2d_tails_lo_f_0.sa_F2 s2d_block_0.s2d_tails_lo_f_0.sa_F2 sg13_hv_pmos ad=1.9p pd=10.38u as=3.4p ps=20.68u w=10u l=1u
X150 s2d_block_0.s2d_tails_hi_f_0.sa_M1 outp s2d_block_0.s2d_casc_n_f_0.yc s2d_block_0.s2d_tails_hi_f_0.sa_M1 sg13_hv_pmos ad=3.4p pd=20.68u as=1.9p ps=10.38u w=10u l=1u
X151 pad Clamp_P_M1_0.gate iovdd iovdd sg13_hv_pmos ad=3.9294p pd=7.84u as=2.1312p ps=7.3u w=6.66u l=0.6u
X152 s2d_block_0.s2d_tails_lo_f_0.sa_F2 a_14374_25918# iovss rhigh l=12.65u w=0.5u
X153 s2d_block_0.sinks_6x6_s2d_c3_core_0.vbn s2d_block_0.sinks_6x6_s2d_c3_core_0.vbn iovss iovss sg13_hv_nmos ad=2.04p pd=12.68u as=2.04p ps=12.68u w=6u l=6u
X154 iovdd Clamp_P_M1_0.gate pad iovdd sg13_hv_pmos ad=2.1312p pd=7.3u as=3.9294p ps=7.84u w=6.66u l=0.6u
X155 iovss s2d_block_0.s2d_casc_n_f_0.vbnc iovss iovss sg13_hv_nmos ad=0.68p pd=4.68u as=0 ps=0 w=2u l=3u
X156 s2d_block_0.s2d_tails_lo_f_0.sa_F2 s2d_block_0.s2d_tails_hi_f_0.vbp iovdd iovdd sg13_hv_pmos ad=1.7p pd=10.68u as=1.7p ps=10.68u w=5u l=6u
X157 iovss Clamp_N_M1_0.gate pad iovss sg13_hv_nmos ad=1.408p pd=5.04u as=2.596p ps=5.58u w=4.4u l=0.6u
X158 s2d_block_0.s2d_tails_lo_f_0.sb_A2 vref s2d_block_0.s2d_casc_n_f_0.x s2d_block_0.s2d_tails_lo_f_0.sb_A2 sg13_hv_pmos ad=3.4p pd=20.68u as=1.9p ps=10.38u w=10u l=1u
X159 pad Clamp_N_M1_0.gate iovss iovss sg13_hv_nmos ad=2.596p pd=5.58u as=1.408p ps=5.04u w=4.4u l=0.6u
X160 a_11758_26462# a_14374_27686# iovss rhigh l=12.65u w=0.5u
X161 s2d_block_0.s2d_casc_n_f_0.x s2d_block_0.sinks_6x6_s2d_c3_core_0.vbn iovss iovss sg13_hv_nmos ad=2.04p pd=12.68u as=2.04p ps=12.68u w=6u l=6u
X162 iovdd Clamp_P_M1_0.gate pad iovdd sg13_hv_pmos ad=2.1312p pd=7.3u as=3.9294p ps=7.84u w=6.66u l=0.6u
X163 s2d_block_0.s2d_tails_hi_f_0.vbp s2d_block_0.bias_tree_noab_n_c3_0.ni iovss iovss sg13_hv_nmos ad=2.04p pd=12.68u as=2.04p ps=12.68u w=6u l=6u
X164 pad Clamp_P_M1_0.gate iovdd iovdd sg13_hv_pmos ad=3.9294p pd=7.84u as=3.1302p ps=14.26u w=6.66u l=0.6u
X165 iovdd iovdd iovdd iovdd sg13_hv_pmos ad=3.4p pd=20.68u as=0 ps=0 w=10u l=1u
X166 iovss s2d_block_0.sinks_6x6_s2d_c3_core_0.vbn s2d_block_0.s2d_casc_n_f_0.xc iovss sg13_hv_nmos ad=2.04p pd=12.68u as=2.04p ps=12.68u w=6u l=6u
X167 Clamp_N_M1_0.gate iovss iovss rppd l=3.54u w=0.5u
X168 iovdd Clamp_P_M1_0.gate pad iovdd sg13_hv_pmos ad=2.1312p pd=7.3u as=3.9294p ps=7.84u w=6.66u l=0.6u
X169 iovss s2d_block_0.s2d_casc_n_f_0.vbnc iovss iovss sg13_hv_nmos ad=0.68p pd=4.68u as=0 ps=0 w=2u l=3u
X170 iovdd iovdd iovdd iovdd sg13_hv_pmos ad=1.9p pd=10.38u as=0 ps=0 w=10u l=1u
X171 s2d_block_0.s2d_tails_lo_f_0.sb_A1 s2d_block_0.s2d_tails_hi_f_0.vbp iovdd iovdd sg13_hv_pmos ad=1.7p pd=10.68u as=1.7p ps=10.68u w=5u l=6u
X172 pad Clamp_P_M1_0.gate iovdd iovdd sg13_hv_pmos ad=3.9294p pd=7.84u as=2.1312p ps=7.3u w=6.66u l=0.6u
X173 a_11758_26734# a_14374_27414# iovss rhigh l=12.65u w=0.5u
X174 pad Clamp_P_M1_0.gate iovdd iovdd sg13_hv_pmos ad=3.9294p pd=7.84u as=2.1312p ps=7.3u w=6.66u l=0.6u
X175 iovdd Clamp_P_M1_0.gate pad iovdd sg13_hv_pmos ad=2.1312p pd=7.3u as=3.9294p ps=7.84u w=6.66u l=0.6u
X176 iovdd Clamp_P_M1_0.gate pad iovdd sg13_hv_pmos ad=3.1302p pd=14.26u as=3.9294p ps=7.84u w=6.66u l=0.6u
X177 outn s2d_block_0.s2d_casc_p_f_0.vbpc s2d_block_0.s2d_loads_f_0.ln iovdd sg13_hv_pmos ad=5.1p pd=30.68u as=5.1p ps=30.68u w=15u l=3u
X178 s2d_block_0.s2d_casc_n_f_0.y pad s2d_block_0.s2d_tails_hi_f_0.sa_A2 s2d_block_0.s2d_tails_hi_f_0.sa_A2 sg13_hv_pmos ad=1.9p pd=10.38u as=3.4p ps=20.68u w=10u l=1u
X179 pad Clamp_P_M1_0.gate iovdd iovdd sg13_hv_pmos ad=3.9294p pd=7.84u as=2.1312p ps=7.3u w=6.66u l=0.6u
X180 iovss Clamp_N_M1_0.gate pad iovss sg13_hv_nmos ad=1.408p pd=5.04u as=2.596p ps=5.58u w=4.4u l=0.6u
X181 s2d_block_0.s2d_casc_n_f_0.yc outn s2d_block_0.s2d_tails_lo_f_0.sa_M2 s2d_block_0.s2d_tails_lo_f_0.sa_M2 sg13_hv_pmos ad=1.9p pd=10.38u as=3.4p ps=20.68u w=10u l=1u
X182 s2d_block_0.s2d_tails_lo_f_0.sb_A2 s2d_block_0.s2d_tails_hi_f_0.vbp iovdd iovdd sg13_hv_pmos ad=1.7p pd=10.68u as=1.7p ps=10.68u w=5u l=6u
X183 iovss s2d_block_0.sinks_6x6_s2d_c3_core_0.vbn s2d_block_0.s2d_casc_n_f_0.x iovss sg13_hv_nmos ad=2.04p pd=12.68u as=2.04p ps=12.68u w=6u l=6u
X184 iovss Clamp_N_M1_0.gate pad iovss sg13_hv_nmos ad=1.408p pd=5.04u as=2.596p ps=5.58u w=4.4u l=0.6u
X185 s2d_block_0.s2d_loads_f_0.lp s2d_block_0.s2d_loads_f_0.vcmfb iovdd iovdd sg13_hv_pmos ad=2.04p pd=12.68u as=2.04p ps=12.68u w=6u l=4u
X186 s2d_block_0.sinks_6x6_s2d_c3_core_0.vbn s2d_block_0.s2d_tails_hi_f_0.vbp iovdd iovdd sg13_hv_pmos ad=1.7p pd=10.68u as=1.7p ps=10.68u w=5u l=6u
X187 s2d_block_0.s2d_tails_lo_f_0.sb_M1 vcm s2d_block_0.s2d_casc_n_f_0.xc s2d_block_0.s2d_tails_lo_f_0.sb_M1 sg13_hv_pmos ad=3.4p pd=20.68u as=1.9p ps=10.38u w=10u l=1u
X188 outp s2d_block_0.s2d_casc_n_f_0.vbnc s2d_block_0.s2d_casc_n_f_0.x iovss sg13_hv_nmos ad=5.1p pd=30.68u as=5.1p ps=30.68u w=15u l=3u
X189 s2d_block_0.s2d_tails_hi_f_0.sa_M1 a_14374_26054# iovss rhigh l=12.65u w=0.5u
X190 iovss Clamp_N_M1_0.gate pad iovss sg13_hv_nmos ad=1.408p pd=5.04u as=2.596p ps=5.58u w=4.4u l=0.6u
X191 iovss s2d_block_0.s2d_casc_n_f_0.vbnc iovss iovss sg13_hv_nmos ad=0.68p pd=4.68u as=0 ps=0 w=2u l=3u
X192 iovss s2d_block_0.sinks_6x6_s2d_c3_core_0.vbn s2d_block_0.s2d_casc_n_f_0.x iovss sg13_hv_nmos ad=2.04p pd=12.68u as=2.04p ps=12.68u w=6u l=6u
X193 iovss s2d_block_0.sinks_6x6_s2d_c3_core_0.vbn iovss iovss sg13_hv_nmos ad=0.68p pd=4.68u as=0 ps=0 w=2u l=6u
X194 iovdd s2d_block_0.s2d_loads_f_0.vcmfb iovdd iovdd sg13_hv_pmos ad=0.34p pd=2.68u as=0 ps=0 w=1u l=4u
X195 outn en_3v3_b vcm iovss sg13_hv_nmos ad=0.34p pd=2.68u as=0.19p ps=1.38u w=1u l=0.45u
X196 s2d_block_0.s2d_tails_hi_f_0.sb_F2 vcm s2d_block_0.s2d_casc_n_f_0.x s2d_block_0.s2d_tails_hi_f_0.sb_F2 sg13_hv_pmos ad=3.4p pd=20.68u as=1.9p ps=10.38u w=10u l=1u
X197 iovss s2d_block_0.sinks_6x6_s2d_c3_core_0.vbn iovss iovss sg13_hv_nmos ad=0.68p pd=4.68u as=0 ps=0 w=2u l=6u
X198 s2d_block_0.s2d_casc_n_f_0.x s2d_block_0.sinks_6x6_s2d_c3_core_0.vbn iovss iovss sg13_hv_nmos ad=2.04p pd=12.68u as=2.04p ps=12.68u w=6u l=6u
X199 s2d_block_0.s2d_casc_n_f_0.y pad s2d_block_0.s2d_tails_hi_f_0.sa_A1 s2d_block_0.s2d_tails_hi_f_0.sa_A1 sg13_hv_pmos ad=1.9p pd=10.38u as=3.4p ps=20.68u w=10u l=1u
X200 s2d_block_0.s2d_tails_lo_f_0.sb_A1 a_14374_27142# iovss rhigh l=12.65u w=0.5u
X201 iovdd s2d_block_0.s2d_loads_f_0.vcmfb s2d_block_0.s2d_loads_f_0.dd iovdd sg13_hv_pmos ad=2.04p pd=12.68u as=2.04p ps=12.68u w=6u l=4u
X202 iovdd iovdd iovdd iovdd sg13_hv_pmos ad=1.9p pd=10.38u as=0 ps=0 w=10u l=1u
X203 iovdd Clamp_P_M1_0.gate pad iovdd sg13_hv_pmos ad=2.1312p pd=7.3u as=3.9294p ps=7.84u w=6.66u l=0.6u
X204 iovdd s2d_block_0.s2d_loads_f_0.vcmfb iovdd iovdd sg13_hv_pmos ad=0.34p pd=2.68u as=0 ps=0 w=1u l=4u
X205 a_11758_26598# a_14374_27550# iovss rhigh l=12.65u w=0.5u
X206 s2d_block_0.s2d_casc_n_f_0.xc s2d_block_0.s2d_casc_n_f_0.vbnc s2d_block_0.s2d_loads_f_0.vcmfb iovss sg13_hv_nmos ad=5.1p pd=30.68u as=5.1p ps=30.68u w=15u l=3u
X207 pad Clamp_P_M1_0.gate iovdd iovdd sg13_hv_pmos ad=3.9294p pd=7.84u as=2.1312p ps=7.3u w=6.66u l=0.6u
X208 s2d_block_0.s2d_tails_lo_f_0.sa_F1 s2d_block_0.s2d_tails_hi_f_0.vbp iovdd iovdd sg13_hv_pmos ad=1.7p pd=10.68u as=1.7p ps=10.68u w=5u l=6u
X209 iovdd Clamp_P_M1_0.gate pad iovdd sg13_hv_pmos ad=3.1302p pd=14.26u as=3.9294p ps=7.84u w=6.66u l=0.6u
X210 outp s2d_block_0.s2d_casc_p_f_0.vbpc s2d_block_0.s2d_loads_f_0.lp iovdd sg13_hv_pmos ad=5.1p pd=30.68u as=5.1p ps=30.68u w=15u l=3u
X211 iovdd s2d_block_0.s2d_tails_hi_f_0.vbp iovdd iovdd sg13_hv_pmos ad=0.68p pd=4.68u as=0 ps=0 w=2u l=6u
X212 a_11758_26870# a_14374_27278# iovss rhigh l=12.65u w=0.5u
X213 s2d_block_0.s2d_casc_n_f_0.vbnc s2d_block_0.s2d_casc_n_f_0.vbnc iovss iovss sg13_hv_nmos ad=0.34p pd=2.68u as=0.34p ps=2.68u w=1u l=8u
X214 pad Clamp_P_M1_0.gate iovdd iovdd sg13_hv_pmos ad=3.9294p pd=7.84u as=2.1312p ps=7.3u w=6.66u l=0.6u
X215 iovss s2d_block_0.sinks_6x6_s2d_c3_core_0.vbn s2d_block_0.s2d_casc_n_f_0.yc iovss sg13_hv_nmos ad=2.04p pd=12.68u as=2.04p ps=12.68u w=6u l=6u
X216 iovss Clamp_N_M1_0.gate pad iovss sg13_hv_nmos ad=1.408p pd=5.04u as=2.596p ps=5.58u w=4.4u l=0.6u
X217 s2d_block_0.s2d_tails_lo_f_0.sa_M2 a_14374_26190# iovss rhigh l=12.65u w=0.5u
X218 s2d_block_0.s2d_loads_f_0.vcmfb s2d_block_0.s2d_casc_n_f_0.vbnc s2d_block_0.s2d_casc_n_f_0.xc iovss sg13_hv_nmos ad=5.1p pd=30.68u as=5.1p ps=30.68u w=15u l=3u
X219 iovss pad dantenna l=1.26u w=27.78u
X220 s2d_block_0.s2d_loads_f_0.dd s2d_block_0.s2d_casc_p_f_0.vbpc s2d_block_0.s2d_loads_f_0.vcmfb iovdd sg13_hv_pmos ad=5.1p pd=30.68u as=5.1p ps=30.68u w=15u l=3u
X221 iovdd iovdd iovdd iovdd sg13_hv_pmos ad=3.4p pd=20.68u as=0 ps=0 w=10u l=1u
X222 s2d_block_0.s2d_casc_n_f_0.x vref s2d_block_0.s2d_tails_lo_f_0.sb_A1 s2d_block_0.s2d_tails_lo_f_0.sb_A1 sg13_hv_pmos ad=1.9p pd=10.38u as=3.4p ps=20.68u w=10u l=1u
X223 iovss Clamp_N_M1_0.gate pad iovss sg13_hv_nmos ad=1.408p pd=5.04u as=2.596p ps=5.58u w=4.4u l=0.6u
X224 iovss s2d_block_0.sinks_6x6_s2d_c3_core_0.vbn iovss iovss sg13_hv_nmos ad=0.68p pd=4.68u as=0 ps=0 w=2u l=6u
C0 s2d_block_0.s2d_tails_hi_f_0.sb_F2 s2d_block_0.s2d_casc_n_f_0.x 4.74734f
C1 outp s2d_block_0.s2d_casc_n_f_0.x 0.87989f
C2 a_11844_26326# a_11844_26462# 0.63642f
C3 iovdd s2d_block_0.s2d_tails_hi_f_0.vbp 67.0717f
C4 s2d_block_0.s2d_loads_f_0.vcmfb s2d_block_0.s2d_casc_n_f_0.xc 1.61182f
C5 a_14374_25782# a_11844_26734# 0.02713f
C6 vdd s2d_block_0.s2d_tails_hi_f_0.sb_M2 0.09122f
C7 s2d_block_0.s2d_tails_lo_f_0.sb_A1 s2d_block_0.s2d_tails_lo_f_0.sa_F2 0.21993f
C8 pad s2d_block_0.s2d_tails_lo_f_0.sa_F1 0.06589f
C9 s2d_block_0.s2d_tails_hi_f_0.sb_F2 a_11844_26462# 0.02158f
C10 s2d_block_0.s2d_loads_f_0.lp s2d_block_0.s2d_loads_f_0.dd 3.89965f
C11 s2d_block_0.s2d_casc_n_f_0.xc s2d_block_0.s2d_tails_lo_f_0.sa_F1 0.04682f
C12 s2d_block_0.s2d_casc_n_f_0.x s2d_block_0.s2d_tails_lo_f_0.sb_A1 1.08045f
C13 vref s2d_block_0.s2d_casc_n_f_0.yc 0.03751f
C14 outp s2d_block_0.s2d_loads_f_0.vcmfb 10.7502f
C15 a_14374_25782# a_14374_25646# 1.00966f
C16 s2d_block_0.s2d_casc_n_f_0.y s2d_block_0.s2d_tails_lo_f_0.sb_A2 0.34721f
C17 pad s2d_block_0.sinks_6x6_s2d_c3_core_0.vbn 0.07772f
C18 s2d_block_0.s2d_tails_hi_f_0.sb_F2 a_11844_25510# 0.02158f
C19 outn s2d_block_0.s2d_loads_f_0.ln 0.36237f
C20 outn s2d_block_0.s2d_casc_n_f_0.y 0.87704f
C21 a_14374_27414# s2d_block_0.sinks_6x6_s2d_c3_core_0.vbn 0.0119f
C22 s2d_block_0.s2d_loads_f_0.ln s2d_block_0.s2d_casc_p_f_0.vbpc 1.72075f
C23 outn s2d_block_0.s2d_tails_lo_f_0.sb_M1 0.03057f
C24 s2d_block_0.sinks_6x6_s2d_c3_core_0.vbn s2d_block_0.s2d_casc_n_f_0.xc 5.64586f
C25 s2d_block_0.s2d_casc_n_f_0.yc s2d_block_0.s2d_tails_hi_f_0.vbp 0.07996f
C26 outp s2d_block_0.s2d_tails_lo_f_0.sa_F1 0.15517f
C27 s2d_block_0.s2d_casc_p_f_0.vbpc s2d_block_0.s2d_tails_lo_f_0.sb_M1 0.01817f
C28 s2d_block_0.s2d_tails_hi_f_0.vbp s2d_block_0.s2d_casc_n_f_0.vbnc 0.11962f
C29 vcm s2d_block_0.s2d_casc_n_f_0.x 0.63386f
C30 a_11844_25646# s2d_block_0.s2d_tails_hi_f_0.sa_A2 0.08082f
C31 s2d_block_0.s2d_tails_hi_f_0.sa_A1 s2d_block_0.s2d_tails_hi_f_0.sa_A2 5.41603f
C32 s2d_block_0.s2d_tails_lo_f_0.sb_A1 s2d_block_0.s2d_tails_lo_f_0.sa_F1 0.84022f
C33 a_11758_27006# a_11844_27006# 0.01971f
C34 a_11758_26870# s2d_block_0.s2d_tails_lo_f_0.sb_M1 0.0482f
C35 s2d_block_0.s2d_tails_hi_f_0.sa_A1 s2d_block_0.s2d_tails_lo_f_0.sa_M2 0.05843f
C36 s2d_block_0.s2d_tails_hi_f_0.sb_F2 s2d_block_0.sinks_6x6_s2d_c3_core_0.vbn 0.5387f
C37 outp s2d_block_0.sinks_6x6_s2d_c3_core_0.vbn 0.0236f
C38 a_7760_4632# Clamp_N_M1_0.gate 0.02705f
C39 iovdd s2d_block_0.s2d_loads_f_0.dd 10.6422f
C40 a_11844_27278# a_11758_26870# 0.01953f
C41 a_11758_26734# a_11758_26598# 0.78325f
C42 a_11844_26598# a_11844_26462# 0.63642f
C43 s2d_block_0.s2d_tails_hi_f_0.vbp s2d_block_0.s2d_tails_hi_f_0.sb_M2 0.57373f
C44 pad s2d_block_0.s2d_tails_hi_f_0.sa_M1 0.07327f
C45 a_11844_28230# s2d_block_0.s2d_tails_hi_f_0.sb_F1 0.03104f
C46 s2d_block_0.s2d_tails_hi_f_0.sb_F2 a_11844_27550# 0.0248f
C47 en_3v3 en_3v3_b 0.28127f
C48 s2d_block_0.s2d_tails_hi_f_0.sb_F2 a_11844_27958# 0.04246f
C49 s2d_block_0.s2d_casc_n_f_0.xc s2d_block_0.s2d_tails_hi_f_0.sa_M1 0.21204f
C50 vcm s2d_block_0.s2d_tails_lo_f_0.sa_F1 2.76655f
C51 s2d_block_0.s2d_loads_f_0.lp outn 0.10561f
C52 s2d_block_0.s2d_loads_f_0.lp s2d_block_0.s2d_casc_p_f_0.vbpc 1.79896f
C53 a_8120_4634# a_7760_4632# 0.05849f
C54 a_11844_25782# s2d_block_0.s2d_tails_hi_f_0.sb_F1 0.0102f
C55 a_11844_26326# s2d_block_0.s2d_tails_hi_f_0.sa_M1 0.01916f
C56 s2d_block_0.s2d_casc_n_f_0.y s2d_block_0.s2d_tails_hi_f_0.sa_A2 1.08046f
C57 s2d_block_0.s2d_tails_lo_f_0.sb_M1 s2d_block_0.s2d_tails_hi_f_0.sa_A2 0.04748f
C58 s2d_block_0.bias_tree_noab_n_c3_0.ni s2d_block_0.sinks_6x6_s2d_c3_core_0.vbn 0.01864f
C59 s2d_block_0.s2d_tails_hi_f_0.sb_F2 s2d_block_0.s2d_tails_hi_f_0.sa_M1 0.02465f
C60 s2d_block_0.s2d_tails_lo_f_0.sa_M2 s2d_block_0.s2d_tails_lo_f_0.sb_M1 0.59445f
C61 vref vdd 1.72018f
C62 outp s2d_block_0.s2d_tails_hi_f_0.sa_M1 3.63692f
C63 en_3v3 outn 2.58957f
C64 Clamp_N_M1_0.gate iovdd 0.31292f
C65 s2d_block_0.s2d_loads_f_0.dd s2d_block_0.s2d_casc_n_f_0.yc 1.54595f
C66 en_3v3 s2d_block_0.s2d_casc_p_f_0.vbpc 0.15115f
C67 a_11844_28502# s2d_block_0.s2d_tails_lo_f_0.sb_A2 0.02094f
C68 pad s2d_block_0.s2d_casc_n_f_0.xc 0.0794f
C69 vdd s2d_block_0.s2d_tails_hi_f_0.vbp 3.45659f
C70 s2d_block_0.s2d_tails_lo_f_0.sb_A1 s2d_block_0.s2d_tails_hi_f_0.sa_M1 0.02784f
C71 en_3v3_b iovdd 0.41196f
C72 a_11844_28094# s2d_block_0.s2d_tails_lo_f_0.sb_M1 0.02626f
C73 a_8120_4634# iovdd 0.08872f
C74 a_11844_27414# a_11844_27550# 0.63642f
C75 s2d_block_0.s2d_tails_hi_f_0.sa_A1 s2d_block_0.s2d_tails_lo_f_0.sa_F2 0.04602f
C76 s2d_block_0.s2d_tails_hi_f_0.sb_F1 s2d_block_0.s2d_tails_lo_f_0.sb_A2 0.58509f
C77 a_11844_27686# a_11758_26462# 0.01935f
C78 s2d_block_0.s2d_tails_hi_f_0.sb_F2 a_11844_26870# 0.02235f
C79 outn s2d_block_0.s2d_tails_hi_f_0.sb_F1 2.08525f
C80 iovdd s2d_block_0.s2d_tails_lo_f_0.sb_A2 1.27584f
C81 s2d_block_0.s2d_tails_hi_f_0.sb_F2 pad 0.22487f
C82 s2d_block_0.s2d_casc_p_f_0.vbpc s2d_block_0.s2d_tails_hi_f_0.sb_F1 0.11357f
C83 s2d_block_0.s2d_tails_hi_f_0.sa_A1 s2d_block_0.s2d_casc_n_f_0.x 0.30215f
C84 outp pad 0.37132f
C85 Clamp_N_M1_0.gate s2d_block_0.s2d_casc_n_f_0.vbnc 0.01177f
C86 s2d_block_0.s2d_tails_hi_f_0.sb_F2 s2d_block_0.s2d_casc_n_f_0.xc 0.03286f
C87 outp s2d_block_0.s2d_casc_n_f_0.xc 0.12002f
C88 iovdd outn 17.1112f
C89 vcm s2d_block_0.s2d_tails_hi_f_0.sa_M1 0.14677f
C90 iovdd s2d_block_0.s2d_casc_p_f_0.vbpc 35.0861f
C91 a_14374_25782# a_14374_25918# 0.78325f
C92 pad s2d_block_0.s2d_tails_lo_f_0.sb_A1 0.02754f
C93 a_14374_26190# a_11844_26326# 0.02746f
C94 s2d_block_0.s2d_tails_hi_f_0.sb_F2 a_11844_26326# 0.02158f
C95 s2d_block_0.s2d_casc_n_f_0.xc s2d_block_0.s2d_tails_lo_f_0.sb_A1 0.04313f
C96 a_11844_26598# s2d_block_0.s2d_tails_hi_f_0.sa_M1 0.01029f
C97 s2d_block_0.s2d_tails_hi_f_0.sb_F2 outp 0.06799f
C98 a_11844_25510# a_11844_25646# 0.63642f
C99 vref s2d_block_0.s2d_tails_hi_f_0.vbp 0.10217f
C100 s2d_block_0.s2d_casc_n_f_0.yc s2d_block_0.s2d_tails_lo_f_0.sb_A2 0.0238f
C101 s2d_block_0.s2d_casc_n_f_0.y s2d_block_0.s2d_tails_lo_f_0.sa_F2 1.20108f
C102 a_11844_26054# s2d_block_0.s2d_tails_hi_f_0.sa_M1 0.09778f
C103 s2d_block_0.s2d_tails_lo_f_0.sb_M1 s2d_block_0.s2d_tails_lo_f_0.sa_F2 0.05732f
C104 s2d_block_0.s2d_tails_hi_f_0.sa_A1 a_11844_25510# 0.0665f
C105 a_11844_27006# a_11844_26870# 0.63642f
C106 s2d_block_0.s2d_tails_hi_f_0.sa_A1 s2d_block_0.s2d_tails_lo_f_0.sa_F1 0.0456f
C107 outn s2d_block_0.s2d_casc_n_f_0.yc 0.87595f
C108 outn s2d_block_0.s2d_casc_n_f_0.vbnc 9.68851f
C109 s2d_block_0.s2d_tails_hi_f_0.sb_F2 s2d_block_0.s2d_tails_lo_f_0.sb_A1 0.0325f
C110 s2d_block_0.s2d_casc_n_f_0.y s2d_block_0.s2d_casc_n_f_0.x 22.009f
C111 pad vcm 0.3255f
C112 s2d_block_0.s2d_casc_n_f_0.yc s2d_block_0.s2d_casc_p_f_0.vbpc 0.05993f
C113 outp s2d_block_0.s2d_tails_lo_f_0.sb_A1 0.98539f
C114 vcm s2d_block_0.s2d_casc_n_f_0.xc 1.31473f
C115 vdd a_11844_27822# 0.02082f
C116 a_11844_27142# a_14374_27142# 0.02707f
C117 s2d_block_0.s2d_tails_hi_f_0.sb_F1 s2d_block_0.s2d_tails_hi_f_0.sa_A2 0.28064f
C118 a_11844_27822# a_14374_27822# 0.02746f
C119 a_11844_27414# a_14374_27414# 0.02713f
C120 a_11844_27686# a_14374_27686# 0.02728f
C121 a_11844_27550# a_14374_27550# 0.02719f
C122 a_11844_27278# a_14374_27278# 0.0271f
C123 a_14374_27686# a_11844_28094# 0.02728f
C124 en_3v3 iref 0.26074f
C125 a_11844_28230# a_11844_28366# 0.63642f
C126 a_11758_27006# s2d_block_0.s2d_tails_lo_f_0.sb_M1 0.04688f
C127 s2d_block_0.s2d_tails_lo_f_0.sa_M2 s2d_block_0.s2d_tails_hi_f_0.sb_F1 0.06369f
C128 iovdd s2d_block_0.s2d_tails_hi_f_0.sa_A2 2.76796f
C129 s2d_block_0.s2d_tails_hi_f_0.sb_F2 a_11844_27006# 0.02253f
C130 s2d_block_0.s2d_loads_f_0.vcmfb s2d_block_0.s2d_loads_f_0.ln 1.8425f
C131 s2d_block_0.s2d_loads_f_0.vcmfb s2d_block_0.s2d_casc_n_f_0.y 0.21086f
C132 s2d_block_0.s2d_tails_hi_f_0.sb_F2 vcm 2.83453f
C133 iovdd s2d_block_0.s2d_tails_lo_f_0.sa_M2 1.97442f
C134 outp vcm 9.47391f
C135 s2d_block_0.s2d_tails_hi_f_0.sb_M2 s2d_block_0.s2d_tails_lo_f_0.sb_A2 1.43713f
C136 Clamp_P_M1_0.gate pad 19.5174f
C137 a_11844_26326# a_11758_26326# 0.01932f
C138 a_11844_26462# a_11758_26462# 0.01935f
C139 outn s2d_block_0.s2d_tails_hi_f_0.sb_M2 0.0267f
C140 s2d_block_0.s2d_casc_p_f_0.vbpc s2d_block_0.s2d_tails_hi_f_0.sb_M2 0.02427f
C141 s2d_block_0.s2d_tails_hi_f_0.sb_F2 a_11844_27414# 0.02378f
C142 s2d_block_0.sinks_6x6_s2d_c3_core_0.vbn a_14374_25646# 0.01791f
C143 s2d_block_0.s2d_casc_n_f_0.y s2d_block_0.s2d_tails_lo_f_0.sa_F1 1.19633f
C144 s2d_block_0.s2d_tails_lo_f_0.sb_M1 s2d_block_0.s2d_tails_lo_f_0.sa_F1 1.43359f
C145 a_11844_28638# s2d_block_0.s2d_tails_hi_f_0.sa_M1 0.02158f
C146 s2d_block_0.s2d_tails_hi_f_0.sb_F2 a_11844_26598# 0.02196f
C147 en_3v3_b vdd 2.65677f
C148 a_11844_25918# a_11844_25782# 0.63642f
C149 iovdd iref 0.39141f
C150 s2d_block_0.s2d_tails_hi_f_0.sb_F2 a_11844_26054# 0.02158f
C151 a_11758_26326# s2d_block_0.s2d_tails_lo_f_0.sb_A1 0.05685f
C152 s2d_block_0.s2d_tails_hi_f_0.sa_A1 s2d_block_0.s2d_tails_hi_f_0.sa_M1 0.17778f
C153 s2d_block_0.s2d_loads_f_0.ln s2d_block_0.sinks_6x6_s2d_c3_core_0.vbn 0.01344f
C154 s2d_block_0.s2d_casc_n_f_0.yc s2d_block_0.s2d_tails_lo_f_0.sa_M2 1.21104f
C155 s2d_block_0.s2d_casc_n_f_0.y s2d_block_0.sinks_6x6_s2d_c3_core_0.vbn 11.4419f
C156 s2d_block_0.sinks_6x6_s2d_c3_core_0.vbn s2d_block_0.s2d_tails_lo_f_0.sb_M1 0.15983f
C157 vdd outn 4.12076f
C158 a_14374_27550# a_14374_27414# 0.78325f
C159 vdd s2d_block_0.s2d_casc_p_f_0.vbpc 0.38387f
C160 s2d_block_0.s2d_loads_f_0.lp s2d_block_0.s2d_loads_f_0.vcmfb 2.06469f
C161 a_14374_27278# a_11844_28502# 0.0271f
C162 a_11844_26734# a_11844_26870# 0.63642f
C163 a_11844_26190# s2d_block_0.s2d_tails_lo_f_0.sa_M2 0.0194f
C164 s2d_block_0.s2d_tails_hi_f_0.sb_M2 s2d_block_0.s2d_tails_hi_f_0.sa_A2 0.30715f
C165 s2d_block_0.s2d_tails_hi_f_0.sb_F1 s2d_block_0.s2d_tails_lo_f_0.sa_F2 3.20673f
C166 s2d_block_0.s2d_tails_hi_f_0.sa_A1 pad 2.83511f
C167 iovdd s2d_block_0.s2d_tails_lo_f_0.sa_F2 5.2742f
C168 s2d_block_0.s2d_casc_n_f_0.x s2d_block_0.s2d_tails_hi_f_0.sb_F1 1.40651f
C169 s2d_block_0.s2d_tails_lo_f_0.sb_M1 s2d_block_0.s2d_tails_hi_f_0.sa_M1 0.05443f
C170 iovdd s2d_block_0.s2d_casc_n_f_0.x 8.59882f
C171 a_14374_25646# a_11844_26870# 0.0271f
C172 s2d_block_0.s2d_loads_f_0.lp s2d_block_0.sinks_6x6_s2d_c3_core_0.vbn 0.25039f
C173 s2d_block_0.s2d_tails_hi_f_0.sb_F2 a_11844_25646# 0.02158f
C174 en_3v3_b s2d_block_0.s2d_tails_hi_f_0.vbp 0.22518f
C175 s2d_block_0.s2d_tails_hi_f_0.sb_F2 a_11844_26734# 0.02221f
C176 a_11844_28638# s2d_block_0.s2d_tails_lo_f_0.sb_A1 0.02111f
C177 s2d_block_0.s2d_tails_hi_f_0.sb_F2 s2d_block_0.s2d_tails_hi_f_0.sa_A1 0.41711f
C178 vref s2d_block_0.s2d_tails_lo_f_0.sb_A2 2.89541f
C179 s2d_block_0.s2d_tails_hi_f_0.sa_A1 outp 0.01644f
C180 vref outn 5.68618f
C181 vdd s2d_block_0.s2d_tails_hi_f_0.sa_A2 0.1052f
C182 iovdd s2d_block_0.s2d_loads_f_0.vcmfb 46.5827f
C183 s2d_block_0.s2d_casc_n_f_0.yc s2d_block_0.s2d_tails_lo_f_0.sa_F2 0.01813f
C184 s2d_block_0.s2d_tails_hi_f_0.vbp s2d_block_0.s2d_tails_lo_f_0.sb_A2 0.35797f
C185 a_11844_25510# s2d_block_0.s2d_tails_hi_f_0.sb_F1 0.01318f
C186 pad s2d_block_0.s2d_casc_n_f_0.y 1.37827f
C187 s2d_block_0.s2d_tails_hi_f_0.sa_A1 s2d_block_0.s2d_tails_lo_f_0.sb_A1 0.04713f
C188 s2d_block_0.s2d_tails_hi_f_0.sb_F1 s2d_block_0.s2d_tails_lo_f_0.sa_F1 1.04342f
C189 pad s2d_block_0.s2d_tails_lo_f_0.sb_M1 0.0582f
C190 s2d_block_0.s2d_loads_f_0.ln s2d_block_0.s2d_casc_n_f_0.xc 0.17914f
C191 outn s2d_block_0.s2d_tails_hi_f_0.vbp 0.35916f
C192 s2d_block_0.s2d_casc_n_f_0.yc s2d_block_0.s2d_casc_n_f_0.x 5.29006f
C193 s2d_block_0.s2d_casc_n_f_0.y s2d_block_0.s2d_casc_n_f_0.xc 7.99643f
C194 s2d_block_0.s2d_casc_p_f_0.vbpc s2d_block_0.s2d_tails_hi_f_0.vbp 3.8698f
C195 s2d_block_0.s2d_casc_n_f_0.x s2d_block_0.s2d_casc_n_f_0.vbnc 2.98545f
C196 s2d_block_0.s2d_casc_n_f_0.xc s2d_block_0.s2d_tails_lo_f_0.sb_M1 1.17345f
C197 iovdd s2d_block_0.s2d_tails_lo_f_0.sa_F1 1.86555f
C198 vdd a_11844_27686# 0.0197f
C199 a_11844_25918# s2d_block_0.s2d_tails_hi_f_0.sa_A2 0.0208f
C200 s2d_block_0.sinks_6x6_s2d_c3_core_0.vbn s2d_block_0.s2d_tails_hi_f_0.sb_F1 0.50564f
C201 s2d_block_0.s2d_tails_hi_f_0.sb_F2 s2d_block_0.s2d_casc_n_f_0.y 0.45356f
C202 outp s2d_block_0.s2d_casc_n_f_0.y 0.03405f
C203 s2d_block_0.s2d_tails_hi_f_0.sa_A1 vcm 0.02624f
C204 outp s2d_block_0.s2d_loads_f_0.ln 0.02987f
C205 s2d_block_0.s2d_tails_hi_f_0.sb_F2 s2d_block_0.s2d_tails_lo_f_0.sb_M1 0.80863f
C206 vdd iref 1.71255f
C207 outp s2d_block_0.s2d_tails_lo_f_0.sb_M1 0.86918f
C208 iovdd s2d_block_0.sinks_6x6_s2d_c3_core_0.vbn 14.9428f
C209 s2d_block_0.s2d_loads_f_0.vcmfb s2d_block_0.s2d_casc_n_f_0.yc 0.20847f
C210 s2d_block_0.s2d_loads_f_0.vcmfb s2d_block_0.s2d_casc_n_f_0.vbnc 4.60294f
C211 a_11844_27142# a_11758_27006# 0.01971f
C212 a_11758_26870# a_11758_26734# 0.55763f
C213 a_11844_26598# a_11844_26734# 0.63642f
C214 s2d_block_0.s2d_tails_hi_f_0.sb_F2 a_11844_27278# 0.02318f
C215 s2d_block_0.s2d_casc_n_f_0.yc s2d_block_0.s2d_tails_lo_f_0.sa_F1 0.02338f
C216 s2d_block_0.s2d_casc_n_f_0.y s2d_block_0.s2d_tails_lo_f_0.sb_A1 0.19349f
C217 s2d_block_0.s2d_tails_lo_f_0.sb_M1 s2d_block_0.s2d_tails_lo_f_0.sb_A1 0.45675f
C218 a_11844_28502# s2d_block_0.s2d_tails_hi_f_0.sa_M1 0.02158f
C219 vref s2d_block_0.s2d_tails_lo_f_0.sa_M2 0.06384f
C220 s2d_block_0.s2d_loads_f_0.lp s2d_block_0.s2d_casc_n_f_0.xc 0.26366f
C221 a_11758_26462# s2d_block_0.s2d_tails_lo_f_0.sb_A1 0.02995f
C222 s2d_block_0.s2d_tails_hi_f_0.vbp s2d_block_0.s2d_tails_hi_f_0.sa_A2 0.27394f
C223 s2d_block_0.s2d_tails_hi_f_0.sb_F1 s2d_block_0.s2d_tails_hi_f_0.sa_M1 1.21732f
C224 a_14374_27142# a_14374_25510# 0.27561f
C225 s2d_block_0.s2d_casc_n_f_0.yc s2d_block_0.sinks_6x6_s2d_c3_core_0.vbn 5.71059f
C226 s2d_block_0.sinks_6x6_s2d_c3_core_0.vbn s2d_block_0.s2d_casc_n_f_0.vbnc 7.23477f
C227 s2d_block_0.s2d_tails_lo_f_0.sa_M2 s2d_block_0.s2d_tails_hi_f_0.vbp 0.4559f
C228 s2d_block_0.s2d_loads_f_0.dd outn 0.03137f
C229 vcm s2d_block_0.s2d_casc_n_f_0.y 0.63563f
C230 vcm s2d_block_0.s2d_tails_lo_f_0.sb_M1 2.76648f
C231 iovdd s2d_block_0.s2d_tails_hi_f_0.sa_M1 0.68866f
C232 s2d_block_0.s2d_loads_f_0.dd s2d_block_0.s2d_casc_p_f_0.vbpc 1.62631f
C233 outp s2d_block_0.s2d_loads_f_0.lp 0.34422f
C234 vdd s2d_block_0.s2d_casc_n_f_0.x 0.04852f
C235 a_11758_26326# s2d_block_0.s2d_tails_lo_f_0.sb_M1 0.04825f
C236 en_3v3 outp 0.10044f
C237 s2d_block_0.s2d_tails_hi_f_0.vbp iref 0.12001f
C238 a_11844_27278# a_11844_27414# 0.63642f
C239 a_11844_25918# s2d_block_0.s2d_tails_lo_f_0.sa_F2 0.01924f
C240 a_11844_27550# a_11758_26598# 0.01938f
C241 a_11758_26462# a_11758_26326# 1.23642f
C242 pad s2d_block_0.s2d_tails_hi_f_0.sb_F1 0.25447f
C243 s2d_block_0.s2d_tails_hi_f_0.sa_A1 a_11844_28638# 0.01046f
C244 s2d_block_0.s2d_casc_n_f_0.xc s2d_block_0.s2d_tails_hi_f_0.sb_F1 0.02742f
C245 s2d_block_0.s2d_casc_n_f_0.yc s2d_block_0.s2d_tails_hi_f_0.sa_M1 1.0972f
C246 pad iovdd 45.5897f
C247 iovdd s2d_block_0.s2d_casc_n_f_0.xc 11.114f
C248 a_14374_25782# a_11844_25782# 0.02713f
C249 a_11844_26462# a_14374_26054# 0.02728f
C250 s2d_block_0.s2d_tails_hi_f_0.sa_A1 a_11844_25646# 0.01445f
C251 en_3v3_b outn 0.23705f
C252 a_11844_27958# s2d_block_0.s2d_tails_hi_f_0.sb_M2 0.01935f
C253 vref s2d_block_0.s2d_tails_lo_f_0.sa_F2 0.07479f
C254 s2d_block_0.s2d_tails_hi_f_0.sb_F2 s2d_block_0.s2d_tails_hi_f_0.sb_F1 6.07872f
C255 outp s2d_block_0.s2d_tails_hi_f_0.sb_F1 2.87685f
C256 en_3v3 s2d_block_0.bias_tree_noab_n_c3_0.ni 0.06138f
C257 s2d_block_0.s2d_tails_hi_f_0.sb_F2 iovdd 7.01741f
C258 vref s2d_block_0.s2d_casc_n_f_0.x 1.49531f
C259 a_11844_26190# s2d_block_0.s2d_tails_hi_f_0.sa_M1 0.03973f
C260 outp iovdd 12.3886f
C261 a_11844_25646# a_14374_25646# 0.0271f
C262 en_3v3 vcm 0.11407f
C263 outn s2d_block_0.s2d_tails_lo_f_0.sb_A2 0.04441f
C264 s2d_block_0.s2d_tails_hi_f_0.vbp s2d_block_0.s2d_tails_lo_f_0.sa_F2 0.35611f
C265 s2d_block_0.s2d_casc_p_f_0.vbpc s2d_block_0.s2d_tails_lo_f_0.sb_A2 0.04675f
C266 pad s2d_block_0.s2d_casc_n_f_0.yc 0.06508f
C267 s2d_block_0.s2d_tails_hi_f_0.sb_M2 s2d_block_0.s2d_tails_hi_f_0.sa_M1 1.08556f
C268 a_11844_25374# a_11844_25510# 0.63642f
C269 s2d_block_0.s2d_tails_hi_f_0.sb_F1 s2d_block_0.s2d_tails_lo_f_0.sb_A1 0.52239f
C270 vdd s2d_block_0.sinks_6x6_s2d_c3_core_0.vbn 1.34414f
C271 outn s2d_block_0.s2d_casc_p_f_0.vbpc 7.61108f
C272 s2d_block_0.s2d_casc_n_f_0.yc s2d_block_0.s2d_casc_n_f_0.xc 12.1225f
C273 s2d_block_0.s2d_casc_n_f_0.x s2d_block_0.s2d_tails_hi_f_0.vbp 0.07574f
C274 s2d_block_0.s2d_casc_n_f_0.xc s2d_block_0.s2d_casc_n_f_0.vbnc 5.59245f
C275 iovdd s2d_block_0.s2d_tails_lo_f_0.sb_A1 4.00867f
C276 a_11844_25782# s2d_block_0.s2d_tails_hi_f_0.sa_A2 0.03941f
C277 vdd a_11844_27550# 0.01806f
C278 a_11844_27686# a_11844_27822# 0.63642f
C279 a_14374_27822# a_11844_27958# 0.02746f
C280 a_11844_28094# a_11844_28230# 0.63642f
C281 s2d_block_0.s2d_tails_hi_f_0.sa_A1 s2d_block_0.s2d_casc_n_f_0.y 1.19158f
C282 s2d_block_0.s2d_tails_hi_f_0.sa_A1 s2d_block_0.s2d_tails_lo_f_0.sb_M1 1.47019f
C283 a_11844_25374# s2d_block_0.sinks_6x6_s2d_c3_core_0.vbn 0.03386f
C284 s2d_block_0.s2d_tails_hi_f_0.sb_F2 s2d_block_0.s2d_casc_n_f_0.yc 0.45586f
C285 vcm s2d_block_0.s2d_tails_hi_f_0.sb_F1 0.24994f
C286 outp s2d_block_0.s2d_casc_n_f_0.yc 0.85572f
C287 outp s2d_block_0.s2d_casc_n_f_0.vbnc 9.68843f
C288 iovdd s2d_block_0.bias_tree_noab_n_c3_0.ni 0.15021f
C289 vref s2d_block_0.s2d_tails_lo_f_0.sa_F1 0.06209f
C290 vcm iovdd 2.7753f
C291 pad s2d_block_0.s2d_tails_hi_f_0.sb_M2 0.06476f
C292 a_11844_26598# a_14374_25918# 0.02719f
C293 s2d_block_0.s2d_casc_n_f_0.xc s2d_block_0.s2d_tails_hi_f_0.sb_M2 1.1962f
C294 vdd s2d_block_0.s2d_tails_hi_f_0.sa_M1 0.10508f
C295 s2d_block_0.s2d_tails_hi_f_0.sb_F2 a_11844_27142# 0.02279f
C296 s2d_block_0.s2d_casc_n_f_0.yc s2d_block_0.s2d_tails_lo_f_0.sb_A1 0.03102f
C297 s2d_block_0.s2d_tails_hi_f_0.vbp s2d_block_0.s2d_tails_lo_f_0.sa_F1 0.26261f
C298 a_11844_26190# a_11844_26326# 0.63642f
C299 s2d_block_0.s2d_tails_lo_f_0.sb_A2 s2d_block_0.s2d_tails_hi_f_0.sa_A2 0.08815f
C300 a_11844_26190# a_14374_26190# 0.02746f
C301 s2d_block_0.s2d_tails_hi_f_0.sb_F2 a_11844_26190# 0.02158f
C302 outn s2d_block_0.s2d_tails_hi_f_0.sa_A2 0.0227f
C303 a_11758_26598# s2d_block_0.s2d_tails_lo_f_0.sb_A1 0.01794f
C304 s2d_block_0.s2d_casc_p_f_0.vbpc s2d_block_0.s2d_tails_hi_f_0.sa_A2 0.02597f
C305 Clamp_P_M1_0.gate iovdd 44.7526f
C306 s2d_block_0.s2d_tails_hi_f_0.sb_F2 s2d_block_0.s2d_tails_hi_f_0.sb_M2 0.03285f
C307 outp s2d_block_0.s2d_tails_hi_f_0.sb_M2 0.84971f
C308 a_11844_25918# s2d_block_0.s2d_tails_hi_f_0.sa_M1 0.03426f
C309 outn s2d_block_0.s2d_tails_lo_f_0.sa_M2 3.08404f
C310 s2d_block_0.s2d_tails_lo_f_0.sa_M2 s2d_block_0.s2d_casc_p_f_0.vbpc 0.02058f
C311 s2d_block_0.sinks_6x6_s2d_c3_core_0.vbn s2d_block_0.s2d_tails_hi_f_0.vbp 0.26763f
C312 en_3v3_b iref 1.56328f
C313 vcm s2d_block_0.s2d_casc_n_f_0.yc 0.10607f
C314 vdd pad 0.09288f
C315 s2d_block_0.s2d_tails_hi_f_0.sb_M2 s2d_block_0.s2d_tails_lo_f_0.sb_A1 0.08784f
C316 vdd s2d_block_0.s2d_casc_n_f_0.xc 0.02686f
C317 a_14374_27686# a_14374_27550# 0.55763f
C318 a_14374_27414# a_11844_28366# 0.02713f
C319 a_11844_27142# a_11844_27006# 0.63642f
C320 a_11844_28502# a_11844_28638# 0.63642f
C321 a_11758_26462# s2d_block_0.s2d_tails_lo_f_0.sb_M1 0.04781f
C322 s2d_block_0.s2d_casc_p_f_0.vbpc iref 0.23455f
C323 s2d_block_0.s2d_loads_f_0.dd s2d_block_0.s2d_loads_f_0.vcmfb 1.40683f
C324 a_11844_26598# a_11758_26598# 0.01938f
C325 a_11844_28638# s2d_block_0.s2d_tails_hi_f_0.sb_F1 0.01626f
C326 s2d_block_0.s2d_tails_hi_f_0.sb_F2 vdd 0.10947f
C327 a_11844_25510# a_14374_25510# 0.02707f
C328 s2d_block_0.s2d_tails_hi_f_0.sa_A1 a_11844_28502# 0.01046f
C329 outp vdd 4.60703f
C330 vcm s2d_block_0.s2d_tails_hi_f_0.sb_M2 2.97323f
C331 a_11844_28774# s2d_block_0.s2d_tails_hi_f_0.sa_M1 0.0238f
C332 a_11844_25374# s2d_block_0.s2d_casc_n_f_0.xc 0.01124f
C333 s2d_block_0.s2d_tails_hi_f_0.sb_F2 a_11844_28366# 0.01762f
C334 s2d_block_0.s2d_tails_hi_f_0.vbp s2d_block_0.s2d_tails_hi_f_0.sa_M1 0.41199f
C335 s2d_block_0.s2d_loads_f_0.lp s2d_block_0.s2d_loads_f_0.ln 5.83659f
C336 a_11758_26326# s2d_block_0.s2d_tails_hi_f_0.sb_M2 0.26248f
C337 a_11844_25646# s2d_block_0.s2d_tails_hi_f_0.sb_F1 0.01133f
C338 a_14374_26190# a_14374_26054# 0.33426f
C339 s2d_block_0.s2d_tails_lo_f_0.sa_M2 s2d_block_0.s2d_tails_hi_f_0.sa_A2 0.03149f
C340 s2d_block_0.s2d_tails_hi_f_0.sa_A1 s2d_block_0.s2d_tails_hi_f_0.sb_F1 0.1176f
C341 a_11844_26190# a_11844_26054# 0.63642f
C342 s2d_block_0.s2d_tails_hi_f_0.sb_F2 a_11844_25918# 0.02158f
C343 s2d_block_0.s2d_tails_hi_f_0.sb_F2 a_11844_25374# 0.02389f
C344 s2d_block_0.sinks_6x6_s2d_c3_core_0.vbn a_14374_25510# 0.03952f
C345 s2d_block_0.s2d_tails_hi_f_0.sa_A1 iovdd 1.52034f
C346 vref pad 0.12553f
C347 s2d_block_0.s2d_tails_lo_f_0.sa_F2 s2d_block_0.s2d_tails_lo_f_0.sb_A2 0.0615f
C348 s2d_block_0.s2d_loads_f_0.dd s2d_block_0.sinks_6x6_s2d_c3_core_0.vbn 0.01093f
C349 vref s2d_block_0.s2d_casc_n_f_0.xc 0.03603f
C350 outn s2d_block_0.s2d_tails_lo_f_0.sa_F2 2.79068f
C351 a_11844_25782# s2d_block_0.s2d_tails_lo_f_0.sa_F1 0.01924f
C352 s2d_block_0.s2d_casc_n_f_0.x s2d_block_0.s2d_tails_lo_f_0.sb_A2 1.26802f
C353 s2d_block_0.s2d_casc_p_f_0.vbpc s2d_block_0.s2d_tails_lo_f_0.sa_F2 0.02327f
C354 vdd s2d_block_0.bias_tree_noab_n_c3_0.ni 1.76708f
C355 vdd a_11844_27006# 0.01077f
C356 pad s2d_block_0.s2d_tails_hi_f_0.vbp 0.03551f
C357 a_14374_27278# a_14374_27142# 1.23642f
C358 outn s2d_block_0.s2d_casc_n_f_0.x 0.03219f
C359 vdd vcm 1.91855f
C360 s2d_block_0.s2d_casc_n_f_0.xc s2d_block_0.s2d_tails_hi_f_0.vbp 0.09249f
C361 a_8120_4634# s2d_block_0.s2d_loads_f_0.vcmfb 0.01054f
C362 s2d_block_0.s2d_tails_hi_f_0.sb_F2 vref 0.35903f
C363 vdd a_11844_27414# 0.01616f
C364 vdd a_11758_26326# 0.01425f
C365 vref outp 0.3077f
C366 a_11844_27822# a_11844_27958# 0.63642f
C367 s2d_block_0.s2d_casc_n_f_0.y s2d_block_0.s2d_tails_hi_f_0.sb_F1 0.22739f
C368 s2d_block_0.s2d_tails_lo_f_0.sb_M1 s2d_block_0.s2d_tails_hi_f_0.sb_F1 0.07854f
C369 Clamp_N_M1_0.gate s2d_block_0.sinks_6x6_s2d_c3_core_0.vbn 0.02015f
C370 s2d_block_0.s2d_tails_hi_f_0.sb_F2 s2d_block_0.s2d_tails_hi_f_0.vbp 0.75445f
C371 outp s2d_block_0.s2d_tails_hi_f_0.vbp 0.19183f
C372 iovdd s2d_block_0.s2d_loads_f_0.ln 9.1759f
C373 s2d_block_0.s2d_loads_f_0.vcmfb outn 4.45704f
C374 iovdd s2d_block_0.s2d_casc_n_f_0.y 15.5797f
C375 vref s2d_block_0.s2d_tails_lo_f_0.sb_A1 2.83346f
C376 iovdd s2d_block_0.s2d_tails_lo_f_0.sb_M1 1.22552f
C377 s2d_block_0.s2d_loads_f_0.vcmfb s2d_block_0.s2d_casc_p_f_0.vbpc 2.11215f
C378 a_11758_27006# a_11758_26870# 0.33426f
C379 s2d_block_0.s2d_tails_lo_f_0.sa_F1 s2d_block_0.s2d_tails_lo_f_0.sb_A2 0.25628f
C380 en_3v3_b s2d_block_0.sinks_6x6_s2d_c3_core_0.vbn 0.79062f
C381 outn s2d_block_0.s2d_tails_lo_f_0.sa_F1 0.02799f
C382 s2d_block_0.s2d_tails_hi_f_0.vbp s2d_block_0.s2d_tails_lo_f_0.sb_A1 0.9893f
C383 s2d_block_0.s2d_casc_p_f_0.vbpc s2d_block_0.s2d_tails_lo_f_0.sa_F1 0.01535f
C384 a_11844_26054# a_14374_26054# 0.02728f
C385 s2d_block_0.s2d_tails_lo_f_0.sa_F2 s2d_block_0.s2d_tails_hi_f_0.sa_A2 0.02005f
C386 a_11844_25918# a_11844_26054# 0.63642f
C387 s2d_block_0.s2d_tails_hi_f_0.sa_A1 s2d_block_0.s2d_tails_hi_f_0.sb_M2 0.13856f
C388 vref vcm 0.29438f
C389 a_11844_25782# s2d_block_0.s2d_tails_hi_f_0.sa_M1 0.01333f
C390 s2d_block_0.s2d_tails_lo_f_0.sa_M2 s2d_block_0.s2d_tails_lo_f_0.sa_F2 0.93094f
C391 a_11758_26734# s2d_block_0.s2d_tails_lo_f_0.sb_A1 0.01181f
C392 s2d_block_0.s2d_casc_n_f_0.x s2d_block_0.s2d_tails_hi_f_0.sa_A2 0.19349f
C393 outn s2d_block_0.sinks_6x6_s2d_c3_core_0.vbn 0.0235f
C394 s2d_block_0.s2d_loads_f_0.ln s2d_block_0.s2d_casc_n_f_0.yc 0.8848f
C395 s2d_block_0.s2d_casc_n_f_0.yc s2d_block_0.s2d_casc_n_f_0.y 1.84321f
C396 a_14374_27142# s2d_block_0.sinks_6x6_s2d_c3_core_0.vbn 0.02814f
C397 s2d_block_0.sinks_6x6_s2d_c3_core_0.vbn s2d_block_0.s2d_casc_p_f_0.vbpc 0.03673f
C398 s2d_block_0.s2d_casc_n_f_0.y s2d_block_0.s2d_casc_n_f_0.vbnc 2.09561f
C399 s2d_block_0.bias_tree_noab_n_c3_0.ni s2d_block_0.s2d_tails_hi_f_0.vbp 0.46959f
C400 s2d_block_0.s2d_casc_n_f_0.yc s2d_block_0.s2d_tails_lo_f_0.sb_M1 0.22904f
C401 vcm s2d_block_0.s2d_tails_hi_f_0.vbp 0.77904f
C402 s2d_block_0.s2d_loads_f_0.dd s2d_block_0.s2d_casc_n_f_0.xc 0.55573f
C403 a_14374_25782# s2d_block_0.sinks_6x6_s2d_c3_core_0.vbn 0.01214f
C404 s2d_block_0.s2d_loads_f_0.lp iovdd 9.55312f
C405 a_11758_26598# s2d_block_0.s2d_tails_lo_f_0.sb_M1 0.04807f
C406 outp s2d_block_0.s2d_loads_f_0.dd 0.0242f
C407 a_11844_25510# s2d_block_0.s2d_tails_hi_f_0.sa_A2 0.01204f
C408 a_11844_27142# a_11844_27278# 0.63642f
C409 en_3v3 iovdd 0.36737f
C410 a_11844_27414# a_11758_26734# 0.01944f
C411 a_11758_26598# a_11758_26462# 1.00966f
C412 s2d_block_0.s2d_tails_hi_f_0.sa_M1 s2d_block_0.s2d_tails_lo_f_0.sb_A2 0.23951f
C413 s2d_block_0.s2d_tails_lo_f_0.sa_F1 s2d_block_0.s2d_tails_hi_f_0.sa_A2 0.31556f
C414 s2d_block_0.s2d_tails_hi_f_0.sa_A1 vdd 0.10518f
C415 a_7760_4632# iovdd 0.04371f
C416 Clamp_N_M1_0.gate pad 7.47057f
C417 s2d_block_0.s2d_tails_lo_f_0.sb_M1 s2d_block_0.s2d_tails_hi_f_0.sb_M2 0.34748f
C418 a_11844_28502# s2d_block_0.s2d_tails_hi_f_0.sb_F1 0.04221f
C419 outn s2d_block_0.s2d_tails_hi_f_0.sa_M1 0.0232f
C420 s2d_block_0.s2d_tails_hi_f_0.sb_F2 a_11844_27822# 0.03091f
C421 s2d_block_0.s2d_tails_hi_f_0.sb_F2 a_11844_28230# 0.14087f
C422 Clamp_N_M1_0.gate s2d_block_0.s2d_casc_n_f_0.xc 0.01061f
C423 s2d_block_0.s2d_tails_lo_f_0.sa_M2 s2d_block_0.s2d_tails_lo_f_0.sa_F1 1.4446f
C424 s2d_block_0.s2d_casc_p_f_0.vbpc s2d_block_0.s2d_tails_hi_f_0.sa_M1 0.02579f
C425 s2d_block_0.s2d_loads_f_0.lp s2d_block_0.s2d_casc_n_f_0.yc 0.21417f
C426 s2d_block_0.s2d_tails_hi_f_0.sb_F2 a_11844_25782# 0.02158f
C427 s2d_block_0.s2d_tails_hi_f_0.sa_A1 a_11844_25374# 0.01837f
C428 a_14374_25510# a_11844_27006# 0.02707f
C429 iovdd s2d_block_0.s2d_tails_hi_f_0.sb_F1 3.46185f
C430 pad s2d_block_0.s2d_tails_lo_f_0.sb_A2 0.0387f
C431 s2d_block_0.s2d_casc_n_f_0.x s2d_block_0.s2d_tails_lo_f_0.sa_F2 0.15244f
C432 pad outn 0.07331f
C433 vdd s2d_block_0.s2d_casc_n_f_0.y 0.06408f
C434 outp en_3v3_b 1.72266f
C435 a_11844_28774# a_11844_28638# 0.63642f
C436 outn s2d_block_0.s2d_casc_n_f_0.xc 0.33309f
C437 s2d_block_0.s2d_casc_n_f_0.xc s2d_block_0.s2d_casc_p_f_0.vbpc 0.11566f
C438 a_11758_26870# a_11844_26870# 0.01953f
C439 vref s2d_block_0.s2d_tails_hi_f_0.sa_A1 0.01051f
C440 vdd a_11844_27278# 0.01422f
C441 vdd a_11758_26462# 0.0103f
C442 a_11844_27550# a_11844_27686# 0.63642f
C443 a_11844_27822# a_11758_26326# 0.01932f
C444 a_11844_27958# a_11844_28094# 0.63642f
C445 s2d_block_0.s2d_tails_hi_f_0.sb_F2 s2d_block_0.s2d_tails_lo_f_0.sb_A2 2.29219f
C446 outp s2d_block_0.s2d_tails_lo_f_0.sb_A2 0.86322f
C447 s2d_block_0.s2d_tails_hi_f_0.sa_M1 s2d_block_0.s2d_tails_hi_f_0.sa_A2 2.31964f
C448 s2d_block_0.s2d_casc_n_f_0.yc s2d_block_0.s2d_tails_hi_f_0.sb_F1 0.08747f
C449 s2d_block_0.s2d_tails_hi_f_0.sa_A1 a_11844_28774# 0.01266f
C450 s2d_block_0.s2d_tails_hi_f_0.sa_A1 s2d_block_0.s2d_tails_hi_f_0.vbp 0.29449f
C451 s2d_block_0.s2d_tails_hi_f_0.sb_F2 outn 0.1826f
C452 outp outn 6.05194f
C453 s2d_block_0.s2d_tails_hi_f_0.sb_F2 s2d_block_0.s2d_casc_p_f_0.vbpc 0.02698f
C454 a_11844_25374# s2d_block_0.s2d_tails_lo_f_0.sb_M1 0.01449f
C455 s2d_block_0.s2d_tails_lo_f_0.sa_M2 s2d_block_0.s2d_tails_hi_f_0.sa_M1 0.33016f
C456 outp s2d_block_0.s2d_casc_p_f_0.vbpc 1.4238f
C457 iovdd s2d_block_0.s2d_casc_n_f_0.yc 10.8054f
C458 s2d_block_0.s2d_loads_f_0.vcmfb s2d_block_0.s2d_casc_n_f_0.x 0.25703f
C459 iovdd s2d_block_0.s2d_casc_n_f_0.vbnc 22.6805f
C460 a_11844_26734# a_11758_26734# 0.01944f
C461 s2d_block_0.s2d_tails_lo_f_0.sa_F1 s2d_block_0.s2d_tails_lo_f_0.sa_F2 1.9391f
C462 s2d_block_0.s2d_tails_lo_f_0.sb_A1 s2d_block_0.s2d_tails_lo_f_0.sb_A2 0.36686f
C463 en_3v3_b s2d_block_0.bias_tree_noab_n_c3_0.ni 0.29376f
C464 outn s2d_block_0.s2d_tails_lo_f_0.sb_A1 0.03508f
C465 s2d_block_0.s2d_casc_p_f_0.vbpc s2d_block_0.s2d_tails_lo_f_0.sb_A1 0.02425f
C466 s2d_block_0.s2d_casc_n_f_0.x s2d_block_0.s2d_tails_lo_f_0.sa_F1 0.17877f
C467 en_3v3_b vcm 0.50727f
C468 vref s2d_block_0.s2d_casc_n_f_0.y 1.67038f
C469 vref s2d_block_0.s2d_tails_lo_f_0.sb_M1 0.07439f
C470 pad s2d_block_0.s2d_tails_hi_f_0.sa_A2 2.83313f
C471 s2d_block_0.s2d_tails_hi_f_0.sb_F1 s2d_block_0.s2d_tails_hi_f_0.sb_M2 0.03169f
C472 s2d_block_0.sinks_6x6_s2d_c3_core_0.vbn s2d_block_0.s2d_tails_lo_f_0.sa_F2 3.85824f
C473 vcm s2d_block_0.s2d_tails_lo_f_0.sb_A2 0.25963f
C474 pad s2d_block_0.s2d_tails_lo_f_0.sa_M2 0.07823f
C475 outn s2d_block_0.bias_tree_noab_n_c3_0.ni 0.0188f
C476 iovdd s2d_block_0.s2d_tails_hi_f_0.sb_M2 0.96539f
C477 a_14374_27278# s2d_block_0.sinks_6x6_s2d_c3_core_0.vbn 0.01757f
C478 s2d_block_0.s2d_tails_lo_f_0.sa_M2 s2d_block_0.s2d_casc_n_f_0.xc 0.23201f
C479 s2d_block_0.s2d_casc_n_f_0.yc s2d_block_0.s2d_casc_n_f_0.vbnc 1.55613f
C480 s2d_block_0.s2d_casc_n_f_0.y s2d_block_0.s2d_tails_hi_f_0.vbp 0.07156f
C481 s2d_block_0.sinks_6x6_s2d_c3_core_0.vbn s2d_block_0.s2d_casc_n_f_0.x 11.6306f
C482 en_3v3 vdd 1.37224f
C483 s2d_block_0.bias_tree_noab_n_c3_0.ni s2d_block_0.s2d_casc_p_f_0.vbpc 0.54432f
C484 vcm outn 6.98968f
C485 s2d_block_0.s2d_tails_hi_f_0.vbp s2d_block_0.s2d_tails_lo_f_0.sb_M1 0.26594f
C486 a_8120_4634# Clamp_P_M1_0.gate 0.03336f
C487 a_14374_27822# a_14374_27686# 0.33426f
C488 a_14374_27550# a_11844_28230# 0.02719f
C489 s2d_block_0.s2d_tails_hi_f_0.sb_F2 s2d_block_0.s2d_tails_hi_f_0.sa_A2 0.02442f
C490 a_11758_26734# s2d_block_0.s2d_tails_lo_f_0.sb_M1 0.04819f
C491 a_11844_28366# a_11844_28502# 0.63642f
C492 outp s2d_block_0.s2d_tails_hi_f_0.sa_A2 0.02196f
C493 s2d_block_0.s2d_tails_hi_f_0.sb_F2 s2d_block_0.s2d_tails_lo_f_0.sa_M2 0.36456f
C494 outp s2d_block_0.s2d_tails_lo_f_0.sa_M2 0.54122f
C495 s2d_block_0.s2d_loads_f_0.vcmfb s2d_block_0.sinks_6x6_s2d_c3_core_0.vbn 0.04166f
C496 s2d_block_0.s2d_tails_hi_f_0.sa_M1 s2d_block_0.s2d_tails_lo_f_0.sa_F2 0.29686f
C497 s2d_block_0.s2d_tails_lo_f_0.sb_A1 s2d_block_0.s2d_tails_hi_f_0.sa_A2 0.03116f
C498 vdd s2d_block_0.s2d_tails_hi_f_0.sb_F1 0.10873f
C499 s2d_block_0.s2d_casc_n_f_0.yc s2d_block_0.s2d_tails_hi_f_0.sb_M2 0.28733f
C500 a_11844_28366# s2d_block_0.s2d_tails_hi_f_0.sb_F1 0.12708f
C501 s2d_block_0.s2d_tails_hi_f_0.sb_F2 a_11844_27686# 0.02672f
C502 s2d_block_0.s2d_tails_lo_f_0.sa_M2 s2d_block_0.s2d_tails_lo_f_0.sb_A1 0.16443f
C503 a_14374_25510# a_14374_25646# 1.23642f
C504 s2d_block_0.s2d_tails_hi_f_0.sb_F2 a_11844_28094# 0.07914f
C505 vdd iovdd 5.97164f
C506 a_11844_25646# a_11844_25782# 0.63642f
C507 a_14374_26054# a_14374_25918# 0.55763f
C508 a_11844_25918# a_14374_25918# 0.02719f
C509 a_11844_26462# s2d_block_0.s2d_tails_hi_f_0.sa_M1 0.01273f
C510 a_11844_25918# s2d_block_0.s2d_tails_hi_f_0.sb_F1 0.0102f
C511 a_11844_25374# s2d_block_0.s2d_tails_hi_f_0.sb_F1 0.01737f
C512 vcm s2d_block_0.s2d_tails_hi_f_0.sa_A2 0.02476f
C513 s2d_block_0.s2d_loads_f_0.dd s2d_block_0.s2d_loads_f_0.ln 12.7936f
C514 en_3v3 s2d_block_0.s2d_tails_hi_f_0.vbp 0.03985f
C515 pad s2d_block_0.s2d_tails_lo_f_0.sa_F2 0.01954f
C516 s2d_block_0.s2d_casc_n_f_0.xc s2d_block_0.s2d_tails_lo_f_0.sa_F2 0.01761f
C517 vdd s2d_block_0.s2d_casc_n_f_0.yc 0.02686f
C518 vdd s2d_block_0.s2d_casc_n_f_0.vbnc 1.187f
C519 a_14374_27414# a_14374_27278# 1.00966f
C520 pad s2d_block_0.s2d_casc_n_f_0.x 0.07862f
C521 a_14374_27142# a_11844_28638# 0.02707f
C522 s2d_block_0.s2d_tails_lo_f_0.sa_M2 a_11758_26326# 0.26248f
C523 s2d_block_0.s2d_casc_n_f_0.xc s2d_block_0.s2d_casc_n_f_0.x 0.32431f
C524 vref s2d_block_0.s2d_tails_hi_f_0.sb_F1 0.05463f
C525 vdd a_11844_27142# 0.01241f
C526 s2d_block_0.bias_tree_noab_n_c3_0.ni iref 0.20242f
C527 s2d_block_0.s2d_tails_hi_f_0.sa_A1 s2d_block_0.s2d_tails_lo_f_0.sb_A2 3.43851f
C528 vref iovdd 0.92461f
C529 s2d_block_0.s2d_tails_hi_f_0.sb_F2 s2d_block_0.s2d_tails_lo_f_0.sa_F2 1.64077f
C530 outp s2d_block_0.s2d_tails_lo_f_0.sa_F2 0.01977f
C531 s2d_block_0.s2d_tails_hi_f_0.sa_A1 outn 0.02153f
C532 s2d_block_0.s2d_tails_hi_f_0.sa_A1 s2d_block_0.s2d_casc_p_f_0.vbpc 0.02514f
C533 s2d_block_0.s2d_tails_hi_f_0.vbp s2d_block_0.s2d_tails_hi_f_0.sb_F1 0.2455f
C534 iref iovss 2.67053f
C535 vdd iovss 0.20836p
C536 s2d_block_0.s2d_loads_f_0.dd iovss 3.19021f
C537 s2d_block_0.s2d_loads_f_0.ln iovss 9.89804f
C538 s2d_block_0.s2d_loads_f_0.lp iovss 6.22746f
C539 a_14374_26190# iovss 1.16641f
C540 a_14374_26054# iovss 1.29287f
C541 a_14374_25918# iovss 1.39935f
C542 a_14374_25782# iovss 1.46247f
C543 a_14374_25646# iovss 1.47687f
C544 a_14374_25510# iovss 2.66141f
C545 a_11758_27006# iovss 1.03056f
C546 a_11758_26870# iovss 1.10629f
C547 a_11758_26734# iovss 1.21292f
C548 a_11758_26598# iovss 1.3156f
C549 a_11758_26462# iovss 1.38801f
C550 a_11758_26326# iovss 2.409f
C551 a_14374_27822# iovss 1.06639f
C552 a_14374_27686# iovss 1.18649f
C553 a_14374_27550# iovss 1.26601f
C554 a_14374_27414# iovss 1.34504f
C555 a_14374_27278# iovss 1.42889f
C556 a_14374_27142# iovss 2.67699f
C557 s2d_block_0.s2d_casc_n_f_0.xc iovss 83.8826f
C558 s2d_block_0.s2d_casc_n_f_0.yc iovss 47.58514f
C559 s2d_block_0.s2d_casc_n_f_0.x iovss 32.88367f
C560 s2d_block_0.s2d_casc_n_f_0.y iovss 39.41771f
C561 s2d_block_0.s2d_tails_lo_f_0.sa_M2 iovss 2.67627f
C562 s2d_block_0.s2d_tails_lo_f_0.sb_M1 iovss 3.81297f
C563 s2d_block_0.s2d_tails_lo_f_0.sb_A1 iovss 3.85353f
C564 s2d_block_0.s2d_tails_lo_f_0.sa_F2 iovss 19.38396f
C565 s2d_block_0.s2d_tails_lo_f_0.sa_F1 iovss 6.60435f
C566 s2d_block_0.s2d_tails_lo_f_0.sb_A2 iovss 9.08991f
C567 s2d_block_0.s2d_tails_hi_f_0.sb_M2 iovss 4.72933f
C568 s2d_block_0.s2d_tails_hi_f_0.sa_M1 iovss 7.29322f
C569 s2d_block_0.s2d_tails_hi_f_0.sa_A2 iovss 4.56941f
C570 s2d_block_0.s2d_tails_hi_f_0.sb_F1 iovss 24.34209f
C571 s2d_block_0.s2d_tails_hi_f_0.sb_F2 iovss 8.68036f
C572 s2d_block_0.s2d_tails_hi_f_0.sa_A1 iovss 5.54355f
Rport_vss vss iovss 1
.ends
