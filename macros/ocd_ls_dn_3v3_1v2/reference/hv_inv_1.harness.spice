.subckt hv_inv_1 vdd A X vss
*.PININFO A:I vdd:B vss:B X:O
XM1 X A vdd vdd sg13_hv_pmos w=2.0u l=0.4u ng=1 m=1 mm_ok=1
XM2 X A vss vss sg13_hv_nmos w=1.0u l=0.45u ng=1 m=1 mm_ok=1
.ends
