* PEX produced on Sun Aug 30 04:22:23 PM CEST 2026 using /foss/tools/sak/sak-pex.sh with m=3 and s=1 (extresist threshold=10000 mOhm, minres=1000 mOhm, mindelay=1 ps)
* NGSPICE file created from sg13cmos5l_cm_ip__single2diff2single_pex.ext - technology: ihp-sg13cmos5l

.subckt sg13cmos5l_cm_ip__single2diff2single_pex VPWR VAPWR VGND rst_n clk ena
+ uio_in[7] uio_in[6] uio_in[5] uio_in[4] uio_in[3] uio_in[2] uio_in[1]
+ uio_in[0] ui_in[7] ui_in[6] ui_in[5] ui_in[4] ui_in[3] ui_in[2] ui_in[1]
+ ui_in[0] uio_oe[7] uio_oe[6] uio_oe[5] uio_oe[4] uio_oe[3] uio_oe[2] uio_oe[1]
+ uio_oe[0] uio_out[7] uio_out[6] uio_out[5] uio_out[4] uio_out[3] uio_out[2]
+ uio_out[1] uio_out[0] uo_out[7] uo_out[6] uo_out[5] uo_out[4] uo_out[3]
+ uo_out[2] uo_out[1] uo_out[0] analog_2 analog_1 analog_0
X0 VAPWR VAPWR VAPWR VAPWR sg13_lv_pmos ad=1.14p pd=6.38u as=0.28875n ps=0.61464m w=6u l=1u
X1 VGND.t55 VGND.t53 VGND.t31 VGND.t54 sg13_lv_nmos ad=0.34p pd=2.68u as=0 ps=0 w=1u l=1u
X2 analog_1 analog_0 VGND.t1 VGND.t0 sg13_lv_nmos ad=0.19p pd=1.38u as=0.19p ps=1.38u w=1u l=1u
X3 analog_1 analog_0 VAPWR VAPWR sg13_lv_pmos ad=1.14p pd=6.38u as=1.14p ps=6.38u w=6u l=1u
X4 VAPWR ui_in[0].t1 analog_2 VAPWR sg13_lv_pmos ad=1.14p pd=6.38u as=1.14p ps=6.38u w=6u l=1u
X5 VAPWR analog_0 analog_1 VAPWR sg13_lv_pmos ad=1.14p pd=6.38u as=1.14p ps=6.38u w=6u l=1u
X6 analog_1 analog_0 VGND.t3 VGND.t4 sg13_lv_nmos ad=0.19p pd=1.38u as=0.19p ps=1.38u w=1u l=1u
X7 VAPWR analog_0 analog_1 VAPWR sg13_lv_pmos ad=1.14p pd=6.38u as=1.14p ps=6.38u w=6u l=1u
X8 VAPWR analog_0 analog_1 VAPWR sg13_lv_pmos ad=1.14p pd=6.38u as=1.14p ps=6.38u w=6u l=1u
X9 VGND.t9 analog_0 analog_1 VGND.t8 sg13_lv_nmos ad=0.19p pd=1.38u as=0.19p ps=1.38u w=1u l=1u
X10 VAPWR analog_0 analog_1 VAPWR sg13_lv_pmos ad=1.14p pd=6.38u as=1.14p ps=6.38u w=6u l=1u
X11 analog_1 analog_0 VAPWR VAPWR sg13_lv_pmos ad=1.14p pd=6.38u as=1.14p ps=6.38u w=6u l=1u
X12 analog_2 ui_in[0].t1 VAPWR VAPWR sg13_lv_pmos ad=1.14p pd=6.38u as=1.14p ps=6.38u w=6u l=1u
X13 VGND.t6 analog_0 analog_1 VGND.t5 sg13_lv_nmos ad=0.19p pd=1.38u as=0.19p ps=1.38u w=1u l=1u
X14 VGND.t12 analog_0 analog_1 VGND.t11 sg13_lv_nmos ad=0.19p pd=1.38u as=0.19p ps=1.38u w=1u l=1u
X15 analog_1 analog_0 VAPWR VAPWR sg13_lv_pmos ad=1.14p pd=6.38u as=1.14p ps=6.38u w=6u l=1u
X16 analog_2 ui_in[0].t1 VAPWR VAPWR sg13_lv_pmos ad=1.14p pd=6.38u as=1.14p ps=6.38u w=6u l=1u
X17 VAPWR analog_0 analog_1 VAPWR sg13_lv_pmos ad=1.14p pd=6.38u as=1.14p ps=6.38u w=6u l=1u
X18 VAPWR ui_in[0].t1 analog_2 VAPWR sg13_lv_pmos ad=1.14p pd=6.38u as=1.14p ps=6.38u w=6u l=1u
X19 VGND.t15 analog_0 analog_1 VGND.t14 sg13_lv_nmos ad=0.19p pd=1.38u as=0.19p ps=1.38u w=1u l=1u
X20 analog_1 analog_0 VGND.t21 VGND.t22 sg13_lv_nmos ad=0.19p pd=1.38u as=0.19p ps=1.38u w=1u l=1u
X21 analog_2 ui_in[0].t1 VAPWR VAPWR sg13_lv_pmos ad=1.14p pd=6.38u as=1.14p ps=6.38u w=6u l=1u
X22 VGND.t50 ui_in[0].t0 analog_2 VGND.t29 sg13_lv_nmos ad=0.19p pd=1.38u as=0.19p ps=1.38u w=1u l=1u
X23 analog_1 analog_0 VGND.t18 VGND.t19 sg13_lv_nmos ad=0.19p pd=1.38u as=0.19p ps=1.38u w=1u l=1u
X24 VAPWR analog_0 analog_1 VAPWR sg13_lv_pmos ad=1.14p pd=6.38u as=1.14p ps=6.38u w=6u l=1u
X25 VAPWR ui_in[0].t1 analog_2 VAPWR sg13_lv_pmos ad=1.14p pd=6.38u as=1.14p ps=6.38u w=6u l=1u
X26 analog_2 ui_in[0].t1 VAPWR VAPWR sg13_lv_pmos ad=1.14p pd=6.38u as=1.14p ps=6.38u w=6u l=1u
X27 analog_2 ui_in[0].t0 VGND.t31 VGND.t0 sg13_lv_nmos ad=0.19p pd=1.38u as=0.19p ps=1.38u w=1u l=1u
X28 VGND.t24 analog_0 analog_1 VGND.t23 sg13_lv_nmos ad=0.19p pd=1.38u as=0.19p ps=1.38u w=1u l=1u
X29 VAPWR VAPWR VAPWR VAPWR sg13_lv_pmos ad=1.14p pd=6.38u as=0 ps=0 w=6u l=1u
X30 analog_2 ui_in[0].t1 VAPWR VAPWR sg13_lv_pmos ad=1.14p pd=6.38u as=1.14p ps=6.38u w=6u l=1u
X31 analog_2 ui_in[0].t1 VAPWR VAPWR sg13_lv_pmos ad=1.14p pd=6.38u as=1.14p ps=6.38u w=6u l=1u
X32 VAPWR VAPWR VAPWR VAPWR sg13_lv_pmos ad=2.04p pd=12.68u as=0 ps=0 w=6u l=1u
X33 VGND.t27 analog_0 analog_1 VGND.t26 sg13_lv_nmos ad=0.19p pd=1.38u as=0.19p ps=1.38u w=1u l=1u
X34 VAPWR analog_0 analog_1 VAPWR sg13_lv_pmos ad=1.14p pd=6.38u as=1.14p ps=6.38u w=6u l=1u
X35 analog_2 ui_in[0].t0 VGND.t32 VGND.t4 sg13_lv_nmos ad=0.19p pd=1.38u as=0.19p ps=1.38u w=1u l=1u
X36 VGND.t30 VGND.t62 VGND.t63 VGND.t57 sg13_lv_nmos ad=0.19p pd=1.38u as=0 ps=0 w=1u l=1u
X37 VGND.t52 VPWR VGND.t52 VGND.t51 sg13_lv_pmos ad=3.4p pd=20.68u as=0 ps=0 w=10u l=10u
X38 VGND.t36 ui_in[0].t0 analog_2 VGND.t8 sg13_lv_nmos ad=0.19p pd=1.38u as=0.19p ps=1.38u w=1u l=1u
X39 VGND.t3 analog_0 analog_1 VGND.t2 sg13_lv_nmos ad=0.19p pd=1.38u as=0.19p ps=1.38u w=1u l=1u
X40 VGND.t34 ui_in[0].t0 analog_2 VGND.t5 sg13_lv_nmos ad=0.19p pd=1.38u as=0.19p ps=1.38u w=1u l=1u
X41 VGND.t38 ui_in[0].t0 analog_2 VGND.t11 sg13_lv_nmos ad=0.19p pd=1.38u as=0.19p ps=1.38u w=1u l=1u
X42 analog_1 analog_0 VAPWR VAPWR sg13_lv_pmos ad=1.14p pd=6.38u as=1.14p ps=6.38u w=6u l=1u
X43 analog_1 analog_0 VAPWR VAPWR sg13_lv_pmos ad=1.14p pd=6.38u as=1.14p ps=6.38u w=6u l=1u
X44 VGND.t40 ui_in[0].t0 analog_2 VGND.t14 sg13_lv_nmos ad=0.19p pd=1.38u as=0.19p ps=1.38u w=1u l=1u
X45 analog_2 ui_in[0].t0 VGND.t44 VGND.t22 sg13_lv_nmos ad=0.19p pd=1.38u as=0.19p ps=1.38u w=1u l=1u
X46 analog_1 analog_0 VGND.t9 VGND.t10 sg13_lv_nmos ad=0.19p pd=1.38u as=0.19p ps=1.38u w=1u l=1u
X47 VAPWR analog_0 analog_1 VAPWR sg13_lv_pmos ad=1.14p pd=6.38u as=1.14p ps=6.38u w=6u l=1u
X48 analog_2 ui_in[0].t0 VGND.t42 VGND.t19 sg13_lv_nmos ad=0.19p pd=1.38u as=0.19p ps=1.38u w=1u l=1u
X49 analog_1 analog_0 VAPWR VAPWR sg13_lv_pmos ad=1.14p pd=6.38u as=1.14p ps=6.38u w=6u l=1u
X50 VGND.t46 ui_in[0].t0 analog_2 VGND.t23 sg13_lv_nmos ad=0.19p pd=1.38u as=0.19p ps=1.38u w=1u l=1u
X51 analog_1 analog_0 VGND.t12 VGND.t13 sg13_lv_nmos ad=0.19p pd=1.38u as=0.19p ps=1.38u w=1u l=1u
X52 VAPWR analog_0 analog_1 VAPWR sg13_lv_pmos ad=1.14p pd=6.38u as=1.14p ps=6.38u w=6u l=1u
X53 analog_1 analog_0 VAPWR VAPWR sg13_lv_pmos ad=1.14p pd=6.38u as=1.14p ps=6.38u w=6u l=1u
X54 VAPWR ui_in[0].t1 analog_2 VAPWR sg13_lv_pmos ad=1.14p pd=6.38u as=1.14p ps=6.38u w=6u l=1u
X55 VGND.t18 analog_0 analog_1 VGND.t17 sg13_lv_nmos ad=0.19p pd=1.38u as=0.19p ps=1.38u w=1u l=1u
X56 analog_1 analog_0 VAPWR VAPWR sg13_lv_pmos ad=1.14p pd=6.38u as=1.14p ps=6.38u w=6u l=1u
X57 analog_1 analog_0 VAPWR VAPWR sg13_lv_pmos ad=1.14p pd=6.38u as=1.14p ps=6.38u w=6u l=1u
X58 analog_2 ui_in[0].t1 VAPWR VAPWR sg13_lv_pmos ad=1.14p pd=6.38u as=1.14p ps=6.38u w=6u l=1u
X59 VGND.t48 ui_in[0].t0 analog_2 VGND.t26 sg13_lv_nmos ad=0.19p pd=1.38u as=0.19p ps=1.38u w=1u l=1u
X60 analog_1 analog_0 VGND.t15 VGND.t16 sg13_lv_nmos ad=0.19p pd=1.38u as=0.19p ps=1.38u w=1u l=1u
X61 VAPWR VAPWR VAPWR VAPWR sg13_lv_pmos ad=2.04p pd=12.68u as=0 ps=0 w=6u l=1u
X62 VGND.t50 VGND.t56 VGND.t58 VGND.t57 sg13_lv_nmos ad=0.19p pd=1.38u as=0 ps=0 w=1u l=1u
X63 VGND.t21 analog_0 analog_1 VGND.t20 sg13_lv_nmos ad=0.19p pd=1.38u as=0.19p ps=1.38u w=1u l=1u
X64 analog_1 analog_0 VGND.t27 VGND.t28 sg13_lv_nmos ad=0.19p pd=1.38u as=0.19p ps=1.38u w=1u l=1u
X65 VGND.t61 VGND.t59 VGND.t1 VGND.t54 sg13_lv_nmos ad=0.34p pd=2.68u as=0 ps=0 w=1u l=1u
X66 analog_1 analog_0 VGND.t6 VGND.t7 sg13_lv_nmos ad=0.19p pd=1.38u as=0.19p ps=1.38u w=1u l=1u
X67 analog_1 analog_0 VGND.t24 VGND.t25 sg13_lv_nmos ad=0.19p pd=1.38u as=0.19p ps=1.38u w=1u l=1u
X68 analog_2 ui_in[0].t1 VAPWR VAPWR sg13_lv_pmos ad=1.14p pd=6.38u as=1.14p ps=6.38u w=6u l=1u
X69 VAPWR ui_in[0].t1 analog_2 VAPWR sg13_lv_pmos ad=1.14p pd=6.38u as=1.14p ps=6.38u w=6u l=1u
X70 VGND.t32 ui_in[0].t0 analog_2 VGND.t2 sg13_lv_nmos ad=0.19p pd=1.38u as=0.19p ps=1.38u w=1u l=1u
X71 VAPWR ui_in[0].t1 analog_2 VAPWR sg13_lv_pmos ad=1.14p pd=6.38u as=1.14p ps=6.38u w=6u l=1u
X72 VAPWR ui_in[0].t1 analog_2 VAPWR sg13_lv_pmos ad=1.14p pd=6.38u as=1.14p ps=6.38u w=6u l=1u
X73 analog_2 ui_in[0].t0 VGND.t36 VGND.t10 sg13_lv_nmos ad=0.19p pd=1.38u as=0.19p ps=1.38u w=1u l=1u
X74 VAPWR ui_in[0].t1 analog_2 VAPWR sg13_lv_pmos ad=1.14p pd=6.38u as=1.14p ps=6.38u w=6u l=1u
X75 analog_2 ui_in[0].t1 VAPWR VAPWR sg13_lv_pmos ad=1.14p pd=6.38u as=1.14p ps=6.38u w=6u l=1u
X76 analog_2 ui_in[0].t0 VGND.t38 VGND.t13 sg13_lv_nmos ad=0.19p pd=1.38u as=0.19p ps=1.38u w=1u l=1u
X77 analog_2 ui_in[0].t1 VAPWR VAPWR sg13_lv_pmos ad=1.14p pd=6.38u as=1.14p ps=6.38u w=6u l=1u
X78 VGND.t42 ui_in[0].t0 analog_2 VGND.t17 sg13_lv_nmos ad=0.19p pd=1.38u as=0.19p ps=1.38u w=1u l=1u
X79 VAPWR analog_0 analog_1 VAPWR sg13_lv_pmos ad=1.14p pd=6.38u as=1.14p ps=6.38u w=6u l=1u
X80 VAPWR ui_in[0].t1 analog_2 VAPWR sg13_lv_pmos ad=1.14p pd=6.38u as=1.14p ps=6.38u w=6u l=1u
X81 analog_2 ui_in[0].t0 VGND.t40 VGND.t16 sg13_lv_nmos ad=0.19p pd=1.38u as=0.19p ps=1.38u w=1u l=1u
X82 analog_1 analog_0 VAPWR VAPWR sg13_lv_pmos ad=1.14p pd=6.38u as=1.14p ps=6.38u w=6u l=1u
X83 VGND.t44 ui_in[0].t0 analog_2 VGND.t20 sg13_lv_nmos ad=0.19p pd=1.38u as=0.19p ps=1.38u w=1u l=1u
X84 analog_2 ui_in[0].t0 VGND.t48 VGND.t28 sg13_lv_nmos ad=0.19p pd=1.38u as=0.19p ps=1.38u w=1u l=1u
X85 VGND.t65 VAPWR VGND.t65 VGND.t64 sg13_lv_pmos ad=3.4p pd=20.68u as=0 ps=0 w=10u l=10u
X86 VAPWR ui_in[0].t1 analog_2 VAPWR sg13_lv_pmos ad=1.14p pd=6.38u as=1.14p ps=6.38u w=6u l=1u
X87 analog_2 ui_in[0].t0 VGND.t34 VGND.t7 sg13_lv_nmos ad=0.19p pd=1.38u as=0.19p ps=1.38u w=1u l=1u
X88 analog_2 ui_in[0].t0 VGND.t46 VGND.t25 sg13_lv_nmos ad=0.19p pd=1.38u as=0.19p ps=1.38u w=1u l=1u
X89 VGND.t30 analog_0 analog_1 VGND.t29 sg13_lv_nmos ad=0.19p pd=1.38u as=0.19p ps=1.38u w=1u l=1u
R0 ui_in[0].n15 ui_in[0].t1 0.994683
R1 ui_in[0].n17 ui_in[0].t0 0.994013
R2 ui_in[0].n9 ui_in[0].n1 0.748572
R3 ui_in[0].n10 ui_in[0].n9 0.578786
R4 ui_in[0].n11 ui_in[0].n10 0.578786
R5 ui_in[0].n12 ui_in[0].n11 0.578786
R6 ui_in[0].n13 ui_in[0].n12 0.578786
R7 ui_in[0].n14 ui_in[0].n13 0.578786
R8 ui_in[0].n15 ui_in[0].n14 0.578786
R9 ui_in[0].n0 ui_in[0].n24 0.755676
R10 ui_in[0].n24 ui_in[0].n23 0.578786
R11 ui_in[0].n23 ui_in[0].n22 0.578786
R12 ui_in[0].n22 ui_in[0].n21 0.578786
R13 ui_in[0].n21 ui_in[0].n20 0.578786
R14 ui_in[0].n20 ui_in[0].n19 0.578786
R15 ui_in[0].n19 ui_in[0].n18 0.578786
R16 ui_in[0].n18 ui_in[0].n17 0.578786
R17 ui_in[0].n14 ui_in[0].n8 0.254024
R18 ui_in[0].n13 ui_in[0].n7 0.254024
R19 ui_in[0].n12 ui_in[0].n6 0.254024
R20 ui_in[0].n11 ui_in[0].n5 0.254024
R21 ui_in[0].n10 ui_in[0].n4 0.254024
R22 ui_in[0].n9 ui_in[0].n3 0.254024
R23 ui_in[0].n1 ui_in[0].n2 0.0282822
R24 ui_in[0].n24 ui_in[0].n2 0.254024
R25 ui_in[0].n23 ui_in[0].n3 0.254024
R26 ui_in[0].n22 ui_in[0].n4 0.254024
R27 ui_in[0].n21 ui_in[0].n5 0.254024
R28 ui_in[0].n20 ui_in[0].n6 0.254024
R29 ui_in[0].n19 ui_in[0].n7 0.254024
R30 ui_in[0].n18 ui_in[0].n8 0.254024
R31 ui_in[0].n17 ui_in[0].n16 0.192615
R32 ui_in[0].n16 ui_in[0].n15 0.191641
R33 ui_in[0].n16 ui_in[0].n8 0.128842
R34 ui_in[0].n1 ui_in[0].n0 0.105962
R35 ui_in[0].n3 ui_in[0].n2 0.12194
R36 ui_in[0].n4 ui_in[0].n3 0.12194
R37 ui_in[0].n5 ui_in[0].n4 0.12194
R38 ui_in[0].n6 ui_in[0].n5 0.12194
R39 ui_in[0].n7 ui_in[0].n6 0.12194
R40 ui_in[0].n8 ui_in[0].n7 0.12194
R41 ui_in[0] ui_in[0].n0 40.295
R42 VGND.n355 VGND.n8 4688.03
R43 VGND.n32 VGND.t0 86.957
R44 VGND.t29 VGND.n12 86.957
R45 VGND.n33 VGND.t2 81.5222
R46 VGND.t28 VGND.n13 81.5222
R47 VGND.n34 VGND.t4 76.0875
R48 VGND.t26 VGND.n14 76.0875
R49 VGND.n35 VGND.t5 70.6527
R50 VGND.t25 VGND.n15 70.6527
R51 VGND.n36 VGND.t7 65.2179
R52 VGND.t23 VGND.n16 65.2179
R53 VGND.n37 VGND.t8 59.7831
R54 VGND.t22 VGND.n17 59.7831
R55 VGND.n38 VGND.t10 54.3483
R56 VGND.t14 VGND.n22 54.3483
R57 VGND.n42 VGND.t16 54.3483
R58 VGND.t20 VGND.n18 54.3483
R59 VGND.n39 VGND.t11 48.9135
R60 VGND.t13 VGND.n23 48.9135
R61 VGND.n43 VGND.t17 48.9135
R62 VGND.t19 VGND.n19 48.9135
R63 VGND.t11 VGND.n24 43.4788
R64 VGND.n40 VGND.t13 43.4788
R65 VGND.t17 VGND.n20 43.4788
R66 VGND.n44 VGND.t19 43.4788
R67 VGND.t10 VGND.n25 38.044
R68 VGND.n41 VGND.t14 38.044
R69 VGND.t16 VGND.n21 38.044
R70 VGND.n45 VGND.t20 38.044
R71 VGND.t8 VGND.n26 32.6092
R72 VGND.n46 VGND.t22 32.6092
R73 VGND.t7 VGND.n27 27.1744
R74 VGND.n47 VGND.t23 27.1744
R75 VGND.t5 VGND.n28 21.7396
R76 VGND.n48 VGND.t25 21.7396
R77 VGND.n6 VGND.n150 17.0005
R78 VGND.n6 VGND.n255 17.0005
R79 VGND.n6 VGND.n151 17.0005
R80 VGND.n6 VGND.t57 17.0005
R81 VGND.n6 VGND.n153 17.0005
R82 VGND.n6 VGND.n254 17.0005
R83 VGND.n6 VGND.n155 17.0005
R84 VGND.n4 VGND.n51 8.50066
R85 VGND.n4 VGND.n12 8.50069
R86 VGND.n6 VGND.n157 17.0005
R87 VGND.n6 VGND.n253 17.0005
R88 VGND.n6 VGND.n158 17.0005
R89 VGND.n6 VGND.n50 17.0005
R90 VGND.n6 VGND.n5 0.00103589
R91 VGND.n6 VGND.n250 17.0005
R92 VGND.n6 VGND.n249 17.0005
R93 VGND.n6 VGND.n159 17.0005
R94 VGND.n4 VGND.n49 8.5
R95 VGND.n6 VGND.n14 17.0005
R96 VGND.n6 VGND.n248 17.0005
R97 VGND.n6 VGND.n162 17.0005
R98 VGND.n6 VGND.n163 17.0005
R99 VGND.n6 VGND.n48 17.0005
R100 VGND.n4 VGND.n15 8.50072
R101 VGND.n6 VGND.n246 17.0005
R102 VGND.n6 VGND.n245 17.0005
R103 VGND.n6 VGND.n164 17.0005
R104 VGND.n6 VGND.n165 17.0005
R105 VGND.n6 VGND.n47 17.0005
R106 VGND.n6 VGND.n16 17.0005
R107 VGND.n6 VGND.n243 17.0005
R108 VGND.n6 VGND.n166 17.0005
R109 VGND.n6 VGND.n46 17.0005
R110 VGND.n4 VGND.n17 8.50029
R111 VGND.n6 VGND.n240 17.0005
R112 VGND.n6 VGND.n239 17.0005
R113 VGND.n6 VGND.n167 17.0005
R114 VGND.n6 VGND.n168 17.0005
R115 VGND.n4 VGND.n45 8.50064
R116 VGND.n6 VGND.n18 17.0005
R117 VGND.n6 VGND.n237 17.0005
R118 VGND.n6 VGND.n169 17.0005
R119 VGND.n6 VGND.n44 17.0005
R120 VGND.n5 VGND.n4 0.00197437
R121 VGND.n6 VGND.n234 17.0005
R122 VGND.n6 VGND.n233 17.0005
R123 VGND.n6 VGND.n170 17.0005
R124 VGND.n6 VGND.n171 17.0005
R125 VGND.n4 VGND.n43 8.50052
R126 VGND.n6 VGND.n20 17.0005
R127 VGND.n6 VGND.n230 17.0005
R128 VGND.n6 VGND.n172 17.0005
R129 VGND.n6 VGND.n42 17.0005
R130 VGND.n6 VGND.n21 17.0005
R131 VGND.n6 VGND.n227 17.0005
R132 VGND.n6 VGND.n143 17.0005
R133 VGND.n6 VGND.n173 17.0005
R134 VGND.n4 VGND.n41 8.49984
R135 VGND.n6 VGND.n22 17.0005
R136 VGND.n6 VGND.n175 17.0005
R137 VGND.n6 VGND.n226 17.0005
R138 VGND.n6 VGND.n176 17.0005
R139 VGND.n6 VGND.n40 17.0005
R140 VGND.n4 VGND.n23 8.5007
R141 VGND.n6 VGND.n223 17.0005
R142 VGND.n6 VGND.n222 17.0005
R143 VGND.n6 VGND.n177 17.0005
R144 VGND.n6 VGND.n178 17.0005
R145 VGND.n6 VGND.n39 17.0005
R146 VGND.n6 VGND.n24 17.0005
R147 VGND.n6 VGND.n219 17.0005
R148 VGND.n6 VGND.n218 17.0005
R149 VGND.n6 VGND.n179 17.0005
R150 VGND.n6 VGND.n38 17.0005
R151 VGND.n6 VGND.n25 17.0005
R152 VGND.n6 VGND.n217 17.0005
R153 VGND.n6 VGND.n182 17.0005
R154 VGND.n6 VGND.n183 17.0005
R155 VGND.n6 VGND.n37 17.0005
R156 VGND.n6 VGND.n26 17.0005
R157 VGND.n6 VGND.n215 17.0005
R158 VGND.n6 VGND.n214 17.0005
R159 VGND.n6 VGND.n184 17.0005
R160 VGND.n4 VGND.n36 8.50073
R161 VGND.n6 VGND.n27 17.0005
R162 VGND.n6 VGND.n213 17.0005
R163 VGND.n6 VGND.n187 17.0005
R164 VGND.n6 VGND.n188 17.0005
R165 VGND.n6 VGND.n35 17.0005
R166 VGND.n4 VGND.n28 8.50056
R167 VGND.n6 VGND.n211 17.0005
R168 VGND.n6 VGND.n189 17.0005
R169 VGND.n4 VGND.n34 8.50038
R170 VGND.n6 VGND.n29 17.0005
R171 VGND.n6 VGND.n208 17.0005
R172 VGND.n6 VGND.n207 17.0005
R173 VGND.n6 VGND.n190 17.0005
R174 VGND.n6 VGND.n191 17.0005
R175 VGND.n6 VGND.n33 17.0005
R176 VGND.n6 VGND.n30 17.0005
R177 VGND.n6 VGND.n204 17.0005
R178 VGND.n6 VGND.n192 17.0005
R179 VGND.n6 VGND.n32 17.0005
R180 VGND.n6 VGND.n31 17.0005
R181 VGND.n6 VGND.n201 17.0005
R182 VGND.n6 VGND.n193 17.0005
R183 VGND.n6 VGND.n199 17.0005
R184 VGND.n6 VGND.t54 17.0005
R185 VGND.n6 VGND.n197 17.0005
R186 VGND.n6 VGND.n10 17.0005
R187 VGND.n6 VGND.n194 17.0005
R188 VGND.n6 VGND.n196 17.0005
R189 VGND.n6 VGND.n195 17.0005
R190 VGND.n352 VGND.n99 17.0005
R191 VGND.n99 VGND.n303 17.0005
R192 VGND.n340 VGND.n99 17.0005
R193 VGND.n99 VGND.n301 17.0005
R194 VGND.n99 VGND.n266 17.0005
R195 VGND.n99 VGND.n292 17.0005
R196 VGND.n99 VGND.n269 17.0005
R197 VGND.n99 VGND.n288 17.0005
R198 VGND.n99 VGND.n271 17.0005
R199 VGND.n99 VGND.n284 17.0005
R200 VGND.n4 VGND.n50 17.0005
R201 VGND.n5 VGND.n13 8.50219
R202 VGND.n4 VGND.n14 17.0005
R203 VGND.n4 VGND.n48 17.0005
R204 VGND.n4 VGND.n47 17.0005
R205 VGND.n4 VGND.n16 17.0005
R206 VGND.n4 VGND.n46 17.0005
R207 VGND.n4 VGND.n18 17.0005
R208 VGND.n4 VGND.n44 17.0005
R209 VGND.n4 VGND.n19 8.49925
R210 VGND.n4 VGND.n20 17.0005
R211 VGND.n4 VGND.n42 17.0005
R212 VGND.n4 VGND.n21 17.0005
R213 VGND.n4 VGND.n22 17.0005
R214 VGND.n4 VGND.n40 17.0005
R215 VGND.n4 VGND.n39 17.0005
R216 VGND.n4 VGND.n24 17.0005
R217 VGND.n4 VGND.n38 17.0005
R218 VGND.n4 VGND.n25 17.0005
R219 VGND.n4 VGND.n37 17.0005
R220 VGND.n4 VGND.n26 17.0005
R221 VGND.n4 VGND.n27 17.0005
R222 VGND.n4 VGND.n35 17.0005
R223 VGND.n4 VGND.n29 17.0005
R224 VGND.n4 VGND.n33 17.0005
R225 VGND.n4 VGND.n30 17.0005
R226 VGND.n4 VGND.n32 17.0005
R227 VGND.n4 VGND.n31 17.0005
R228 VGND.t4 VGND.n29 16.3048
R229 VGND.n49 VGND.t26 16.3048
R230 VGND.t53 VGND.n149 15.0005
R231 VGND.t62 VGND.n350 15.0005
R232 VGND.n337 VGND.t56 15.0005
R233 VGND.n360 VGND.t59 15.0005
R234 VGND.n332 VGND.n7 14.141
R235 VGND.n318 VGND.n227 13.099
R236 VGND.n318 VGND.n173 13.099
R237 VGND.n332 VGND.n331 12.4279
R238 VGND.n330 VGND.n255 12.4279
R239 VGND.n329 VGND.t57 12.4279
R240 VGND.n328 VGND.n254 12.4279
R241 VGND.n327 VGND.n253 12.4279
R242 VGND.n326 VGND.n250 12.4279
R243 VGND.n325 VGND.n248 12.4279
R244 VGND.n324 VGND.n246 12.4279
R245 VGND.n323 VGND.n243 12.4279
R246 VGND.n322 VGND.n240 12.4279
R247 VGND.n321 VGND.n237 12.4279
R248 VGND.n320 VGND.n234 12.4279
R249 VGND.n319 VGND.n230 12.4279
R250 VGND.n317 VGND.n226 12.4279
R251 VGND.n316 VGND.n223 12.4279
R252 VGND.n315 VGND.n219 12.4279
R253 VGND.n314 VGND.n217 12.4279
R254 VGND.n313 VGND.n215 12.4279
R255 VGND.n312 VGND.n213 12.4279
R256 VGND.n311 VGND.n211 12.4279
R257 VGND.n310 VGND.n208 12.4279
R258 VGND.n309 VGND.n204 12.4279
R259 VGND.n308 VGND.n201 12.4279
R260 VGND.n307 VGND.n199 12.4279
R261 VGND.n306 VGND.n197 12.4279
R262 VGND.n305 VGND.n196 12.4279
R263 VGND.n305 VGND.n195 12.4279
R264 VGND.n306 VGND.n194 12.4279
R265 VGND.n307 VGND.t54 12.4279
R266 VGND.n308 VGND.n193 12.4279
R267 VGND.n309 VGND.n192 12.4279
R268 VGND.n310 VGND.n190 12.4279
R269 VGND.n311 VGND.n189 12.4279
R270 VGND.n312 VGND.n187 12.4279
R271 VGND.n313 VGND.n184 12.4279
R272 VGND.n314 VGND.n182 12.4279
R273 VGND.n315 VGND.n179 12.4279
R274 VGND.n316 VGND.n177 12.4279
R275 VGND.n317 VGND.n176 12.4279
R276 VGND.n319 VGND.n172 12.4279
R277 VGND.n320 VGND.n170 12.4279
R278 VGND.n321 VGND.n169 12.4279
R279 VGND.n322 VGND.n167 12.4279
R280 VGND.n323 VGND.n166 12.4279
R281 VGND.n324 VGND.n164 12.4279
R282 VGND.n325 VGND.n162 12.4279
R283 VGND.n326 VGND.n159 12.4279
R284 VGND.n327 VGND.n158 12.4279
R285 VGND.n328 VGND.n155 12.4279
R286 VGND.n329 VGND.n153 12.4279
R287 VGND.n330 VGND.n151 12.4279
R288 VGND.n331 VGND.n150 12.4279
R289 VGND.t2 VGND.n30 10.8701
R290 VGND.n50 VGND.t28 10.8701
R291 VGND.n99 VGND.n100 0.00140728
R292 VGND.n355 VGND.n4 1.70039
R293 VGND.t51 VGND.n111 1.88976
R294 VGND.n0 VGND.t51 0.129064
R295 VGND.n110 VGND.t51 2.83428
R296 VGND.n105 VGND.n110 0.00158329
R297 VGND.n102 VGND.n0 0.0161483
R298 VGND.n99 VGND.n332 8.5005
R299 VGND.n6 VGND.n9 2.08781
R300 VGND.t52 VGND.n124 8.5005
R301 VGND.t52 VGND.n104 0.111013
R302 VGND.n6 VGND.n152 8.4984
R303 VGND.n6 VGND.n154 8.4984
R304 VGND.n6 VGND.n156 8.4984
R305 VGND.n6 VGND.n252 8.4984
R306 VGND.n6 VGND.n251 8.4984
R307 VGND.n6 VGND.n160 8.4984
R308 VGND.n6 VGND.n161 8.4984
R309 VGND.n6 VGND.n247 8.4984
R310 VGND.n6 VGND.n244 8.4984
R311 VGND.n6 VGND.n242 8.4984
R312 VGND.n6 VGND.n241 8.4984
R313 VGND.n6 VGND.n238 8.4984
R314 VGND.n6 VGND.n236 8.4984
R315 VGND.n6 VGND.n235 8.4984
R316 VGND.n6 VGND.n231 8.4984
R317 VGND.n6 VGND.n229 8.4984
R318 VGND.n6 VGND.n228 8.4984
R319 VGND.n6 VGND.n174 8.4984
R320 VGND.n6 VGND.n225 8.4984
R321 VGND.n6 VGND.n224 8.4984
R322 VGND.n6 VGND.n220 8.4984
R323 VGND.n6 VGND.n180 8.4984
R324 VGND.n6 VGND.n181 8.4984
R325 VGND.n6 VGND.n216 8.4984
R326 VGND.n6 VGND.n185 8.4984
R327 VGND.n6 VGND.n186 8.4984
R328 VGND.n6 VGND.n212 8.4984
R329 VGND.n6 VGND.n210 8.4984
R330 VGND.n6 VGND.n209 8.4984
R331 VGND.n6 VGND.n205 8.4984
R332 VGND.n6 VGND.n203 8.4984
R333 VGND.n6 VGND.n202 8.4984
R334 VGND.n6 VGND.n200 8.4984
R335 VGND.n6 VGND.n198 8.4984
R336 VGND.n99 VGND.n256 8.4984
R337 VGND.n99 VGND.n304 8.4984
R338 VGND.n99 VGND.n257 8.4984
R339 VGND.n99 VGND.n302 8.4984
R340 VGND.n99 VGND.n258 8.4984
R341 VGND.n99 VGND.n259 8.4984
R342 VGND.n99 VGND.n260 8.4984
R343 VGND.n99 VGND.n300 8.4984
R344 VGND.n99 VGND.n299 8.4984
R345 VGND.n99 VGND.n261 8.4984
R346 VGND.n99 VGND.n298 8.4984
R347 VGND.n99 VGND.n297 8.4984
R348 VGND.n99 VGND.n262 8.4984
R349 VGND.n99 VGND.n296 8.4984
R350 VGND.n99 VGND.n295 8.4984
R351 VGND.n99 VGND.n294 8.4984
R352 VGND.n99 VGND.n263 8.4984
R353 VGND.n99 VGND.n264 8.4984
R354 VGND.n99 VGND.n293 8.4984
R355 VGND.n99 VGND.n265 8.4984
R356 VGND.n99 VGND.n267 8.4984
R357 VGND.n99 VGND.n291 8.4984
R358 VGND.n99 VGND.n268 8.4984
R359 VGND.n99 VGND.n290 8.4984
R360 VGND.n99 VGND.n289 8.4984
R361 VGND.n99 VGND.n270 8.4984
R362 VGND.n99 VGND.n286 8.4984
R363 VGND.n99 VGND.n285 8.4984
R364 VGND.n99 VGND.n272 8.4984
R365 VGND.n99 VGND.n282 8.4984
R366 VGND.n99 VGND.n281 8.4984
R367 VGND.n99 VGND.n280 8.4984
R368 VGND.n99 VGND.n279 8.4984
R369 VGND.n99 VGND.n273 8.4984
R370 VGND.n99 VGND.n278 8.4984
R371 VGND.n99 VGND.n277 8.4984
R372 VGND.n99 VGND.n274 8.4984
R373 VGND.n99 VGND.n276 8.4984
R374 VGND.n99 VGND.n275 8.4984
R375 VGND.n2 VGND.n1 0.0364198
R376 VGND.n108 VGND.n107 2.71665
R377 VGND.n2 VGND.n108 1.78621
R378 VGND.n105 VGND.n106 2.30972
R379 VGND.n106 VGND.n108 0.775541
R380 VGND.n2 VGND.n109 1.77941
R381 VGND.n195 VGND.n98 7.65593
R382 VGND.n357 VGND.t53 7.49606
R383 VGND.n351 VGND.t62 7.49606
R384 VGND.t56 VGND.n333 7.49606
R385 VGND.t59 VGND.n148 7.49606
R386 VGND.n86 VGND.n153 7.18094
R387 VGND.n87 VGND.n155 7.18094
R388 VGND.n88 VGND.n158 7.18094
R389 VGND.n89 VGND.n13 7.18094
R390 VGND.n90 VGND.n159 7.18094
R391 VGND.n56 VGND.n162 7.18094
R392 VGND.n91 VGND.n15 7.18094
R393 VGND.n92 VGND.n164 7.18094
R394 VGND.n93 VGND.n166 7.18094
R395 VGND.n58 VGND.n17 7.18094
R396 VGND.n60 VGND.n18 7.18094
R397 VGND.n94 VGND.n169 7.18094
R398 VGND.n61 VGND.n19 7.18094
R399 VGND.n63 VGND.n20 7.18094
R400 VGND.n64 VGND.n172 7.18094
R401 VGND.n67 VGND.n22 7.18094
R402 VGND.n68 VGND.n176 7.18094
R403 VGND.n69 VGND.n23 7.18094
R404 VGND.n72 VGND.n179 7.18094
R405 VGND.n73 VGND.n25 7.18094
R406 VGND.n74 VGND.n182 7.18094
R407 VGND.n75 VGND.n26 7.18094
R408 VGND.n95 VGND.n27 7.18094
R409 VGND.n78 VGND.n28 7.18094
R410 VGND.n81 VGND.n190 7.18094
R411 VGND.n84 VGND.n31 7.18094
R412 VGND.n96 VGND.n193 7.18094
R413 VGND.n85 VGND.t54 7.18094
R414 VGND.n97 VGND.n194 7.18094
R415 VGND.n83 VGND.n32 7.18094
R416 VGND.n82 VGND.n204 7.18094
R417 VGND.n80 VGND.n208 7.18094
R418 VGND.n79 VGND.n34 7.18094
R419 VGND.n77 VGND.n35 7.18094
R420 VGND.n76 VGND.n36 7.18094
R421 VGND.n71 VGND.n219 7.18094
R422 VGND.n70 VGND.n39 7.18094
R423 VGND.n66 VGND.n41 7.18094
R424 VGND.n65 VGND.n227 7.18094
R425 VGND.n62 VGND.n43 7.18094
R426 VGND.n59 VGND.n45 7.18094
R427 VGND.n57 VGND.n243 7.18094
R428 VGND.n55 VGND.n248 7.18094
R429 VGND.n54 VGND.n253 7.18094
R430 VGND.n53 VGND.t57 7.18094
R431 VGND.n52 VGND.n255 7.18094
R432 VGND.n86 VGND.n254 7.18026
R433 VGND.n87 VGND.n51 7.18026
R434 VGND.n88 VGND.n50 7.18026
R435 VGND.n89 VGND.n250 7.18026
R436 VGND.n90 VGND.n49 7.18026
R437 VGND.n56 VGND.n48 7.18026
R438 VGND.n91 VGND.n246 7.18026
R439 VGND.n92 VGND.n47 7.18026
R440 VGND.n93 VGND.n46 7.18026
R441 VGND.n58 VGND.n240 7.18026
R442 VGND.n60 VGND.n237 7.18026
R443 VGND.n94 VGND.n44 7.18026
R444 VGND.n61 VGND.n234 7.18026
R445 VGND.n63 VGND.n230 7.18026
R446 VGND.n64 VGND.n42 7.18026
R447 VGND.n67 VGND.n226 7.18026
R448 VGND.n68 VGND.n40 7.18026
R449 VGND.n69 VGND.n223 7.18026
R450 VGND.n72 VGND.n38 7.18026
R451 VGND.n73 VGND.n217 7.18026
R452 VGND.n74 VGND.n37 7.18026
R453 VGND.n75 VGND.n215 7.18026
R454 VGND.n95 VGND.n213 7.18026
R455 VGND.n78 VGND.n211 7.18026
R456 VGND.n81 VGND.n33 7.18026
R457 VGND.n84 VGND.n201 7.18026
R458 VGND.n96 VGND.n199 7.18026
R459 VGND.n85 VGND.n197 7.18026
R460 VGND.n97 VGND.n196 7.18026
R461 VGND.n52 VGND.n150 7.18026
R462 VGND.n53 VGND.n151 7.18026
R463 VGND.n54 VGND.n12 7.18026
R464 VGND.n55 VGND.n14 7.18026
R465 VGND.n57 VGND.n16 7.18026
R466 VGND.n59 VGND.n167 7.18026
R467 VGND.n62 VGND.n170 7.18026
R468 VGND.n65 VGND.n21 7.18026
R469 VGND.n66 VGND.n173 7.18026
R470 VGND.n70 VGND.n177 7.18026
R471 VGND.n71 VGND.n24 7.18026
R472 VGND.n76 VGND.n184 7.18026
R473 VGND.n77 VGND.n187 7.18026
R474 VGND.n79 VGND.n189 7.18026
R475 VGND.n80 VGND.n29 7.18026
R476 VGND.n82 VGND.n30 7.18026
R477 VGND.n83 VGND.n192 7.18026
R478 VGND.n100 VGND.n8 1.70119
R479 VGND.n7 VGND.n8 1.4149
R480 VGND.n123 VGND.t51 5.66778
R481 VGND.n1 VGND.n0 0.00744518
R482 VGND.n103 VGND.n104 1.81423
R483 VGND.n3 VGND.n9 1.67523
R484 VGND.n109 VGND.n102 3.30338
R485 VGND.t0 VGND.n31 5.43528
R486 VGND.n51 VGND.t29 5.43528
R487 VGND.t1 VGND.n147 4.5005
R488 VGND.n358 VGND.t31 4.5005
R489 VGND.t30 VGND.n349 4.5005
R490 VGND.t50 VGND.n336 4.5005
R491 VGND.n99 VGND.n11 4.25247
R492 VGND.n354 VGND.n99 4.25206
R493 VGND.n6 VGND.n354 4.25175
R494 VGND.n6 VGND.n11 4.25172
R495 VGND.n99 VGND.n101 0.00325482
R496 VGND.n362 VGND.n361 3.0005
R497 VGND.n356 VGND.n146 3.0005
R498 VGND.n348 VGND.n335 3.0005
R499 VGND.n339 VGND.n338 3.0005
R500 VGND.n364 VGND.t3 2.48177
R501 VGND.n365 VGND.t6 2.48177
R502 VGND.n366 VGND.t9 2.48177
R503 VGND.n145 VGND.t12 2.48177
R504 VGND.t18 VGND.n144 2.48177
R505 VGND.n344 VGND.t21 2.48177
R506 VGND.n345 VGND.t24 2.48177
R507 VGND.n346 VGND.t27 2.48177
R508 VGND.n364 VGND.t32 2.48177
R509 VGND.n365 VGND.t34 2.48177
R510 VGND.n366 VGND.t36 2.48177
R511 VGND.n145 VGND.t38 2.48177
R512 VGND.t42 VGND.n144 2.48177
R513 VGND.n344 VGND.t44 2.48177
R514 VGND.n345 VGND.t46 2.48177
R515 VGND.n346 VGND.t48 2.48177
R516 VGND.n331 VGND.n4 2.28755
R517 VGND.n4 VGND.n330 2.28755
R518 VGND.n4 VGND.n329 2.28755
R519 VGND.n4 VGND.n328 2.28755
R520 VGND.n4 VGND.n327 2.28755
R521 VGND.n4 VGND.n326 2.28755
R522 VGND.n4 VGND.n325 2.28755
R523 VGND.n4 VGND.n324 2.28755
R524 VGND.n4 VGND.n323 2.28755
R525 VGND.n4 VGND.n322 2.28755
R526 VGND.n4 VGND.n321 2.28755
R527 VGND.n4 VGND.n320 2.28755
R528 VGND.n4 VGND.n319 2.28755
R529 VGND.n4 VGND.n317 2.28755
R530 VGND.n4 VGND.n316 2.28755
R531 VGND.n4 VGND.n315 2.28755
R532 VGND.n4 VGND.n314 2.28755
R533 VGND.n4 VGND.n313 2.28755
R534 VGND.n4 VGND.n312 2.28755
R535 VGND.n4 VGND.n311 2.28755
R536 VGND.n4 VGND.n310 2.28755
R537 VGND.n4 VGND.n309 2.28755
R538 VGND.n4 VGND.n308 2.28755
R539 VGND.n4 VGND.n307 2.28755
R540 VGND.n4 VGND.n306 2.28755
R541 VGND.n4 VGND.n305 2.28755
R542 VGND.t61 VGND.n147 2.2505
R543 VGND.t55 VGND.n358 2.2505
R544 VGND.n349 VGND.t63 2.2505
R545 VGND.n336 VGND.t58 2.2505
R546 VGND.n4 VGND.n318 1.95198
R547 VGND VGND.n367 1.88203
R548 VGND.n334 VGND.n101 1.18318
R549 VGND.n355 VGND.n98 1.53271
R550 VGND.n367 VGND.n141 1.49725
R551 VGND.n367 VGND.n140 1.41932
R552 VGND.n6 VGND.n7 0.261291
R553 VGND.n99 VGND.n52 0.661826
R554 VGND.n99 VGND.n53 0.661826
R555 VGND.n99 VGND.n54 0.661826
R556 VGND.n99 VGND.n55 0.661826
R557 VGND.n99 VGND.n56 0.661826
R558 VGND.n99 VGND.n57 0.661826
R559 VGND.n99 VGND.n58 0.661826
R560 VGND.n99 VGND.n59 0.661826
R561 VGND.n99 VGND.n60 0.661826
R562 VGND.n99 VGND.n61 0.661826
R563 VGND.n99 VGND.n62 0.661826
R564 VGND.n99 VGND.n63 0.661826
R565 VGND.n99 VGND.n64 0.661826
R566 VGND.n99 VGND.n65 0.661826
R567 VGND.n99 VGND.n66 0.661826
R568 VGND.n99 VGND.n67 0.661826
R569 VGND.n99 VGND.n68 0.661826
R570 VGND.n99 VGND.n69 0.661826
R571 VGND.n99 VGND.n70 0.661826
R572 VGND.n99 VGND.n71 0.661826
R573 VGND.n99 VGND.n72 0.661826
R574 VGND.n99 VGND.n73 0.661826
R575 VGND.n99 VGND.n74 0.661826
R576 VGND.n99 VGND.n75 0.661826
R577 VGND.n99 VGND.n76 0.661826
R578 VGND.n99 VGND.n77 0.661826
R579 VGND.n99 VGND.n78 0.661826
R580 VGND.n99 VGND.n79 0.661826
R581 VGND.n99 VGND.n80 0.661826
R582 VGND.n99 VGND.n81 0.661826
R583 VGND.n99 VGND.n82 0.661826
R584 VGND.n99 VGND.n83 0.661826
R585 VGND.n99 VGND.n84 0.661826
R586 VGND.n99 VGND.n85 0.661826
R587 VGND.n99 VGND.n86 0.661826
R588 VGND.n99 VGND.n87 0.661826
R589 VGND.n99 VGND.n88 0.661826
R590 VGND.n99 VGND.n89 0.661826
R591 VGND.n99 VGND.n90 0.661826
R592 VGND.n99 VGND.n91 0.661826
R593 VGND.n99 VGND.n92 0.661826
R594 VGND.n99 VGND.n93 0.661826
R595 VGND.n99 VGND.n94 0.661826
R596 VGND.n99 VGND.n95 0.661826
R597 VGND.n99 VGND.n96 0.661826
R598 VGND.n99 VGND.n97 0.661826
R599 VGND.n125 VGND.t52 0.412831
R600 VGND.n116 VGND.t65 0.412464
R601 VGND.n126 VGND.n112 0.41245
R602 VGND.n139 VGND.n138 0.41245
R603 VGND.n128 VGND.n127 0.409591
R604 VGND.n130 VGND.n129 0.409591
R605 VGND.n132 VGND.n131 0.409591
R606 VGND.n134 VGND.n133 0.409591
R607 VGND.n136 VGND.n135 0.409591
R608 VGND.n137 VGND.n115 0.409591
R609 VGND.n126 VGND.n125 0.409591
R610 VGND.n127 VGND.n122 0.409591
R611 VGND.n130 VGND.n121 0.409591
R612 VGND.n131 VGND.n120 0.409591
R613 VGND.n134 VGND.n119 0.409591
R614 VGND.n136 VGND.n118 0.409591
R615 VGND.n137 VGND.n117 0.409591
R616 VGND.n138 VGND.n116 0.409591
R617 VGND.n106 VGND.t52 0.251731
R618 VGND.t64 VGND.t65 0.652438
R619 VGND.n140 VGND.n112 0.204366
R620 VGND.n140 VGND.n113 0.204366
R621 VGND.n140 VGND.n114 0.204366
R622 VGND.n140 VGND.n139 0.204366
R623 VGND.n206 VGND.t32 0.200997
R624 VGND.n283 VGND.t34 0.200997
R625 VGND.n287 VGND.t36 0.200997
R626 VGND.n221 VGND.t38 0.200997
R627 VGND.n232 VGND.t42 0.200997
R628 VGND.t44 VGND.n343 0.200997
R629 VGND.t46 VGND.n342 0.200997
R630 VGND.t48 VGND.n341 0.200997
R631 VGND.n206 VGND.t3 0.200995
R632 VGND.n283 VGND.t6 0.200995
R633 VGND.n287 VGND.t9 0.200995
R634 VGND.n221 VGND.t12 0.200995
R635 VGND.n232 VGND.t18 0.200995
R636 VGND.n343 VGND.t21 0.200995
R637 VGND.n342 VGND.t24 0.200995
R638 VGND.n341 VGND.t27 0.200995
R639 VGND.n142 VGND.t15 0.185126
R640 VGND.n99 VGND.n98 0.142116
R641 VGND.t55 VGND.n3 1.06058
R642 VGND.n364 VGND.n363 0.117247
R643 VGND.n347 VGND.n346 0.1171
R644 VGND.n9 VGND.t58 0.109077
R645 VGND.n104 VGND.n109 0.69354
R646 VGND.n365 VGND.n364 0.08146
R647 VGND.n366 VGND.n365 0.08146
R648 VGND.n145 VGND.n366 0.08146
R649 VGND.n141 VGND.n145 0.08146
R650 VGND.n141 VGND.n144 0.08146
R651 VGND.n344 VGND.n144 0.08146
R652 VGND.n345 VGND.n344 0.08146
R653 VGND.n346 VGND.n345 0.08146
R654 VGND.t63 VGND.n334 0.0592831
R655 VGND.t31 VGND.n357 0.031258
R656 VGND.n148 VGND.t1 0.031258
R657 VGND.n363 VGND.n362 0.0291125
R658 VGND.n363 VGND.n146 0.0291125
R659 VGND.n347 VGND.n339 0.0291125
R660 VGND.n348 VGND.n347 0.0291125
R661 VGND.n362 VGND.n147 0.0281144
R662 VGND.n358 VGND.n146 0.0281144
R663 VGND.n339 VGND.n336 0.0281144
R664 VGND.n349 VGND.n348 0.0281144
R665 VGND.n353 VGND.n351 0.0216549
R666 VGND.n353 VGND.n333 0.0216549
R667 VGND.n350 VGND.t30 0.0208704
R668 VGND.n337 VGND.t50 0.0208704
R669 VGND.n356 VGND.n149 0.0202884
R670 VGND.n350 VGND.n335 0.0202884
R671 VGND.n338 VGND.n337 0.0202884
R672 VGND.n361 VGND.n360 0.0202884
R673 VGND.n142 VGND.n141 0.0194533
R674 VGND.n354 VGND.n353 0.0162424
R675 VGND.n359 VGND.n11 0.0158083
R676 VGND.n256 VGND.n152 0.0118857
R677 VGND.n304 VGND.n156 0.0118857
R678 VGND.n257 VGND.n156 0.0118857
R679 VGND.n302 VGND.n252 0.0118857
R680 VGND.n259 VGND.n160 0.0118857
R681 VGND.n260 VGND.n161 0.0118857
R682 VGND.n300 VGND.n247 0.0118857
R683 VGND.n261 VGND.n242 0.0118857
R684 VGND.n298 VGND.n242 0.0118857
R685 VGND.n297 VGND.n241 0.0118857
R686 VGND.n262 VGND.n238 0.0118857
R687 VGND.n296 VGND.n238 0.0118857
R688 VGND.n295 VGND.n236 0.0118857
R689 VGND.n294 VGND.n235 0.0118857
R690 VGND.n263 VGND.n231 0.0118857
R691 VGND.n264 VGND.n229 0.0118857
R692 VGND.n293 VGND.n229 0.0118857
R693 VGND.n267 VGND.n174 0.0118857
R694 VGND.n291 VGND.n225 0.0118857
R695 VGND.n289 VGND.n220 0.0118857
R696 VGND.n270 VGND.n180 0.0118857
R697 VGND.n285 VGND.n216 0.0118857
R698 VGND.n272 VGND.n185 0.0118857
R699 VGND.n281 VGND.n212 0.0118857
R700 VGND.n280 VGND.n210 0.0118857
R701 VGND.n279 VGND.n209 0.0118857
R702 VGND.n273 VGND.n205 0.0118857
R703 VGND.n278 VGND.n205 0.0118857
R704 VGND.n277 VGND.n203 0.0118857
R705 VGND.n274 VGND.n200 0.0118857
R706 VGND.n276 VGND.n200 0.0118857
R707 VGND.n275 VGND.n198 0.0118857
R708 VGND.n276 VGND.n198 0.0118857
R709 VGND.n274 VGND.n202 0.0118857
R710 VGND.n277 VGND.n202 0.0118857
R711 VGND.n278 VGND.n203 0.0118857
R712 VGND.n280 VGND.n209 0.0118857
R713 VGND.n281 VGND.n210 0.0118857
R714 VGND.n282 VGND.n212 0.0118857
R715 VGND.n272 VGND.n186 0.0118857
R716 VGND.n286 VGND.n216 0.0118857
R717 VGND.n270 VGND.n181 0.0118857
R718 VGND.n290 VGND.n220 0.0118857
R719 VGND.n268 VGND.n224 0.0118857
R720 VGND.n291 VGND.n224 0.0118857
R721 VGND.n265 VGND.n228 0.0118857
R722 VGND.n293 VGND.n228 0.0118857
R723 VGND.n264 VGND.n231 0.0118857
R724 VGND.n295 VGND.n235 0.0118857
R725 VGND.n296 VGND.n236 0.0118857
R726 VGND.n298 VGND.n241 0.0118857
R727 VGND.n261 VGND.n244 0.0118857
R728 VGND.n299 VGND.n244 0.0118857
R729 VGND.n259 VGND.n161 0.0118857
R730 VGND.n258 VGND.n251 0.0118857
R731 VGND.n302 VGND.n251 0.0118857
R732 VGND.n304 VGND.n154 0.0118857
R733 VGND.n256 VGND.n154 0.0118857
R734 VGND.n359 VGND.n149 0.0115582
R735 VGND.n360 VGND.n359 0.0115582
R736 VGND.n271 VGND.n214 0.0108889
R737 VGND.n269 VGND.n218 0.0108889
R738 VGND.n292 VGND.n175 0.0108889
R739 VGND.n301 VGND.n163 0.0108889
R740 VGND.n303 VGND.n157 0.0108889
R741 VGND.n357 VGND.n356 0.0108877
R742 VGND.n351 VGND.n335 0.0108877
R743 VGND.n338 VGND.n333 0.0108877
R744 VGND.n361 VGND.n148 0.0108877
R745 VGND.n353 VGND.t63 0.0101032
R746 VGND.n353 VGND.t58 0.0101032
R747 VGND.n359 VGND.t55 0.00981217
R748 VGND.n359 VGND.t61 0.00981217
R749 VGND.n207 VGND.n206 0.00936111
R750 VGND.n341 VGND.n340 0.00936111
R751 VGND.n284 VGND.n283 0.00813889
R752 VGND.n342 VGND.n165 0.00813889
R753 VGND.n4 VGND.n3 0.00470124
R754 VGND.n288 VGND.n287 0.00691667
R755 VGND.n266 VGND.t40 0.00691667
R756 VGND.t40 VGND.n143 0.00691667
R757 VGND.n343 VGND.n168 0.00691667
R758 VGND.n125 VGND.n122 0.00643258
R759 VGND.n122 VGND.n121 0.00643258
R760 VGND.n121 VGND.n120 0.00643258
R761 VGND.n120 VGND.n119 0.00643258
R762 VGND.n119 VGND.n118 0.00643258
R763 VGND.n118 VGND.n117 0.00643258
R764 VGND.n117 VGND.n116 0.00643258
R765 VGND.n359 VGND.n10 0.00630556
R766 VGND.n288 VGND.n181 0.00619286
R767 VGND.n284 VGND.n186 0.00619286
R768 VGND.n258 VGND.n249 0.00619286
R769 VGND.n299 VGND.n165 0.00619286
R770 VGND.n265 VGND.n143 0.00619286
R771 VGND.n268 VGND.n222 0.00619286
R772 VGND.n290 VGND.n178 0.00619286
R773 VGND.n286 VGND.n183 0.00619286
R774 VGND.n282 VGND.n188 0.00619286
R775 VGND.n275 VGND.n10 0.00619286
R776 VGND.n273 VGND.n191 0.00619286
R777 VGND.n279 VGND.n207 0.00619286
R778 VGND.n271 VGND.n185 0.00619286
R779 VGND.n285 VGND.n214 0.00619286
R780 VGND.n269 VGND.n180 0.00619286
R781 VGND.n289 VGND.n218 0.00619286
R782 VGND.n292 VGND.n225 0.00619286
R783 VGND.n267 VGND.n175 0.00619286
R784 VGND.n266 VGND.n174 0.00619286
R785 VGND.n263 VGND.n171 0.00619286
R786 VGND.n294 VGND.n233 0.00619286
R787 VGND.n262 VGND.n168 0.00619286
R788 VGND.n297 VGND.n239 0.00619286
R789 VGND.n300 VGND.n245 0.00619286
R790 VGND.n301 VGND.n247 0.00619286
R791 VGND.n260 VGND.n163 0.00619286
R792 VGND.n340 VGND.n160 0.00619286
R793 VGND.n303 VGND.n252 0.00619286
R794 VGND.n257 VGND.n157 0.00619286
R795 VGND.n352 VGND.n152 0.00619286
R796 VGND.n353 VGND.n352 0.00615278
R797 VGND.n221 VGND.n178 0.00569444
R798 VGND.n222 VGND.n221 0.00569444
R799 VGND.n232 VGND.n171 0.00569444
R800 VGND.n233 VGND.n232 0.00569444
R801 VGND.n129 VGND.n128 0.00524607
R802 VGND.n133 VGND.n132 0.00524607
R803 VGND.n135 VGND.n115 0.00524607
R804 VGND.n127 VGND.n126 0.00524607
R805 VGND.n130 VGND.n127 0.00524607
R806 VGND.n131 VGND.n130 0.00524607
R807 VGND.n134 VGND.n131 0.00524607
R808 VGND.n136 VGND.n134 0.00524607
R809 VGND.n137 VGND.n136 0.00524607
R810 VGND.n138 VGND.n137 0.00524607
R811 VGND.n107 VGND.n1 0.00499889
R812 VGND.n287 VGND.n183 0.00447222
R813 VGND.n343 VGND.n239 0.00447222
R814 VGND.n103 VGND.n111 0.00438867
R815 VGND.n110 VGND.n107 0.00416644
R816 VGND.t61 VGND.n101 1.08107
R817 VGND.n129 VGND.n113 0.00335935
R818 VGND.n133 VGND.n114 0.00335935
R819 VGND.n139 VGND.n115 0.00335935
R820 VGND.n128 VGND.n112 0.00335935
R821 VGND.n132 VGND.n113 0.00335935
R822 VGND.n135 VGND.n114 0.00335935
R823 VGND.n283 VGND.n188 0.00325
R824 VGND.n342 VGND.n245 0.00325
R825 VGND.t40 VGND.n142 0.00249109
R826 VGND.n206 VGND.n191 0.00202778
R827 VGND.n341 VGND.n249 0.00202778
R828 VGND.n124 VGND.n123 0.00166667
R829 VGND.n124 VGND.n111 0.00361034
R830 VGND.n123 VGND.n105 0.00308331
R831 VGND.n103 VGND.n102 0.00299997
R832 VGND.n334 VGND.n100 5.66943
C0 analog_2 VAPWR 11.144f
C1 analog_2 ui_in[0] 16.0232f
C2 analog_2 analog_1 0.72158f
C3 analog_0 VAPWR 26.7524f
C4 VPWR ui_in[0] 0.54099f
C5 analog_0 ui_in[0] 0.12731f
C6 ui_in[0] VAPWR 26.8581f
C7 analog_0 analog_1 16.6419f
C8 analog_1 VAPWR 11.1938f
C9 uo_out[0] VGND 0.04448f
C10 uo_out[1] VGND 0.03799f
C11 uo_out[2] VGND 0.03799f
C12 uo_out[3] VGND 0.03799f
C13 uo_out[4] VGND 0.03799f
C14 uo_out[5] VGND 0.03799f
C15 uo_out[6] VGND 0.03799f
C16 uo_out[7] VGND 0.03799f
C17 uio_out[0] VGND 0.03799f
C18 uio_out[1] VGND 0.03799f
C19 uio_out[2] VGND 0.03799f
C20 uio_out[3] VGND 0.03799f
C21 uio_out[4] VGND 0.03799f
C22 uio_out[5] VGND 0.03799f
C23 uio_out[6] VGND 0.03799f
C24 uio_out[7] VGND 0.03799f
C25 uio_oe[0] VGND 0.03799f
C26 uio_oe[1] VGND 0.03799f
C27 uio_oe[2] VGND 0.03799f
C28 uio_oe[3] VGND 0.03799f
C29 uio_oe[4] VGND 0.03799f
C30 uio_oe[5] VGND 0.03799f
C31 uio_oe[6] VGND 0.03799f
C32 uio_oe[7] VGND 0.03799f
C33 ui_in[1] VGND 0.03799f
C34 ui_in[2] VGND 0.03799f
C35 ui_in[3] VGND 0.03799f
C36 ui_in[4] VGND 0.03799f
C37 ui_in[5] VGND 0.03799f
C38 ui_in[6] VGND 0.03799f
C39 ui_in[7] VGND 0.03799f
C40 uio_in[0] VGND 0.03799f
C41 uio_in[1] VGND 0.03799f
C42 uio_in[2] VGND 0.03799f
C43 uio_in[3] VGND 0.03799f
C44 uio_in[4] VGND 0.03799f
C45 uio_in[5] VGND 0.03799f
C46 uio_in[6] VGND 0.03799f
C47 uio_in[7] VGND 0.03799f
C48 ena VGND 0.03799f
C49 clk VGND 0.03799f
C50 rst_n VGND 0.04448f
C51 analog_1 VGND 24.30245f
C52 analog_2 VGND 29.06621f
C53 ui_in[0] VGND 28.23714f
C54 VGND.t52 VGND 43.632f
C55 VGND.t1 VGND 11.71255f
C56 VGND.t50 VGND 3.09716f
C57 ui_in[0].n0 VGND 4.027f
C58 ui_in[0].n1 VGND 0.12143f
C59 ui_in[0].n2 VGND 0.23471f
C60 ui_in[0].n3 VGND 0.23471f
C61 ui_in[0].n4 VGND 0.23471f
C62 ui_in[0].n5 VGND 0.23471f
C63 ui_in[0].n6 VGND 0.23471f
C64 ui_in[0].n7 VGND 0.23471f
C65 ui_in[0].n8 VGND 0.24805f
C66 ui_in[0].n9 VGND 0.07136f
C67 ui_in[0].n10 VGND 0.05503f
C68 ui_in[0].n11 VGND 0.05503f
C69 ui_in[0].n12 VGND 0.05503f
C70 ui_in[0].n13 VGND 0.05503f
C71 ui_in[0].n14 VGND 0.05503f
C72 ui_in[0].n15 VGND 0.61403f
C73 ui_in[0].n16 VGND 2.469f
C74 ui_in[0].n17 VGND 0.62395f
C75 ui_in[0].n18 VGND 0.05503f
C76 ui_in[0].n19 VGND 0.05503f
C77 ui_in[0].n20 VGND 0.05503f
C78 ui_in[0].n21 VGND 0.05503f
C79 ui_in[0].n22 VGND 0.05503f
C80 ui_in[0].n23 VGND 0.05503f
C81 ui_in[0].n24 VGND 0.0721f
.ends
