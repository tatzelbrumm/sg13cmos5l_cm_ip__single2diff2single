* PEX produced on Mon Aug 31 08:37:19 PM CEST 2026 using /foss/tools/sak/sak-pex.sh with m=3 and s=1 (extresist threshold=10000 mOhm, minres=1000 mOhm, mindelay=1 ps)
* NGSPICE file created from sg13cmos5l_cm_ip__single2diff2single_pex.ext - technology: ihp-sg13cmos5l

.subckt sg13cmos5l_cm_ip__single2diff2single_pex VPWR VAPWR VGND rst_n clk ena
+ uio_in[7] uio_in[6] uio_in[5] uio_in[4] uio_in[3] uio_in[2] uio_in[1]
+ uio_in[0] ui_in[7] ui_in[6] ui_in[5] ui_in[4] ui_in[3] ui_in[2] ui_in[1]
+ ui_in[0] uio_oe[7] uio_oe[6] uio_oe[5] uio_oe[4] uio_oe[3] uio_oe[2] uio_oe[1]
+ uio_oe[0] uio_out[7] uio_out[6] uio_out[5] uio_out[4] uio_out[3] uio_out[2]
+ uio_out[1] uio_out[0] uo_out[7] uo_out[6] uo_out[5] uo_out[4] uo_out[3]
+ uo_out[2] uo_out[1] uo_out[0] analog_2 analog_1 analog_0
X0 VAPWR VAPWR VAPWR VAPWR sg13_lv_pmos ad=1.14p pd=6.38u as=0.28875n ps=0.61464m w=6u l=1u
X1 VGND.t1 VGND.t53 VGND.t1 VGND.t54 sg13_lv_nmos ad=0.34p pd=2.68u as=0 ps=0 w=1u l=1u
X2 analog_1 analog_0 VGND.t1 VGND.t0 sg13_lv_nmos ad=0.19p pd=1.38u as=0.19p ps=1.38u w=1u l=1u
X3 analog_1 analog_0 VAPWR VAPWR sg13_lv_pmos ad=1.14p pd=6.38u as=1.14p ps=6.38u w=6u l=1u
X4 VAPWR ui_in[0].t1 analog_2 VAPWR sg13_lv_pmos ad=1.14p pd=6.38u as=1.14p ps=6.38u w=6u l=1u
X5 VAPWR analog_0 analog_1 VAPWR sg13_lv_pmos ad=1.14p pd=6.38u as=1.14p ps=6.38u w=6u l=1u
X6 analog_1 analog_0 VGND.t3 VGND.t4 sg13_lv_nmos ad=0.19p pd=1.38u as=0.19p ps=1.38u w=1u l=1u
X7 VAPWR analog_0 analog_1 VAPWR sg13_lv_pmos ad=1.14p pd=6.38u as=1.14p ps=6.38u w=6u l=1u
X8 VAPWR analog_0 analog_1 VAPWR sg13_lv_pmos ad=1.14p pd=6.38u as=1.14p ps=6.38u w=6u l=1u
X9 VGND.t9 analog_0 analog_1 VGND.t8 sg13_lv_nmos ad=0.19p pd=1.38u as=0.19p ps=1.38u w=1u l=1u
X10 VAPWR analog_0 analog_1 VAPWR sg13_lv_pmos ad=1.14p pd=6.38u as=1.14p ps=6.38u w=6u l=1u
X11 analog_1 analog_0 VAPWR VAPWR sg13_lv_pmos ad=1.14p pd=6.38u as=1.14p ps=6.38u w=6u l=1u
X12 analog_2 ui_in[0].t1 VAPWR VAPWR sg13_lv_pmos ad=1.14p pd=6.38u as=1.14p ps=6.38u w=6u l=1u
X13 VGND.t6 analog_0 analog_1 VGND.t5 sg13_lv_nmos ad=0.19p pd=1.38u as=0.19p ps=1.38u w=1u l=1u
X14 VGND.t12 analog_0 analog_1 VGND.t11 sg13_lv_nmos ad=0.19p pd=1.38u as=0.19p ps=1.38u w=1u l=1u
X15 analog_1 analog_0 VAPWR VAPWR sg13_lv_pmos ad=1.14p pd=6.38u as=1.14p ps=6.38u w=6u l=1u
X16 analog_2 ui_in[0].t1 VAPWR VAPWR sg13_lv_pmos ad=1.14p pd=6.38u as=1.14p ps=6.38u w=6u l=1u
X17 VAPWR analog_0 analog_1 VAPWR sg13_lv_pmos ad=1.14p pd=6.38u as=1.14p ps=6.38u w=6u l=1u
X18 VAPWR ui_in[0].t1 analog_2 VAPWR sg13_lv_pmos ad=1.14p pd=6.38u as=1.14p ps=6.38u w=6u l=1u
X19 VGND.t15 analog_0 analog_1 VGND.t14 sg13_lv_nmos ad=0.19p pd=1.38u as=0.19p ps=1.38u w=1u l=1u
X20 analog_1 analog_0 VGND.t21 VGND.t22 sg13_lv_nmos ad=0.19p pd=1.38u as=0.19p ps=1.38u w=1u l=1u
X21 analog_2 ui_in[0].t1 VAPWR VAPWR sg13_lv_pmos ad=1.14p pd=6.38u as=1.14p ps=6.38u w=6u l=1u
X22 VGND.t50 ui_in[0].t0 analog_2 VGND.t29 sg13_lv_nmos ad=0.19p pd=1.38u as=0.19p ps=1.38u w=1u l=1u
X23 analog_1 analog_0 VGND.t18 VGND.t19 sg13_lv_nmos ad=0.19p pd=1.38u as=0.19p ps=1.38u w=1u l=1u
X24 VAPWR analog_0 analog_1 VAPWR sg13_lv_pmos ad=1.14p pd=6.38u as=1.14p ps=6.38u w=6u l=1u
X25 VAPWR ui_in[0].t1 analog_2 VAPWR sg13_lv_pmos ad=1.14p pd=6.38u as=1.14p ps=6.38u w=6u l=1u
X26 analog_2 ui_in[0].t1 VAPWR VAPWR sg13_lv_pmos ad=1.14p pd=6.38u as=1.14p ps=6.38u w=6u l=1u
X27 analog_2 ui_in[0].t0 VGND.t1 VGND.t0 sg13_lv_nmos ad=0.19p pd=1.38u as=0.19p ps=1.38u w=1u l=1u
X28 VGND.t24 analog_0 analog_1 VGND.t23 sg13_lv_nmos ad=0.19p pd=1.38u as=0.19p ps=1.38u w=1u l=1u
X29 VAPWR VAPWR VAPWR VAPWR sg13_lv_pmos ad=1.14p pd=6.38u as=0 ps=0 w=6u l=1u
X30 analog_2 ui_in[0].t1 VAPWR VAPWR sg13_lv_pmos ad=1.14p pd=6.38u as=1.14p ps=6.38u w=6u l=1u
X31 analog_2 ui_in[0].t1 VAPWR VAPWR sg13_lv_pmos ad=1.14p pd=6.38u as=1.14p ps=6.38u w=6u l=1u
X32 VAPWR VAPWR VAPWR VAPWR sg13_lv_pmos ad=2.04p pd=12.68u as=0 ps=0 w=6u l=1u
X33 VGND.t27 analog_0 analog_1 VGND.t26 sg13_lv_nmos ad=0.19p pd=1.38u as=0.19p ps=1.38u w=1u l=1u
X34 VAPWR analog_0 analog_1 VAPWR sg13_lv_pmos ad=1.14p pd=6.38u as=1.14p ps=6.38u w=6u l=1u
X35 analog_2 ui_in[0].t0 VGND.t32 VGND.t4 sg13_lv_nmos ad=0.19p pd=1.38u as=0.19p ps=1.38u w=1u l=1u
X36 VGND.t30 VGND.t60 VGND.t57 VGND.t56 sg13_lv_nmos ad=0.19p pd=1.38u as=0 ps=0 w=1u l=1u
X37 VGND.t52 VPWR VGND.t52 VGND.t51 sg13_lv_pmos ad=3.4p pd=20.68u as=0 ps=0 w=10u l=10u
X38 VGND.t36 ui_in[0].t0 analog_2 VGND.t8 sg13_lv_nmos ad=0.19p pd=1.38u as=0.19p ps=1.38u w=1u l=1u
X39 VGND.t3 analog_0 analog_1 VGND.t2 sg13_lv_nmos ad=0.19p pd=1.38u as=0.19p ps=1.38u w=1u l=1u
X40 VGND.t34 ui_in[0].t0 analog_2 VGND.t5 sg13_lv_nmos ad=0.19p pd=1.38u as=0.19p ps=1.38u w=1u l=1u
X41 VGND.t38 ui_in[0].t0 analog_2 VGND.t11 sg13_lv_nmos ad=0.19p pd=1.38u as=0.19p ps=1.38u w=1u l=1u
X42 analog_1 analog_0 VAPWR VAPWR sg13_lv_pmos ad=1.14p pd=6.38u as=1.14p ps=6.38u w=6u l=1u
X43 analog_1 analog_0 VAPWR VAPWR sg13_lv_pmos ad=1.14p pd=6.38u as=1.14p ps=6.38u w=6u l=1u
X44 VGND.t40 ui_in[0].t0 analog_2 VGND.t14 sg13_lv_nmos ad=0.19p pd=1.38u as=0.19p ps=1.38u w=1u l=1u
X45 analog_2 ui_in[0].t0 VGND.t44 VGND.t22 sg13_lv_nmos ad=0.19p pd=1.38u as=0.19p ps=1.38u w=1u l=1u
X46 analog_1 analog_0 VGND.t9 VGND.t10 sg13_lv_nmos ad=0.19p pd=1.38u as=0.19p ps=1.38u w=1u l=1u
X47 VAPWR analog_0 analog_1 VAPWR sg13_lv_pmos ad=1.14p pd=6.38u as=1.14p ps=6.38u w=6u l=1u
X48 analog_2 ui_in[0].t0 VGND.t42 VGND.t19 sg13_lv_nmos ad=0.19p pd=1.38u as=0.19p ps=1.38u w=1u l=1u
X49 analog_1 analog_0 VAPWR VAPWR sg13_lv_pmos ad=1.14p pd=6.38u as=1.14p ps=6.38u w=6u l=1u
X50 VGND.t46 ui_in[0].t0 analog_2 VGND.t23 sg13_lv_nmos ad=0.19p pd=1.38u as=0.19p ps=1.38u w=1u l=1u
X51 analog_1 analog_0 VGND.t12 VGND.t13 sg13_lv_nmos ad=0.19p pd=1.38u as=0.19p ps=1.38u w=1u l=1u
X52 VAPWR analog_0 analog_1 VAPWR sg13_lv_pmos ad=1.14p pd=6.38u as=1.14p ps=6.38u w=6u l=1u
X53 analog_1 analog_0 VAPWR VAPWR sg13_lv_pmos ad=1.14p pd=6.38u as=1.14p ps=6.38u w=6u l=1u
X54 VAPWR ui_in[0].t1 analog_2 VAPWR sg13_lv_pmos ad=1.14p pd=6.38u as=1.14p ps=6.38u w=6u l=1u
X55 VGND.t18 analog_0 analog_1 VGND.t17 sg13_lv_nmos ad=0.19p pd=1.38u as=0.19p ps=1.38u w=1u l=1u
X56 analog_1 analog_0 VAPWR VAPWR sg13_lv_pmos ad=1.14p pd=6.38u as=1.14p ps=6.38u w=6u l=1u
X57 analog_1 analog_0 VAPWR VAPWR sg13_lv_pmos ad=1.14p pd=6.38u as=1.14p ps=6.38u w=6u l=1u
X58 analog_2 ui_in[0].t1 VAPWR VAPWR sg13_lv_pmos ad=1.14p pd=6.38u as=1.14p ps=6.38u w=6u l=1u
X59 VGND.t48 ui_in[0].t0 analog_2 VGND.t26 sg13_lv_nmos ad=0.19p pd=1.38u as=0.19p ps=1.38u w=1u l=1u
X60 analog_1 analog_0 VGND.t15 VGND.t16 sg13_lv_nmos ad=0.19p pd=1.38u as=0.19p ps=1.38u w=1u l=1u
X61 VAPWR VAPWR VAPWR VAPWR sg13_lv_pmos ad=2.04p pd=12.68u as=0 ps=0 w=6u l=1u
X62 VGND.t50 VGND.t55 VGND.t57 VGND.t56 sg13_lv_nmos ad=0.19p pd=1.38u as=0 ps=0 w=1u l=1u
X63 VGND.t21 analog_0 analog_1 VGND.t20 sg13_lv_nmos ad=0.19p pd=1.38u as=0.19p ps=1.38u w=1u l=1u
X64 analog_1 analog_0 VGND.t27 VGND.t28 sg13_lv_nmos ad=0.19p pd=1.38u as=0.19p ps=1.38u w=1u l=1u
X65 VGND.t1 VGND.t58 VGND.t1 VGND.t54 sg13_lv_nmos ad=0.34p pd=2.68u as=0 ps=0 w=1u l=1u
X66 analog_1 analog_0 VGND.t6 VGND.t7 sg13_lv_nmos ad=0.19p pd=1.38u as=0.19p ps=1.38u w=1u l=1u
X67 analog_1 analog_0 VGND.t24 VGND.t25 sg13_lv_nmos ad=0.19p pd=1.38u as=0.19p ps=1.38u w=1u l=1u
X68 analog_2 ui_in[0].t1 VAPWR VAPWR sg13_lv_pmos ad=1.14p pd=6.38u as=1.14p ps=6.38u w=6u l=1u
X69 VAPWR ui_in[0].t1 analog_2 VAPWR sg13_lv_pmos ad=1.14p pd=6.38u as=1.14p ps=6.38u w=6u l=1u
X70 VGND.t32 ui_in[0].t0 analog_2 VGND.t2 sg13_lv_nmos ad=0.19p pd=1.38u as=0.19p ps=1.38u w=1u l=1u
X71 VAPWR ui_in[0].t1 analog_2 VAPWR sg13_lv_pmos ad=1.14p pd=6.38u as=1.14p ps=6.38u w=6u l=1u
X72 VAPWR ui_in[0].t1 analog_2 VAPWR sg13_lv_pmos ad=1.14p pd=6.38u as=1.14p ps=6.38u w=6u l=1u
X73 analog_2 ui_in[0].t0 VGND.t36 VGND.t10 sg13_lv_nmos ad=0.19p pd=1.38u as=0.19p ps=1.38u w=1u l=1u
X74 VAPWR ui_in[0].t1 analog_2 VAPWR sg13_lv_pmos ad=1.14p pd=6.38u as=1.14p ps=6.38u w=6u l=1u
X75 analog_2 ui_in[0].t1 VAPWR VAPWR sg13_lv_pmos ad=1.14p pd=6.38u as=1.14p ps=6.38u w=6u l=1u
X76 analog_2 ui_in[0].t0 VGND.t38 VGND.t13 sg13_lv_nmos ad=0.19p pd=1.38u as=0.19p ps=1.38u w=1u l=1u
X77 analog_2 ui_in[0].t1 VAPWR VAPWR sg13_lv_pmos ad=1.14p pd=6.38u as=1.14p ps=6.38u w=6u l=1u
X78 VGND.t42 ui_in[0].t0 analog_2 VGND.t17 sg13_lv_nmos ad=0.19p pd=1.38u as=0.19p ps=1.38u w=1u l=1u
X79 VAPWR analog_0 analog_1 VAPWR sg13_lv_pmos ad=1.14p pd=6.38u as=1.14p ps=6.38u w=6u l=1u
X80 VAPWR ui_in[0].t1 analog_2 VAPWR sg13_lv_pmos ad=1.14p pd=6.38u as=1.14p ps=6.38u w=6u l=1u
X81 analog_2 ui_in[0].t0 VGND.t40 VGND.t16 sg13_lv_nmos ad=0.19p pd=1.38u as=0.19p ps=1.38u w=1u l=1u
X82 analog_1 analog_0 VAPWR VAPWR sg13_lv_pmos ad=1.14p pd=6.38u as=1.14p ps=6.38u w=6u l=1u
X83 VGND.t44 ui_in[0].t0 analog_2 VGND.t20 sg13_lv_nmos ad=0.19p pd=1.38u as=0.19p ps=1.38u w=1u l=1u
X84 analog_2 ui_in[0].t0 VGND.t48 VGND.t28 sg13_lv_nmos ad=0.19p pd=1.38u as=0.19p ps=1.38u w=1u l=1u
X85 VGND.t52 VAPWR VGND.t52 VGND.t52 sg13_lv_pmos ad=3.4p pd=20.68u as=0 ps=0 w=10u l=10u
X86 VAPWR ui_in[0].t1 analog_2 VAPWR sg13_lv_pmos ad=1.14p pd=6.38u as=1.14p ps=6.38u w=6u l=1u
X87 analog_2 ui_in[0].t0 VGND.t34 VGND.t7 sg13_lv_nmos ad=0.19p pd=1.38u as=0.19p ps=1.38u w=1u l=1u
X88 analog_2 ui_in[0].t0 VGND.t46 VGND.t25 sg13_lv_nmos ad=0.19p pd=1.38u as=0.19p ps=1.38u w=1u l=1u
X89 VGND.t30 analog_0 analog_1 VGND.t29 sg13_lv_nmos ad=0.19p pd=1.38u as=0.19p ps=1.38u w=1u l=1u
R0 ui_in[0].n15 ui_in[0].t1 0.994683
R1 ui_in[0].n17 ui_in[0].t0 0.994013
R2 ui_in[0].n9 ui_in[0].n1 0.748572
R3 ui_in[0].n10 ui_in[0].n9 0.578786
R4 ui_in[0].n11 ui_in[0].n10 0.578786
R5 ui_in[0].n12 ui_in[0].n11 0.578786
R6 ui_in[0].n13 ui_in[0].n12 0.578786
R7 ui_in[0].n14 ui_in[0].n13 0.578786
R8 ui_in[0].n15 ui_in[0].n14 0.578786
R9 ui_in[0].n0 ui_in[0].n24 0.755676
R10 ui_in[0].n24 ui_in[0].n23 0.578786
R11 ui_in[0].n23 ui_in[0].n22 0.578786
R12 ui_in[0].n22 ui_in[0].n21 0.578786
R13 ui_in[0].n21 ui_in[0].n20 0.578786
R14 ui_in[0].n20 ui_in[0].n19 0.578786
R15 ui_in[0].n19 ui_in[0].n18 0.578786
R16 ui_in[0].n18 ui_in[0].n17 0.578786
R17 ui_in[0].n14 ui_in[0].n8 0.254024
R18 ui_in[0].n13 ui_in[0].n7 0.254024
R19 ui_in[0].n12 ui_in[0].n6 0.254024
R20 ui_in[0].n11 ui_in[0].n5 0.254024
R21 ui_in[0].n10 ui_in[0].n4 0.254024
R22 ui_in[0].n9 ui_in[0].n3 0.254024
R23 ui_in[0].n1 ui_in[0].n2 0.0282822
R24 ui_in[0].n24 ui_in[0].n2 0.254024
R25 ui_in[0].n23 ui_in[0].n3 0.254024
R26 ui_in[0].n22 ui_in[0].n4 0.254024
R27 ui_in[0].n21 ui_in[0].n5 0.254024
R28 ui_in[0].n20 ui_in[0].n6 0.254024
R29 ui_in[0].n19 ui_in[0].n7 0.254024
R30 ui_in[0].n18 ui_in[0].n8 0.254024
R31 ui_in[0].n17 ui_in[0].n16 0.192615
R32 ui_in[0].n16 ui_in[0].n15 0.191641
R33 ui_in[0].n16 ui_in[0].n8 0.128842
R34 ui_in[0].n1 ui_in[0].n0 0.105962
R35 ui_in[0].n3 ui_in[0].n2 0.12194
R36 ui_in[0].n4 ui_in[0].n3 0.12194
R37 ui_in[0].n5 ui_in[0].n4 0.12194
R38 ui_in[0].n6 ui_in[0].n5 0.12194
R39 ui_in[0].n7 ui_in[0].n6 0.12194
R40 ui_in[0].n8 ui_in[0].n7 0.12194
R41 ui_in[0] ui_in[0].n0 40.295
R42 VGND.n115 VGND.t0 86.957
R43 VGND.t29 VGND.n96 86.957
R44 VGND.n116 VGND.t2 81.5222
R45 VGND.t28 VGND.n97 81.5222
R46 VGND.n117 VGND.t4 76.0875
R47 VGND.t26 VGND.n98 76.0875
R48 VGND.n118 VGND.t5 70.6527
R49 VGND.t25 VGND.n99 70.6527
R50 VGND.n119 VGND.t7 65.2179
R51 VGND.t23 VGND.n100 65.2179
R52 VGND.n120 VGND.t8 59.7831
R53 VGND.t22 VGND.n101 59.7831
R54 VGND.n121 VGND.t10 54.3483
R55 VGND.t14 VGND.n106 54.3483
R56 VGND.n125 VGND.t16 54.3483
R57 VGND.t20 VGND.n102 54.3483
R58 VGND.n122 VGND.t11 48.9135
R59 VGND.t13 VGND.n107 48.9135
R60 VGND.n126 VGND.t17 48.9135
R61 VGND.t19 VGND.n103 48.9135
R62 VGND.t11 VGND.n108 43.4788
R63 VGND.n123 VGND.t13 43.4788
R64 VGND.t17 VGND.n104 43.4788
R65 VGND.n127 VGND.t19 43.4788
R66 VGND.t10 VGND.n109 38.044
R67 VGND.n124 VGND.t14 38.044
R68 VGND.t16 VGND.n105 38.044
R69 VGND.n128 VGND.t20 38.044
R70 VGND.t8 VGND.n110 32.6092
R71 VGND.n129 VGND.t22 32.6092
R72 VGND.t7 VGND.n111 27.1744
R73 VGND.n130 VGND.t23 27.1744
R74 VGND.t5 VGND.n112 21.7396
R75 VGND.n131 VGND.t25 21.7396
R76 VGND.n17 VGND.n21 1.80856
R77 VGND.n17 VGND.n12 0.663531
R78 VGND.n17 VGND.n28 0.661826
R79 VGND.n28 VGND.n81 14.3607
R80 VGND.n17 VGND.n42 0.661826
R81 VGND.n42 VGND.n52 14.3607
R82 VGND.n40 VGND.n82 14.36
R83 VGND.n17 VGND.n40 0.661826
R84 VGND.n41 VGND.n53 14.36
R85 VGND.n17 VGND.n41 0.661826
R86 VGND.n18 VGND.n54 14.36
R87 VGND.n17 VGND.n18 0.661826
R88 VGND.n17 VGND.n34 0.661826
R89 VGND.n17 VGND.n19 0.661826
R90 VGND.n19 VGND.n59 14.3607
R91 VGND.n17 VGND.n101 8.4986
R92 VGND.n17 VGND.n38 0.661826
R93 VGND.n11 VGND.n51 0.0183475
R94 VGND.n38 VGND.n61 14.36
R95 VGND.n17 VGND.n49 17.0005
R96 VGND.n26 VGND.n62 14.3607
R97 VGND.n17 VGND.n46 3.39221
R98 VGND.n17 VGND.n36 0.661826
R99 VGND.n36 VGND.n64 14.36
R100 VGND.n47 VGND.n48 0.0303656
R101 VGND.n24 VGND.n65 14.3607
R102 VGND.n17 VGND.n47 2.82864
R103 VGND.n14 VGND.t40 0.137797
R104 VGND.n27 VGND.n66 14.579
R105 VGND.n17 VGND.n124 8.4994
R106 VGND.n37 VGND.n88 14.3607
R107 VGND.n33 VGND.n68 14.36
R108 VGND.n17 VGND.n33 0.661826
R109 VGND.n31 VGND.n89 14.36
R110 VGND.n17 VGND.n31 0.661826
R111 VGND.n20 VGND.n72 14.36
R112 VGND.n39 VGND.n74 14.36
R113 VGND.n22 VGND.n76 14.3607
R114 VGND.n23 VGND.n78 14.3607
R115 VGND.n17 VGND.n32 0.661826
R116 VGND.n32 VGND.n80 14.3607
R117 VGND.n29 VGND.n91 14.3607
R118 VGND.n35 VGND.n95 7.18026
R119 VGND.n17 VGND.n35 0.661826
R120 VGND.n30 VGND.n92 14.3607
R121 VGND.n25 VGND.t54 7.74028
R122 VGND.n17 VGND.n25 0.0779879
R123 VGND.n9 VGND.n7 0.0162933
R124 VGND.n94 VGND.n50 3.39255
R125 VGND.n94 VGND.n45 2.42377
R126 VGND.n44 VGND.n47 0.0342261
R127 VGND.n6 VGND.t1 0.0303895
R128 VGND.n134 VGND.n17 8.4905
R129 VGND.n96 VGND.n17 8.49976
R130 VGND.n133 VGND.n17 8.49074
R131 VGND.n97 VGND.n17 8.49951
R132 VGND.n132 VGND.n17 8.49097
R133 VGND.n98 VGND.n17 8.49926
R134 VGND.n131 VGND.n17 8.49121
R135 VGND.n99 VGND.n17 8.49901
R136 VGND.n130 VGND.n17 8.49145
R137 VGND.n100 VGND.n17 8.49876
R138 VGND.n129 VGND.n17 8.49169
R139 VGND.n128 VGND.n17 8.49193
R140 VGND.n102 VGND.n17 8.49975
R141 VGND.n127 VGND.n17 8.49217
R142 VGND.n103 VGND.n17 8.49975
R143 VGND.n126 VGND.n17 8.50219
R144 VGND.n104 VGND.n17 8.49707
R145 VGND.n125 VGND.n17 8.49241
R146 VGND.n105 VGND.n17 8.49682
R147 VGND.n106 VGND.n17 8.49657
R148 VGND.n123 VGND.n17 8.49265
R149 VGND.n107 VGND.n17 8.50001
R150 VGND.n122 VGND.n17 8.4929
R151 VGND.n108 VGND.n17 8.49632
R152 VGND.n121 VGND.n17 8.49314
R153 VGND.n109 VGND.n17 8.49608
R154 VGND.n120 VGND.n17 8.49338
R155 VGND.n110 VGND.n17 8.49583
R156 VGND.n119 VGND.n17 8.49362
R157 VGND.n111 VGND.n17 8.49558
R158 VGND.n118 VGND.n17 8.49387
R159 VGND.n112 VGND.n17 8.49534
R160 VGND.n117 VGND.n17 8.49411
R161 VGND.n113 VGND.n17 8.49509
R162 VGND.n116 VGND.n17 8.49435
R163 VGND.n114 VGND.n17 8.49485
R164 VGND.n115 VGND.n17 8.4946
R165 VGND.t4 VGND.n113 16.3048
R166 VGND.n132 VGND.t26 16.3048
R167 VGND.t53 VGND.t1 4.99672
R168 VGND.t30 VGND.t60 4.99233
R169 VGND.t50 VGND.t55 4.99233
R170 VGND.t1 VGND.t58 4.99672
R171 VGND.n87 VGND.n27 14.5797
R172 VGND.t56 VGND.n28 7.18094
R173 VGND.n85 VGND.n26 14.3607
R174 VGND.n86 VGND.n24 14.3607
R175 VGND.n67 VGND.n37 14.3607
R176 VGND.n73 VGND.n39 14.3607
R177 VGND.n90 VGND.n29 14.3607
R178 VGND.n30 VGND.n93 14.3607
R179 VGND.n93 VGND.n35 14.3614
R180 VGND.n31 VGND.n70 14.3614
R181 VGND.n33 VGND.n69 14.3614
R182 VGND.n34 VGND.n57 14.3607
R183 VGND.n18 VGND.n55 14.3614
R184 VGND.n41 VGND.n84 14.3614
R185 VGND.n40 VGND.n83 14.3614
R186 VGND.t2 VGND.n114 10.8701
R187 VGND.n133 VGND.t28 10.8701
R188 VGND.n21 VGND.n94 0.077335
R189 VGND.n94 VGND.n95 8.5005
R190 VGND.n12 VGND.t57 0.024419
R191 VGND.n17 VGND.n8 1.28942
R192 VGND.n8 VGND.n10 0.078867
R193 VGND.n17 VGND.n11 1.54034
R194 VGND.n46 VGND.n50 0.0461375
R195 VGND.n46 VGND.n45 0.0302828
R196 VGND.n17 VGND.n15 1.04448
R197 VGND.n15 VGND.n16 0.0242945
R198 VGND.n17 VGND.n5 0.872547
R199 VGND.n5 VGND.n6 0.178689
R200 VGND.n17 VGND.t1 0.516128
R201 VGND.n94 VGND.n9 0.82958
R202 VGND.n94 VGND.n10 4.24402
R203 VGND.n49 VGND.n51 0.0123715
R204 VGND.n50 VGND.n49 0.00657674
R205 VGND.n45 VGND.n48 0.00873411
R206 VGND.n94 VGND.n44 2.82539
R207 VGND.n94 VGND.n14 0.855329
R208 VGND.n14 VGND.n15 0.0537637
R209 VGND.n16 VGND.n43 0.0157515
R210 VGND.n5 VGND.n4 0.0205411
R211 VGND.n94 VGND.n6 0.352886
R212 VGND.n82 VGND.n96 7.18094
R213 VGND.n53 VGND.n97 7.18094
R214 VGND.n54 VGND.n98 7.18094
R215 VGND.n60 VGND.n101 7.18094
R216 VGND.n85 VGND.n102 7.18094
R217 VGND.n63 VGND.n103 7.18094
R218 VGND.n86 VGND.n104 7.18094
R219 VGND.n87 VGND.n105 7.18094
R220 VGND.n67 VGND.n106 7.18094
R221 VGND.n68 VGND.n107 7.18094
R222 VGND.n89 VGND.n108 7.18094
R223 VGND.n73 VGND.n110 7.18094
R224 VGND.n90 VGND.n114 7.18094
R225 VGND.n79 VGND.n32 14.3614
R226 VGND.n77 VGND.n23 14.3614
R227 VGND.n75 VGND.n22 14.3614
R228 VGND.n74 VGND.n119 7.18094
R229 VGND.n72 VGND.n120 7.18094
R230 VGND.n71 VGND.n20 14.3614
R231 VGND.n66 VGND.n124 7.18094
R232 VGND.n64 VGND.n126 7.18094
R233 VGND.n61 VGND.n128 7.18094
R234 VGND.n58 VGND.n19 14.3614
R235 VGND.n57 VGND.n130 7.18094
R236 VGND.n56 VGND.n34 14.3607
R237 VGND.n21 VGND.t56 7.74091
R238 VGND.n81 VGND.n42 14.3607
R239 VGND.n52 VGND.n134 7.18026
R240 VGND.n83 VGND.n133 7.18026
R241 VGND.n84 VGND.n132 7.18026
R242 VGND.n55 VGND.n131 7.18026
R243 VGND.n59 VGND.n129 7.18026
R244 VGND.n60 VGND.n38 14.3607
R245 VGND.n62 VGND.n127 7.18026
R246 VGND.n63 VGND.n36 14.3607
R247 VGND.n65 VGND.n125 7.18026
R248 VGND.n88 VGND.n123 7.18026
R249 VGND.n69 VGND.n122 7.18026
R250 VGND.n70 VGND.n121 7.18026
R251 VGND.n76 VGND.n118 7.18026
R252 VGND.n78 VGND.n117 7.18026
R253 VGND.n80 VGND.n116 7.18026
R254 VGND.n91 VGND.n115 7.18026
R255 VGND.n92 VGND.t54 7.18026
R256 VGND.n56 VGND.n99 7.18026
R257 VGND.n58 VGND.n100 7.18026
R258 VGND.n71 VGND.n109 7.18026
R259 VGND.n75 VGND.n111 7.18026
R260 VGND.n77 VGND.n112 7.18026
R261 VGND.n79 VGND.n113 7.18026
R262 VGND.t0 VGND.n95 5.43528
R263 VGND.n134 VGND.t29 5.43528
R264 VGND.n138 VGND.n0 1.03821
R265 VGND.t50 VGND.n1 0.0407738
R266 VGND.n94 VGND.n12 0.773721
R267 VGND.n139 VGND.n13 0.475918
R268 VGND.n140 VGND.t6 2.48177
R269 VGND.n141 VGND.t9 2.48177
R270 VGND.n2 VGND.t12 2.48177
R271 VGND.t18 VGND.n3 2.48177
R272 VGND.n135 VGND.t21 2.48177
R273 VGND.n136 VGND.t24 2.48177
R274 VGND.n137 VGND.t27 2.48177
R275 VGND.n139 VGND.t32 2.48177
R276 VGND.n140 VGND.t34 2.48177
R277 VGND.n141 VGND.t36 2.48177
R278 VGND.n2 VGND.t38 2.48177
R279 VGND.t42 VGND.n3 2.48177
R280 VGND.n135 VGND.t44 2.48177
R281 VGND.n136 VGND.t46 2.48177
R282 VGND.n137 VGND.t48 2.48177
R283 VGND.n26 VGND.n17 0.661826
R284 VGND.n24 VGND.n17 0.661826
R285 VGND.n37 VGND.n17 0.661826
R286 VGND.n20 VGND.n17 0.661826
R287 VGND.n39 VGND.n17 0.661826
R288 VGND.n22 VGND.n17 0.661826
R289 VGND.n23 VGND.n17 0.661826
R290 VGND.n29 VGND.n17 0.661826
R291 VGND.n30 VGND.n17 0.661826
R292 VGND.t57 VGND.n0 0.0357096
R293 VGND.n27 VGND.n17 0.552335
R294 VGND VGND.n142 1.88203
R295 VGND.n142 VGND.t40 1.49725
R296 VGND.n94 VGND.n52 0.661826
R297 VGND.n94 VGND.n53 0.661826
R298 VGND.n94 VGND.n54 0.661826
R299 VGND.n94 VGND.n55 0.661826
R300 VGND.n94 VGND.n56 0.661826
R301 VGND.n94 VGND.n57 0.661826
R302 VGND.n94 VGND.n58 0.661826
R303 VGND.n94 VGND.n59 0.661826
R304 VGND.n94 VGND.n60 0.661826
R305 VGND.n94 VGND.n61 0.661826
R306 VGND.n94 VGND.n62 0.661826
R307 VGND.n94 VGND.n63 0.661826
R308 VGND.n94 VGND.n64 0.661826
R309 VGND.n94 VGND.n65 0.661826
R310 VGND.n94 VGND.n66 0.661826
R311 VGND.n94 VGND.n67 0.661826
R312 VGND.n94 VGND.n68 0.661826
R313 VGND.n94 VGND.n69 0.661826
R314 VGND.n94 VGND.n70 0.661826
R315 VGND.n94 VGND.n71 0.661826
R316 VGND.n94 VGND.n72 0.661826
R317 VGND.n94 VGND.n73 0.661826
R318 VGND.n94 VGND.n74 0.661826
R319 VGND.n94 VGND.n75 0.661826
R320 VGND.n94 VGND.n76 0.661826
R321 VGND.n94 VGND.n77 0.661826
R322 VGND.n94 VGND.n78 0.661826
R323 VGND.n94 VGND.n79 0.661826
R324 VGND.n94 VGND.n80 0.661826
R325 VGND.n94 VGND.n93 0.661826
R326 VGND.n94 VGND.n25 1.82398
R327 VGND.n94 VGND.n81 0.661826
R328 VGND.n94 VGND.n82 0.661826
R329 VGND.n94 VGND.n83 0.661826
R330 VGND.n94 VGND.n84 0.661826
R331 VGND.n94 VGND.n85 0.661826
R332 VGND.n94 VGND.n86 0.661826
R333 VGND.n94 VGND.n87 0.661826
R334 VGND.n94 VGND.n88 0.661826
R335 VGND.n94 VGND.n89 0.661826
R336 VGND.n94 VGND.n90 0.661826
R337 VGND.n94 VGND.n91 0.661826
R338 VGND.n94 VGND.n92 0.661826
R339 VGND.n142 VGND.t52 1.57131
R340 VGND.t52 VGND.t51 1.13314
R341 VGND.t1 VGND.t32 0.200997
R342 VGND.n4 VGND.t34 0.200997
R343 VGND.n43 VGND.t36 0.200997
R344 VGND.n16 VGND.t38 0.200997
R345 VGND.n48 VGND.t42 0.200997
R346 VGND.t44 VGND.n51 0.200997
R347 VGND.t46 VGND.n10 0.200997
R348 VGND.t48 VGND.n7 0.200997
R349 VGND.n13 VGND.t3 0.151
R350 VGND.n4 VGND.t6 0.200995
R351 VGND.n43 VGND.t9 0.200995
R352 VGND.n16 VGND.t12 0.200995
R353 VGND.n48 VGND.t18 0.200995
R354 VGND.n51 VGND.t21 0.200995
R355 VGND.n10 VGND.t24 0.200995
R356 VGND.n7 VGND.t27 0.200995
R357 VGND.t40 VGND.t15 0.185126
R358 VGND.n138 VGND.n137 0.1171
R359 VGND.n140 VGND.n139 0.08146
R360 VGND.n141 VGND.n140 0.08146
R361 VGND.n2 VGND.n141 0.08146
R362 VGND.t40 VGND.n2 0.08146
R363 VGND.t40 VGND.n3 0.08146
R364 VGND.n135 VGND.n3 0.08146
R365 VGND.n136 VGND.n135 0.08146
R366 VGND.n137 VGND.n136 0.08146
R367 VGND.n9 VGND.t57 0.0810034
R368 VGND.n10 VGND.n11 0.0617928
R369 VGND.n7 VGND.n8 0.0374647
R370 VGND.t30 VGND.n0 0.0597788
R371 VGND.n1 VGND.t57 0.0122781
R372 VGND.n13 VGND.t1 0.039375
R373 VGND.t40 VGND.n44 0.0380384
R374 VGND.n4 VGND.n43 0.0331202
R375 VGND.n138 VGND.n1 1.03385
C0 analog_2 ui_in[0] 16.0232f
C1 VAPWR analog_0 26.7524f
C2 ui_in[0] VPWR 0.54099f
C3 analog_0 analog_1 16.6419f
C4 VAPWR analog_1 11.1938f
C5 ui_in[0] analog_0 0.12731f
C6 analog_2 VAPWR 11.144f
C7 VAPWR ui_in[0] 26.8581f
C8 analog_2 analog_1 0.72158f
C9 uo_out[0] VGND 0.04448f
C10 uo_out[1] VGND 0.03799f
C11 uo_out[2] VGND 0.03799f
C12 uo_out[3] VGND 0.03799f
C13 uo_out[4] VGND 0.03799f
C14 uo_out[5] VGND 0.03799f
C15 uo_out[6] VGND 0.03799f
C16 uo_out[7] VGND 0.03799f
C17 uio_out[0] VGND 0.03799f
C18 uio_out[1] VGND 0.03799f
C19 uio_out[2] VGND 0.03799f
C20 uio_out[3] VGND 0.03799f
C21 uio_out[4] VGND 0.03799f
C22 uio_out[5] VGND 0.03799f
C23 uio_out[6] VGND 0.03799f
C24 uio_out[7] VGND 0.03799f
C25 uio_oe[0] VGND 0.03799f
C26 uio_oe[1] VGND 0.03799f
C27 uio_oe[2] VGND 0.03799f
C28 uio_oe[3] VGND 0.03799f
C29 uio_oe[4] VGND 0.03799f
C30 uio_oe[5] VGND 0.03799f
C31 uio_oe[6] VGND 0.03799f
C32 uio_oe[7] VGND 0.03799f
C33 ui_in[1] VGND 0.03799f
C34 ui_in[2] VGND 0.03799f
C35 ui_in[3] VGND 0.03799f
C36 ui_in[4] VGND 0.03799f
C37 ui_in[5] VGND 0.03799f
C38 ui_in[6] VGND 0.03799f
C39 ui_in[7] VGND 0.03799f
C40 uio_in[0] VGND 0.03799f
C41 uio_in[1] VGND 0.03799f
C42 uio_in[2] VGND 0.03799f
C43 uio_in[3] VGND 0.03799f
C44 uio_in[4] VGND 0.03799f
C45 uio_in[5] VGND 0.03799f
C46 uio_in[6] VGND 0.03799f
C47 uio_in[7] VGND 0.03799f
C48 ena VGND 0.03799f
C49 clk VGND 0.03799f
C50 rst_n VGND 0.04448f
C51 analog_1 VGND 24.30245f
C52 analog_2 VGND 29.06621f
C53 ui_in[0] VGND 28.23714f
C54 VGND.t50 VGND 3.09716f
C55 VGND.t52 VGND 43.632f
C56 VGND.t1 VGND 11.71255f
C57 ui_in[0].n0 VGND 4.027f
C58 ui_in[0].n1 VGND 0.12143f
C59 ui_in[0].n2 VGND 0.23471f
C60 ui_in[0].n3 VGND 0.23471f
C61 ui_in[0].n4 VGND 0.23471f
C62 ui_in[0].n5 VGND 0.23471f
C63 ui_in[0].n6 VGND 0.23471f
C64 ui_in[0].n7 VGND 0.23471f
C65 ui_in[0].n8 VGND 0.24805f
C66 ui_in[0].n9 VGND 0.07136f
C67 ui_in[0].n10 VGND 0.05503f
C68 ui_in[0].n11 VGND 0.05503f
C69 ui_in[0].n12 VGND 0.05503f
C70 ui_in[0].n13 VGND 0.05503f
C71 ui_in[0].n14 VGND 0.05503f
C72 ui_in[0].n15 VGND 0.61403f
C73 ui_in[0].n16 VGND 2.46899f
C74 ui_in[0].n17 VGND 0.62395f
C75 ui_in[0].n18 VGND 0.05503f
C76 ui_in[0].n19 VGND 0.05503f
C77 ui_in[0].n20 VGND 0.05503f
C78 ui_in[0].n21 VGND 0.05503f
C79 ui_in[0].n22 VGND 0.05503f
C80 ui_in[0].n23 VGND 0.05503f
C81 ui_in[0].n24 VGND 0.0721f
.ends
