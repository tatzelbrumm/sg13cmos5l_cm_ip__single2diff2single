* Extracted by KLayout with SG13CMOS5L LVS runset on : 03/11/2026 20:01

.SUBCKT s2d_tails_c3 vbp vdd
M$1 vdd vbp vdd vdd sg13_hv_pmos L=6u W=15u AS=5.1p AD=5.1p PS=32.04u PD=32.04u
+ rfmode=0
M$2 \$8 vbp vdd vdd sg13_hv_pmos L=6u W=5u AS=1.7p AD=1.7p PS=10.68u PD=10.68u
+ rfmode=0
M$3 \$9 vbp vdd vdd sg13_hv_pmos L=6u W=5u AS=1.7p AD=1.7p PS=10.68u PD=10.68u
+ rfmode=0
M$4 \$10 vbp vdd vdd sg13_hv_pmos L=6u W=5u AS=1.7p AD=1.7p PS=10.68u PD=10.68u
+ rfmode=0
M$5 \$11 vbp vdd vdd sg13_hv_pmos L=6u W=5u AS=1.7p AD=1.7p PS=10.68u PD=10.68u
+ rfmode=0
M$6 \$12 vbp vdd vdd sg13_hv_pmos L=6u W=5u AS=1.7p AD=1.7p PS=10.68u PD=10.68u
+ rfmode=0
M$7 \$13 vbp vdd vdd sg13_hv_pmos L=6u W=5u AS=1.7p AD=1.7p PS=10.68u PD=10.68u
+ rfmode=0
M$9 vdd vbp vbp vdd sg13_hv_pmos L=6u W=5u AS=1.7p AD=1.7p PS=10.68u PD=10.68u
+ rfmode=0
M$10 vdd vbp \$47 vdd sg13_hv_pmos L=6u W=5u AS=1.7p AD=1.7p PS=10.68u
+ PD=10.68u rfmode=0
M$11 vdd vbp \$48 vdd sg13_hv_pmos L=6u W=5u AS=1.7p AD=1.7p PS=10.68u
+ PD=10.68u rfmode=0
M$12 vdd vbp \$49 vdd sg13_hv_pmos L=6u W=5u AS=1.7p AD=1.7p PS=10.68u
+ PD=10.68u rfmode=0
M$13 vdd vbp \$50 vdd sg13_hv_pmos L=6u W=5u AS=1.7p AD=1.7p PS=10.68u
+ PD=10.68u rfmode=0
M$14 vdd vbp \$51 vdd sg13_hv_pmos L=6u W=5u AS=1.7p AD=1.7p PS=10.68u
+ PD=10.68u rfmode=0
M$15 vdd vbp \$52 vdd sg13_hv_pmos L=6u W=5u AS=1.7p AD=1.7p PS=10.68u
+ PD=10.68u rfmode=0
.ENDS s2d_tails_c3
