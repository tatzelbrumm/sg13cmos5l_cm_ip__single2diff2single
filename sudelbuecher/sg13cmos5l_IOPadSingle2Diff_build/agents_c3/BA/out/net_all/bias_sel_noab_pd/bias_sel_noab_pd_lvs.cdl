** sch_path: /tmp/claude-0/-home-user-sg13cmos5l-cm-ip--single2diff2single/9625f5bb-27cd-530e-a9cf-d1aa15a8223d/scratchpad/agents/BA/work/macros/bias_sel_noab_pd/schematic/xschem/bias_sel_noab_pd.sch
.subckt bias_sel_noab_pd vdd vss ibias vbp vbn vbpc vbnc en_3v3 sel0_3v3 sel1_3v3 en_3v3_b
*.PININFO vdd:B vss:B ibias:B vbp:O vbn:O vbpc:O vbnc:O en_3v3:I sel0_3v3:I sel1_3v3:I en_3v3_b:I
Xt vdd vss ir vbp vbn vbpc vbnc en_3v3 en_3v3_b bias_tree_noab_pd
XDA vdd vss en_3v3 sel0_3v3 en_oa_b nand2_hv
XDB vdd vss en_oa_b en_oa inv_hv
XDC vdd vss en_3v3 sel1_3v3 en_bg_b nand2_hv
XDD vdd vss en_bg_b en_bg inv_hv
XDE vdd vss sel0_3v3 sel1_3v3 s00 nor2_hv
XDF vdd vss en_3v3 s00 en_ext_b nand2_hv
XDG vdd vss en_ext_b en_ext inv_hv
Xoa vdd vss ir en_oa en_oa_b oa_core_pd
Xbg vdd vss ir en_bg en_bg_b bg_core_pd
MTEN ir en_ext ibias vss sg13_hv_nmos w=1u l=0.45u ng=1
MTEP ir en_ext_b ibias vdd sg13_hv_pmos w=1u l=0.45u ng=1
.ends

* expanding   symbol:  bias_tree_noab_pd.sym # of pins=9
** sym_path: /tmp/claude-0/-home-user-sg13cmos5l-cm-ip--single2diff2single/9625f5bb-27cd-530e-a9cf-d1aa15a8223d/scratchpad/agents/BA/work/macros/bias_tree_noab_pd/schematic/xschem/bias_tree_noab_pd.sym
** sch_path: /tmp/claude-0/-home-user-sg13cmos5l-cm-ip--single2diff2single/9625f5bb-27cd-530e-a9cf-d1aa15a8223d/scratchpad/agents/BA/work/macros/bias_tree_noab_pd/schematic/xschem/bias_tree_noab_pd.sch
.subckt bias_tree_noab_pd vdd vss iref vbp vbn vbpc vbnc en_3v3 en_3v3_b
*.PININFO vdd:B vss:B iref:B vbp:O vbn:O vbpc:O vbnc:O en_3v3:I en_3v3_b:I
MNI ni ni vss vss sg13_hv_nmos w=6u l=6u ng=1
MBPC vbpc vbpc vdd vdd sg13_hv_pmos w=1u l=4u ng=1
MNBPC vbpc ni vss vss sg13_hv_nmos w=2.4u l=6u ng=1
MBP vbp vbp vdd vdd sg13_hv_pmos w=5u l=6u ng=1
MNBP vbp ni vss vss sg13_hv_nmos w=6u l=6u ng=1
MPBNC vbnc vbp vdd vdd sg13_hv_pmos w=2u l=6u ng=1
MBNC vbnc vbnc vss vss sg13_hv_nmos w=1u l=8u ng=1
MPBN vbn vbp vdd vdd sg13_hv_pmos w=5u l=6u ng=1
MBN vbn vbn vss vss sg13_hv_nmos w=6u l=6u ng=1
MTGP ni en_3v3_b iref vdd sg13_hv_pmos w=1u l=0.45u ng=1
MTGN iref en_3v3 ni vss sg13_hv_nmos w=1u l=0.45u ng=1
MTDN ni en_3v3_b vss vss sg13_hv_nmos w=1u l=0.45u ng=1
MMDBP vdd vbp vdd vdd sg13_hv_pmos w=2u l=6u ng=1
MMDBN vss ni vss vss sg13_hv_nmos w=2.4u l=6u ng=1
.ends

* expanding   symbol:  nand2_hv.sym # of pins=5
** sym_path: /tmp/claude-0/-home-user-sg13cmos5l-cm-ip--single2diff2single/9625f5bb-27cd-530e-a9cf-d1aa15a8223d/scratchpad/agents/BA/work/macros/hv_logic/schematic/xschem/nand2_hv.sym
** sch_path: /tmp/claude-0/-home-user-sg13cmos5l-cm-ip--single2diff2single/9625f5bb-27cd-530e-a9cf-d1aa15a8223d/scratchpad/agents/BA/work/macros/hv_logic/schematic/xschem/nand2_hv.sch
.subckt nand2_hv vdd vss a b y
*.PININFO vdd:B vss:B a:I b:I y:O
MPA y a vdd vdd sg13_hv_pmos w=1u l=0.45u ng=1
MPB y b vdd vdd sg13_hv_pmos w=1u l=0.45u ng=1
MNA y a n1 vss sg13_hv_nmos w=1u l=0.45u ng=1
MNB n1 b vss vss sg13_hv_nmos w=1u l=0.45u ng=1
.ends

* expanding   symbol:  inv_hv.sym # of pins=4
** sym_path: /tmp/claude-0/-home-user-sg13cmos5l-cm-ip--single2diff2single/9625f5bb-27cd-530e-a9cf-d1aa15a8223d/scratchpad/agents/BA/work/macros/hv_logic/schematic/xschem/inv_hv.sym
** sch_path: /tmp/claude-0/-home-user-sg13cmos5l-cm-ip--single2diff2single/9625f5bb-27cd-530e-a9cf-d1aa15a8223d/scratchpad/agents/BA/work/macros/hv_logic/schematic/xschem/inv_hv.sch
.subckt inv_hv vdd vss a y
*.PININFO vdd:B vss:B a:I y:O
MP y a vdd vdd sg13_hv_pmos w=1u l=0.45u ng=1
MN y a vss vss sg13_hv_nmos w=1u l=0.45u ng=1
.ends

* expanding   symbol:  nor2_hv.sym # of pins=5
** sym_path: /tmp/claude-0/-home-user-sg13cmos5l-cm-ip--single2diff2single/9625f5bb-27cd-530e-a9cf-d1aa15a8223d/scratchpad/agents/BA/work/macros/hv_logic/schematic/xschem/nor2_hv.sym
** sch_path: /tmp/claude-0/-home-user-sg13cmos5l-cm-ip--single2diff2single/9625f5bb-27cd-530e-a9cf-d1aa15a8223d/scratchpad/agents/BA/work/macros/hv_logic/schematic/xschem/nor2_hv.sch
.subckt nor2_hv vdd vss a b y
*.PININFO vdd:B vss:B a:I b:I y:O
MPA p1 a vdd vdd sg13_hv_pmos w=2u l=0.45u ng=1
MPB y b p1 vdd sg13_hv_pmos w=2u l=0.45u ng=1
MNA y a vss vss sg13_hv_nmos w=1u l=0.45u ng=1
MNB y b vss vss sg13_hv_nmos w=1u l=0.45u ng=1
.ends

* expanding   symbol:  oa_core_pd.sym # of pins=5
** sym_path: /tmp/claude-0/-home-user-sg13cmos5l-cm-ip--single2diff2single/9625f5bb-27cd-530e-a9cf-d1aa15a8223d/scratchpad/agents/BA/work/macros/oa_core_pd/schematic/xschem/oa_core_pd.sym
** sch_path: /tmp/claude-0/-home-user-sg13cmos5l-cm-ip--single2diff2single/9625f5bb-27cd-530e-a9cf-d1aa15a8223d/scratchpad/agents/BA/work/macros/oa_core_pd/schematic/xschem/oa_core_pd.sch
.subckt oa_core_pd vdd vss iout en_3v3 en_3v3_b
*.PININFO vdd:B vss:B en_3v3:I en_3v3_b:I iout:O
MMS2 ks vbr vss vss sg13_hv_nmos w=10u l=1u ng=1
MMS3 vpc ks vss vss sg13_hv_nmos w=0.5u l=2u ng=1
MP0 vpg vpg vdd vdd sg13_hv_pmos w=2u l=8u ng=1
MP0C vpc vpc vpg vdd sg13_hv_pmos w=0.5u l=2u ng=1
MMC10 vpc vbr d10 vss sg13_hv_nmos w=10u l=1u ng=1
MM10 d10 vnc vres vss sg13_hv_nmos w=180u l=1u ng=18
MMCL vres vbr vss vss sg13_hv_nmos w=3.4u l=30u ng=1
MP8 c8 vpg vdd vdd sg13_hv_pmos w=16u l=8u ng=8
MP8C vnc vpc c8 vdd sg13_hv_pmos w=4u l=2u ng=2
MM11 vnc vnc vss vss sg13_hv_nmos w=90u l=1u ng=9
MP2 c2 vpg vdd vdd sg13_hv_pmos w=4u l=8u ng=2
MP2C vbr vpc c2 vdd sg13_hv_pmos w=1u l=2u ng=1
MMCS vbr vbr vss vss sg13_hv_nmos w=3.4u l=30u ng=1
MPO co vpg vdd vdd sg13_hv_pmos w=40u l=8u ng=20
MPOC iout vpc co vdd sg13_hv_pmos w=10u l=2u ng=5
MSKS ks en_3v3_b vss vss sg13_hv_nmos w=1u l=0.45u ng=1
MSVPG vpg en_3v3 vdd vdd sg13_hv_pmos w=1u l=0.45u ng=1
MMS1_0 net1 en_3v3_b vdd vdd sg13_hv_pmos w=0.5u l=12.5u ng=1
MMS1_1 net2 en_3v3_b net1 vdd sg13_hv_pmos w=0.5u l=12.5u ng=1
MMS1_2 net3 en_3v3_b net2 vdd sg13_hv_pmos w=0.5u l=12.5u ng=1
MMS1_3 net4 en_3v3_b net3 vdd sg13_hv_pmos w=0.5u l=12.5u ng=1
MMS1_4 net5 en_3v3_b net4 vdd sg13_hv_pmos w=0.5u l=12.5u ng=1
MMS1_5 net6 en_3v3_b net5 vdd sg13_hv_pmos w=0.5u l=12.5u ng=1
MMS1_6 net7 en_3v3_b net6 vdd sg13_hv_pmos w=0.5u l=12.5u ng=1
MMS1_7 ks en_3v3_b net7 vdd sg13_hv_pmos w=0.5u l=12.5u ng=1
MMDUM0 vdd vpg vdd vdd sg13_hv_pmos w=4.4u l=8u ng=9
MMDUM1 vss vnc vss vss sg13_hv_nmos w=36u l=1u ng=18
MMDUM2 vss vbr vss vss sg13_hv_nmos w=4u l=1u ng=2
.ends

* expanding   symbol:  bg_core_pd.sym # of pins=5
** sym_path: /tmp/claude-0/-home-user-sg13cmos5l-cm-ip--single2diff2single/9625f5bb-27cd-530e-a9cf-d1aa15a8223d/scratchpad/agents/BA/work/macros/bg_core_pd/schematic/xschem/bg_core_pd.sym
** sch_path: /tmp/claude-0/-home-user-sg13cmos5l-cm-ip--single2diff2single/9625f5bb-27cd-530e-a9cf-d1aa15a8223d/scratchpad/agents/BA/work/macros/bg_core_pd/schematic/xschem/bg_core_pd.sch
.subckt bg_core_pd vdd vss iout en_3v3 en_3v3_b
*.PININFO vdd:B vss:B en_3v3:I en_3v3_b:I iout:O
MMS2 ks g vss vss sg13_hv_nmos w=10u l=1u ng=1
MMS3 vpc ks vss vss sg13_hv_nmos w=0.5u l=2u ng=1
MPB vpg vpg vdd vdd sg13_hv_pmos w=40u l=1u ng=4
MPBC vpc vpc vpg vdd sg13_hv_pmos w=40u l=1u ng=4
MNB vpc g eb vss sg13_hv_nmos w=20u l=4u ng=2
QQ2 vss vss e2 pnpMPA a=4e-12 p=8e-06 m=8
MPA ca vpg vdd vdd sg13_hv_pmos w=40u l=1u ng=4
MPAC g vpc ca vdd sg13_hv_pmos w=40u l=1u ng=4
MNA g g ea vss sg13_hv_nmos w=20u l=4u ng=2
QQ1 vss vss ea pnpMPA a=4e-12 p=8e-06
MPO co vpg vdd vdd sg13_hv_pmos w=80u l=1u ng=8
MPOC iout vpc co vdd sg13_hv_pmos w=80u l=1u ng=8
MSKS ks en_3v3_b vss vss sg13_hv_nmos w=1u l=0.45u ng=1
MSVPG vpg en_3v3 vdd vdd sg13_hv_pmos w=1u l=0.45u ng=1
RR1B[9] eb n1b[8] 29.71k $SUB=vss $[rhigh] w=0.5u l=9.94u b=0
R1B[8] n1b[8] n1b[7] 29.71k $SUB=vss $[rhigh] w=0.5u l=9.94u b=0
R1B[7] n1b[7] n1b[6] 29.71k $SUB=vss $[rhigh] w=0.5u l=9.94u b=0
R1B[6] n1b[6] n1b[5] 29.71k $SUB=vss $[rhigh] w=0.5u l=9.94u b=0
R1B[5] n1b[5] n1b[4] 29.71k $SUB=vss $[rhigh] w=0.5u l=9.94u b=0
R1B[4] n1b[4] n1b[3] 29.71k $SUB=vss $[rhigh] w=0.5u l=9.94u b=0
R1B[3] n1b[3] n1b[2] 29.71k $SUB=vss $[rhigh] w=0.5u l=9.94u b=0
R1B[2] n1b[2] n1b[1] 29.71k $SUB=vss $[rhigh] w=0.5u l=9.94u b=0
R1B[1] n1b[1] n1b[0] 29.71k $SUB=vss $[rhigh] w=0.5u l=9.94u b=0
R1B[0] n1b[0] vss 29.71k $SUB=vss $[rhigh] w=0.5u l=9.94u b=0
RR0[17] eb n0[16] 29.71k $SUB=vss $[rhigh] w=0.5u l=9.94u b=0
R0[16] n0[16] n0[15] 29.71k $SUB=vss $[rhigh] w=0.5u l=9.94u b=0
R0[15] n0[15] n0[14] 29.71k $SUB=vss $[rhigh] w=0.5u l=9.94u b=0
R0[14] n0[14] n0[13] 29.71k $SUB=vss $[rhigh] w=0.5u l=9.94u b=0
R0[13] n0[13] n0[12] 29.71k $SUB=vss $[rhigh] w=0.5u l=9.94u b=0
R0[12] n0[12] n0[11] 29.71k $SUB=vss $[rhigh] w=0.5u l=9.94u b=0
R0[11] n0[11] n0[10] 29.71k $SUB=vss $[rhigh] w=0.5u l=9.94u b=0
R0[10] n0[10] n0[9] 29.71k $SUB=vss $[rhigh] w=0.5u l=9.94u b=0
R0[9] n0[9] n0[8] 29.71k $SUB=vss $[rhigh] w=0.5u l=9.94u b=0
R0[8] n0[8] n0[7] 29.71k $SUB=vss $[rhigh] w=0.5u l=9.94u b=0
R0[7] n0[7] n0[6] 29.71k $SUB=vss $[rhigh] w=0.5u l=9.94u b=0
R0[6] n0[6] n0[5] 29.71k $SUB=vss $[rhigh] w=0.5u l=9.94u b=0
R0[5] n0[5] n0[4] 29.71k $SUB=vss $[rhigh] w=0.5u l=9.94u b=0
R0[4] n0[4] n0[3] 29.71k $SUB=vss $[rhigh] w=0.5u l=9.94u b=0
R0[3] n0[3] n0[2] 29.71k $SUB=vss $[rhigh] w=0.5u l=9.94u b=0
R0[2] n0[2] n0[1] 29.71k $SUB=vss $[rhigh] w=0.5u l=9.94u b=0
R0[1] n0[1] n0[0] 29.71k $SUB=vss $[rhigh] w=0.5u l=9.94u b=0
R0[0] n0[0] e2 29.71k $SUB=vss $[rhigh] w=0.5u l=9.94u b=0
RR1A[10] ea n1a[9] 29.71k $SUB=vss $[rhigh] w=0.5u l=9.94u b=0
R1A[9] n1a[9] n1a[8] 29.71k $SUB=vss $[rhigh] w=0.5u l=9.94u b=0
R1A[8] n1a[8] n1a[7] 29.71k $SUB=vss $[rhigh] w=0.5u l=9.94u b=0
R1A[7] n1a[7] n1a[6] 29.71k $SUB=vss $[rhigh] w=0.5u l=9.94u b=0
R1A[6] n1a[6] n1a[5] 29.71k $SUB=vss $[rhigh] w=0.5u l=9.94u b=0
R1A[5] n1a[5] n1a[4] 29.71k $SUB=vss $[rhigh] w=0.5u l=9.94u b=0
R1A[4] n1a[4] n1a[3] 29.71k $SUB=vss $[rhigh] w=0.5u l=9.94u b=0
R1A[3] n1a[3] n1a[2] 29.71k $SUB=vss $[rhigh] w=0.5u l=9.94u b=0
R1A[2] n1a[2] n1a[1] 29.71k $SUB=vss $[rhigh] w=0.5u l=9.94u b=0
R1A[1] n1a[1] n1a[0] 29.71k $SUB=vss $[rhigh] w=0.5u l=9.94u b=0
R1A[0] n1a[0] vss 29.71k $SUB=vss $[rhigh] w=0.5u l=9.94u b=0
MMS1_0 net1 en_3v3_b vdd vdd sg13_hv_pmos w=0.5u l=12.5u ng=1
MMS1_1 net2 en_3v3_b net1 vdd sg13_hv_pmos w=0.5u l=12.5u ng=1
MMS1_2 net3 en_3v3_b net2 vdd sg13_hv_pmos w=0.5u l=12.5u ng=1
MMS1_3 net4 en_3v3_b net3 vdd sg13_hv_pmos w=0.5u l=12.5u ng=1
MMS1_4 net5 en_3v3_b net4 vdd sg13_hv_pmos w=0.5u l=12.5u ng=1
MMS1_5 net6 en_3v3_b net5 vdd sg13_hv_pmos w=0.5u l=12.5u ng=1
MMS1_6 net7 en_3v3_b net6 vdd sg13_hv_pmos w=0.5u l=12.5u ng=1
MMS1_7 ks en_3v3_b net7 vdd sg13_hv_pmos w=0.5u l=12.5u ng=1
MMDUM0 vdd vpg vdd vdd sg13_hv_pmos w=2.4u l=1u ng=8
MMDUM1 vdd vpc vdd vdd sg13_hv_pmos w=2.4u l=1u ng=8
MMDUM2 g g g vss sg13_hv_nmos w=2u l=1u ng=1
MMDUM3 g g g vss sg13_hv_nmos w=16u l=4u ng=8
RRDUM[1] vss vss 29.71k $SUB=vss $[rhigh] w=0.5u l=9.94u b=0
RDUM[0] vss vss 29.71k $SUB=vss $[rhigh] w=0.5u l=9.94u b=0
.ends
