** sch_path: /tmp/claude-0/-home-user-sg13cmos5l-cm-ip--single2diff2single/9625f5bb-27cd-530e-a9cf-d1aa15a8223d/scratchpad/agents/BA/work/macros/bias_tree_noab_pd/schematic/xschem/bias_tree_noab_pd.sch
.subckt bias_tree_noab_pd vdd vss iref vbp vbn vbpc vbnc en_3v3 en_3v3_b
*.PININFO vdd:B vss:B iref:B vbp:O vbn:O vbpc:O vbnc:O en_3v3:I en_3v3_b:I
MNI ni ni vss vss sg13_hv_nmos w=6u l=6u ng=1
MBPC vbpc vbpc vdd vdd sg13_hv_pmos w=1u l=4u ng=1
MNBPC vbpc ni vss vss sg13_hv_nmos w=2.4u l=6u ng=1
MBP vbp vbp vdd vdd sg13_hv_pmos w=5u l=6u ng=1
MNBP vbp ni vss vss sg13_hv_nmos w=6u l=6u ng=1
MPBNC vbnc vbp vdd vdd sg13_hv_pmos w=2u l=6u ng=1
MBNC vbnc vbnc vss vss sg13_hv_nmos w=1u l=8u ng=1
MPBN vbn vbp vdd vdd sg13_hv_pmos w=5u l=6u ng=1
MBN vbn vbn vss vss sg13_hv_nmos w=6u l=6u ng=1
MTGP ni en_3v3_b iref vdd sg13_hv_pmos w=1u l=0.45u ng=1
MTGN iref en_3v3 ni vss sg13_hv_nmos w=1u l=0.45u ng=1
MTDN ni en_3v3_b vss vss sg13_hv_nmos w=1u l=0.45u ng=1
MMDBP vdd vbp vdd vdd sg13_hv_pmos w=2u l=6u ng=1
MMDBN vss ni vss vss sg13_hv_nmos w=2.4u l=6u ng=1
.ends
