** sch_path: /tmp/claude-0/-home-user-sg13cmos5l-cm-ip--single2diff2single/9625f5bb-27cd-530e-a9cf-d1aa15a8223d/scratchpad/agents/BA/work/macros/sg13cmos5l_IOPadSingle2Diff/schematic/xschem/s2d_mpdda.sch
.subckt s2d_mpdda vdd vss vin vref vcm voutp voutn vfbp vfbn vbp vbn vbpc vbnc
*.PININFO vdd:B vss:B vin:I vref:I vcm:I voutp:O voutn:O vfbp:I vfbn:I vbp:B vbn:B vbpc:B vbnc:B
XA1 x y vin vref vdd vss vbp unit_r2
XA2 x y vin vref vdd vss vbp unit_r2
XF1 x y vcm vfbp vdd vss vbp unit_r2
XF2 x y vfbn vcm vdd vss vbp unit_r2
MLP lp vcmfb vdd vdd sg13_hv_pmos w=24u l=4u ng=4
MLPC voutp vbpc lp vdd sg13_hv_pmos w=30u l=3u ng=2
MCX voutp vbnc x vss sg13_hv_nmos w=30u l=3u ng=2
MSX x vbn vss vss sg13_hv_nmos w=36u l=6u ng=6
MLN ln vcmfb vdd vdd sg13_hv_pmos w=24u l=4u ng=4
MLNC voutn vbpc ln vdd sg13_hv_pmos w=30u l=3u ng=2
MCY voutn vbnc y vss sg13_hv_nmos w=30u l=3u ng=2
MSY y vbn vss vss sg13_hv_nmos w=36u l=6u ng=6
MCLP vss voutp vss vss sg13_hv_nmos w=12u l=12u ng=1
MCLN vss voutn vss vss sg13_hv_nmos w=12u l=12u ng=1
XM1 xc yc vfbp vcm vdd vss vbp unit_r2
XM2 xc yc vfbn vcm vdd vss vbp unit_r2
MD dd vcmfb vdd vdd sg13_hv_pmos w=24u l=4u ng=4
MDC vcmfb vbpc dd vdd sg13_hv_pmos w=30u l=3u ng=2
MCXC vcmfb vbnc xc vss sg13_hv_nmos w=30u l=3u ng=2
MSXC xc vbn vss vss sg13_hv_nmos w=24u l=6u ng=4
MCYC vdd vbnc yc vss sg13_hv_nmos w=30u l=3u ng=2
MSYC yc vbn vss vss sg13_hv_nmos w=24u l=6u ng=4
MMDL[3] vdd vcmfb vdd vdd sg13_hv_pmos w=1u l=4u ng=1
MDL[2] vdd vcmfb vdd vdd sg13_hv_pmos w=1u l=4u ng=1
MDL[1] vdd vcmfb vdd vdd sg13_hv_pmos w=1u l=4u ng=1
MDL[0] vdd vcmfb vdd vdd sg13_hv_pmos w=1u l=4u ng=1
.ends

* expanding   symbol:  unit_r2.sym # of pins=7
** sym_path: /tmp/claude-0/-home-user-sg13cmos5l-cm-ip--single2diff2single/9625f5bb-27cd-530e-a9cf-d1aa15a8223d/scratchpad/agents/BA/work/macros/sg13cmos5l_IOPadDiff2Single/schematic/xschem/unit_r2.sym
** sch_path: /tmp/claude-0/-home-user-sg13cmos5l-cm-ip--single2diff2single/9625f5bb-27cd-530e-a9cf-d1aa15a8223d/scratchpad/agents/BA/work/macros/sg13cmos5l_IOPadDiff2Single/schematic/xschem/unit_r2.sch
.subckt unit_r2 x y gp gn vdd vss vbp
*.PININFO x:O y:O gp:I gn:I vdd:B vss:B vbp:I
MTa sa vbp vdd vdd sg13_hv_pmos w=5u l=6u ng=1
MTb sb vbp vdd vdd sg13_hv_pmos w=5u l=6u ng=1
MMa y gp sa sa sg13_hv_pmos w=20u l=1u ng=2
MMb x gn sb sb sg13_hv_pmos w=20u l=1u ng=2
RR[3] sa n1 37.72k $SUB=vss $[rhigh] w=0.5u l=12.65u b=0
R[2] n1 n2 37.72k $SUB=vss $[rhigh] w=0.5u l=12.65u b=0
R[1] n2 n3 37.72k $SUB=vss $[rhigh] w=0.5u l=12.65u b=0
R[0] n3 sb 37.72k $SUB=vss $[rhigh] w=0.5u l=12.65u b=0
.ends
