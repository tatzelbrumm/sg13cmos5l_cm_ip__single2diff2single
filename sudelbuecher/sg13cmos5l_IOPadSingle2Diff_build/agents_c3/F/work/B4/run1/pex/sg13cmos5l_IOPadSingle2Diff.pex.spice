* PEX produced on Wed Nov  4 21:12:32 UTC 2026 using /usr/local/bin/sak-pex.sh with m=2 and s=1
* NGSPICE file created from sg13cmos5l_IOPadSingle2Diff.ext - technology: ihp-sg13cmos5l

.subckt sg13cmos5l_IOPadSingle2Diff vdd iovss pad iovdd vref outp outn vcm en_3v3
+ en_3v3_b iref
X0 iovdd s2d_block_0.s2d_tails_hi_f_0.vbp iovdd iovdd sg13_hv_pmos ad=1.7p pd=10.68u as=0.65663n ps=2.66142m w=5u l=6u
X1 iovss iovss iovss rhigh l=12.65u w=0.5u
X2 s2d_block_0.s2d_loads_f_0.ln s2d_block_0.s2d_loads_f_0.vcmfb iovdd iovdd sg13_hv_pmos ad=2.04p pd=12.68u as=2.04p ps=12.68u w=6u l=4u
X3 s2d_block_0.s2d_loads_f_0.ln s2d_block_0.s2d_casc_p_f_0.vbpc outn iovdd sg13_hv_pmos ad=5.1p pd=30.68u as=5.1p ps=30.68u w=15u l=3u
X4 s2d_block_0.s2d_tails_hi_f_0.sa_A2 a_14374_25646# iovss rhigh l=12.65u w=0.5u
X5 s2d_block_0.s2d_casc_n_f_0.xc s2d_block_0.sinks_6x6_s2d_c3_core_0.vbn iovss iovss sg13_hv_nmos ad=2.04p pd=12.68u as=2.04p ps=12.68u w=6u l=6u
X6 iovdd s2d_block_0.s2d_casc_n_f_0.vbnc s2d_block_0.s2d_casc_n_f_0.yc iovss sg13_hv_nmos ad=5.1p pd=30.68u as=5.1p ps=30.68u w=15u l=3u
X7 Clamp_P_M1_0.gate iovdd iovss rppd l=12.9u w=0.5u
X8 s2d_block_0.s2d_loads_f_0.ln s2d_block_0.s2d_loads_f_0.vcmfb iovdd iovdd sg13_hv_pmos ad=2.04p pd=12.68u as=2.04p ps=12.68u w=6u l=4u
X9 s2d_block_0.s2d_casc_p_f_0.vbpc s2d_block_0.bias_tree_noab_n_c3_0.ni iovss iovss sg13_hv_nmos ad=0.816p pd=5.48u as=0.816p ps=5.48u w=2.4u l=6u
X10 a_11758_27006# a_14374_25510# iovss rhigh l=12.65u w=0.5u
X11 s2d_block_0.s2d_tails_lo_f_0.sa_F1 vcm s2d_block_0.s2d_casc_n_f_0.y s2d_block_0.s2d_tails_lo_f_0.sa_F1 sg13_hv_pmos ad=3.4p pd=20.68u as=1.9p ps=10.38u w=10u l=1u
X12 iovss s2d_block_0.sinks_6x6_s2d_c3_core_0.vbn iovss iovss sg13_hv_nmos ad=0.68p pd=4.68u as=0.75674n ps=2.78086m w=2u l=6u
X13 iovdd Clamp_P_M1_0.gate pad iovdd sg13_hv_pmos ad=2.1312p pd=7.3u as=3.9294p ps=7.84u w=6.66u l=0.6u
X14 iovss s2d_block_0.sinks_6x6_s2d_c3_core_0.vbn s2d_block_0.s2d_casc_n_f_0.xc iovss sg13_hv_nmos ad=2.04p pd=12.68u as=2.04p ps=12.68u w=6u l=6u
X15 s2d_block_0.bias_tree_noab_n_c3_0.ni en_3v3_b iovss iovss sg13_hv_nmos ad=0.34p pd=2.68u as=0.34p ps=2.68u w=1u l=0.45u
X16 iovdd Clamp_P_M1_0.gate pad iovdd sg13_hv_pmos ad=2.1312p pd=7.3u as=3.9294p ps=7.84u w=6.66u l=0.6u
X17 iovss s2d_block_0.sinks_6x6_s2d_c3_core_0.vbn iovss iovss sg13_hv_nmos ad=2.04p pd=12.68u as=0 ps=0 w=6u l=6u
X18 s2d_block_0.s2d_casc_n_f_0.x s2d_block_0.s2d_casc_n_f_0.vbnc outp iovss sg13_hv_nmos ad=5.1p pd=30.68u as=5.1p ps=30.68u w=15u l=3u
X19 s2d_block_0.s2d_casc_n_f_0.x vref s2d_block_0.s2d_tails_lo_f_0.sb_A2 s2d_block_0.s2d_tails_lo_f_0.sb_A2 sg13_hv_pmos ad=1.9p pd=10.38u as=3.4p ps=20.68u w=10u l=1u
X20 iovdd Clamp_P_M1_0.gate pad iovdd sg13_hv_pmos ad=2.1312p pd=7.3u as=3.9294p ps=7.84u w=6.66u l=0.6u
X21 s2d_block_0.s2d_tails_hi_f_0.sb_F1 outp s2d_block_0.s2d_casc_n_f_0.x s2d_block_0.s2d_tails_hi_f_0.sb_F1 sg13_hv_pmos ad=3.4p pd=20.68u as=1.9p ps=10.38u w=10u l=1u
X22 iovdd iovdd iovdd iovdd sg13_hv_pmos ad=1.9p pd=10.38u as=0 ps=0 w=10u l=1u
X23 iovdd s2d_block_0.s2d_tails_hi_f_0.vbp iovdd iovdd sg13_hv_pmos ad=1.7p pd=10.68u as=0 ps=0 w=5u l=6u
X24 s2d_block_0.s2d_casc_n_f_0.y s2d_block_0.sinks_6x6_s2d_c3_core_0.vbn iovss iovss sg13_hv_nmos ad=2.04p pd=12.68u as=2.04p ps=12.68u w=6u l=6u
X25 s2d_block_0.s2d_tails_lo_f_0.sb_A2 a_14374_27278# iovss rhigh l=12.65u w=0.5u
X26 iovdd s2d_block_0.s2d_loads_f_0.vcmfb s2d_block_0.s2d_loads_f_0.dd iovdd sg13_hv_pmos ad=2.04p pd=12.68u as=2.04p ps=12.68u w=6u l=4u
X27 pad Clamp_N_M1_0.gate iovss iovss sg13_hv_nmos ad=2.596p pd=5.58u as=1.408p ps=5.04u w=4.4u l=0.6u
X28 pad Clamp_N_M1_0.gate iovss iovss sg13_hv_nmos ad=2.596p pd=5.58u as=2.068p ps=9.74u w=4.4u l=0.6u
X29 iovdd s2d_block_0.s2d_loads_f_0.vcmfb s2d_block_0.s2d_loads_f_0.lp iovdd sg13_hv_pmos ad=2.04p pd=12.68u as=2.04p ps=12.68u w=6u l=4u
X30 pad Clamp_N_M1_0.gate iovss iovss sg13_hv_nmos ad=2.596p pd=5.58u as=1.408p ps=5.04u w=4.4u l=0.6u
X31 vcm en_3v3_b outp iovss sg13_hv_nmos ad=0.19p pd=1.38u as=0.34p ps=2.68u w=1u l=0.45u
X32 s2d_block_0.s2d_tails_lo_f_0.sa_F1 a_14374_25782# iovss rhigh l=12.65u w=0.5u
X33 a_11758_27006# a_14374_27142# iovss rhigh l=12.65u w=0.5u
X34 iovdd iovdd iovdd iovdd sg13_hv_pmos ad=3.4p pd=20.68u as=0 ps=0 w=10u l=1u
X35 pad Clamp_P_M1_0.gate iovdd iovdd sg13_hv_pmos ad=3.9294p pd=7.84u as=2.1312p ps=7.3u w=6.66u l=0.6u
X36 s2d_block_0.s2d_loads_f_0.lp s2d_block_0.s2d_casc_p_f_0.vbpc outp iovdd sg13_hv_pmos ad=5.1p pd=30.68u as=5.1p ps=30.68u w=15u l=3u
X37 iovdd s2d_block_0.s2d_tails_hi_f_0.vbp s2d_block_0.s2d_tails_hi_f_0.sa_M1 iovdd sg13_hv_pmos ad=1.7p pd=10.68u as=1.7p ps=10.68u w=5u l=6u
X38 s2d_block_0.s2d_casc_n_f_0.y s2d_block_0.sinks_6x6_s2d_c3_core_0.vbn iovss iovss sg13_hv_nmos ad=2.04p pd=12.68u as=2.04p ps=12.68u w=6u l=6u
X39 iovdd Clamp_P_M1_0.gate pad iovdd sg13_hv_pmos ad=2.1312p pd=7.3u as=3.9294p ps=7.84u w=6.66u l=0.6u
X40 iovdd Clamp_P_M1_0.gate pad iovdd sg13_hv_pmos ad=2.1312p pd=7.3u as=3.9294p ps=7.84u w=6.66u l=0.6u
X41 iref en_3v3 s2d_block_0.bias_tree_noab_n_c3_0.ni iovss sg13_hv_nmos ad=0.34p pd=2.68u as=0.34p ps=2.68u w=1u l=0.45u
X42 iovdd Clamp_P_M1_0.gate pad iovdd sg13_hv_pmos ad=2.1312p pd=7.3u as=3.9294p ps=7.84u w=6.66u l=0.6u
X43 pad iovdd dpantenna l=1.26u w=27.78u
X44 pad Clamp_P_M1_0.gate iovdd iovdd sg13_hv_pmos ad=3.9294p pd=7.84u as=2.1312p ps=7.3u w=6.66u l=0.6u
X45 s2d_block_0.s2d_casc_n_f_0.x vcm s2d_block_0.s2d_tails_hi_f_0.sb_F2 s2d_block_0.s2d_tails_hi_f_0.sb_F2 sg13_hv_pmos ad=1.9p pd=10.38u as=3.4p ps=20.68u w=10u l=1u
X46 s2d_block_0.s2d_tails_hi_f_0.sa_A1 a_14374_25510# iovss rhigh l=12.65u w=0.5u
X47 iovss s2d_block_0.sinks_6x6_s2d_c3_core_0.vbn s2d_block_0.s2d_casc_n_f_0.y iovss sg13_hv_nmos ad=2.04p pd=12.68u as=2.04p ps=12.68u w=6u l=6u
X48 s2d_block_0.s2d_tails_hi_f_0.sb_F1 a_14374_27414# iovss rhigh l=12.65u w=0.5u
X49 s2d_block_0.s2d_tails_lo_f_0.sa_F2 outn s2d_block_0.s2d_casc_n_f_0.y s2d_block_0.s2d_tails_lo_f_0.sa_F2 sg13_hv_pmos ad=3.4p pd=20.68u as=1.9p ps=10.38u w=10u l=1u
X50 iovss s2d_block_0.bias_tree_noab_n_c3_0.ni iovss iovss sg13_hv_nmos ad=0.816p pd=5.48u as=0 ps=0 w=2.4u l=6u
X51 s2d_block_0.s2d_casc_n_f_0.y s2d_block_0.s2d_casc_n_f_0.vbnc outn iovss sg13_hv_nmos ad=5.1p pd=30.68u as=5.1p ps=30.68u w=15u l=3u
X52 pad Clamp_N_M1_0.gate iovss iovss sg13_hv_nmos ad=2.596p pd=5.58u as=1.408p ps=5.04u w=4.4u l=0.6u
X53 iovss s2d_block_0.s2d_casc_n_f_0.vbnc iovss iovss sg13_hv_nmos ad=0.68p pd=4.68u as=0 ps=0 w=2u l=3u
X54 iovss pad dantenna l=1.26u w=27.78u
X55 pad Clamp_N_M1_0.gate iovss iovss sg13_hv_nmos ad=2.596p pd=5.58u as=1.408p ps=5.04u w=4.4u l=0.6u
X56 vcm en_3v3 outp iovdd sg13_hv_pmos ad=0.19p pd=1.38u as=0.34p ps=2.68u w=1u l=0.45u
X57 outn en_3v3 vcm iovdd sg13_hv_pmos ad=0.34p pd=2.68u as=0.19p ps=1.38u w=1u l=0.45u
X58 iovdd s2d_block_0.s2d_tails_hi_f_0.vbp s2d_block_0.s2d_tails_hi_f_0.sb_M2 iovdd sg13_hv_pmos ad=1.7p pd=10.68u as=1.7p ps=10.68u w=5u l=6u
X59 iovss s2d_block_0.sinks_6x6_s2d_c3_core_0.vbn s2d_block_0.s2d_casc_n_f_0.y iovss sg13_hv_nmos ad=2.04p pd=12.68u as=2.04p ps=12.68u w=6u l=6u
X60 pad Clamp_P_M1_0.gate iovdd iovdd sg13_hv_pmos ad=3.9294p pd=7.84u as=2.1312p ps=7.3u w=6.66u l=0.6u
X61 iovdd s2d_block_0.s2d_tails_hi_f_0.vbp s2d_block_0.s2d_tails_hi_f_0.sb_F1 iovdd sg13_hv_pmos ad=1.7p pd=10.68u as=1.7p ps=10.68u w=5u l=6u
X62 iovdd s2d_block_0.s2d_loads_f_0.vcmfb s2d_block_0.s2d_loads_f_0.lp iovdd sg13_hv_pmos ad=2.04p pd=12.68u as=2.04p ps=12.68u w=6u l=4u
X63 iovdd Clamp_P_M1_0.gate pad iovdd sg13_hv_pmos ad=2.1312p pd=7.3u as=3.9294p ps=7.84u w=6.66u l=0.6u
X64 a_11758_26734# a_14374_25782# iovss rhigh l=12.65u w=0.5u
X65 pad Clamp_P_M1_0.gate iovdd iovdd sg13_hv_pmos ad=3.9294p pd=7.84u as=2.1312p ps=7.3u w=6.66u l=0.6u
X66 pad Clamp_P_M1_0.gate iovdd iovdd sg13_hv_pmos ad=3.9294p pd=7.84u as=2.1312p ps=7.3u w=6.66u l=0.6u
X67 pad Clamp_P_M1_0.gate iovdd iovdd sg13_hv_pmos ad=3.9294p pd=7.84u as=2.1312p ps=7.3u w=6.66u l=0.6u
X68 s2d_block_0.s2d_tails_hi_f_0.sb_M2 vcm s2d_block_0.s2d_casc_n_f_0.xc s2d_block_0.s2d_tails_hi_f_0.sb_M2 sg13_hv_pmos ad=3.4p pd=20.68u as=1.9p ps=10.38u w=10u l=1u
X69 pad Clamp_P_M1_0.gate iovdd iovdd sg13_hv_pmos ad=3.9294p pd=7.84u as=2.1312p ps=7.3u w=6.66u l=0.6u
X70 iovss Clamp_N_M1_0.gate pad iovss sg13_hv_nmos ad=1.408p pd=5.04u as=2.596p ps=5.58u w=4.4u l=0.6u
X71 iovss Clamp_N_M1_0.gate pad iovss sg13_hv_nmos ad=1.408p pd=5.04u as=2.596p ps=5.58u w=4.4u l=0.6u
X72 iovss iovss iovss rhigh l=12.65u w=0.5u
X73 s2d_block_0.s2d_casc_n_f_0.yc s2d_block_0.s2d_casc_n_f_0.vbnc iovdd iovss sg13_hv_nmos ad=5.1p pd=30.68u as=5.1p ps=30.68u w=15u l=3u
X74 iovdd s2d_block_0.s2d_casc_p_f_0.vbpc iovdd iovdd sg13_hv_pmos ad=0.34p pd=2.68u as=0 ps=0 w=1u l=4u
X75 s2d_block_0.s2d_casc_n_f_0.yc outp s2d_block_0.s2d_tails_hi_f_0.sa_M1 s2d_block_0.s2d_tails_hi_f_0.sa_M1 sg13_hv_pmos ad=1.9p pd=10.38u as=3.4p ps=20.68u w=10u l=1u
X76 s2d_block_0.s2d_casc_n_f_0.y vcm s2d_block_0.s2d_tails_lo_f_0.sa_F1 s2d_block_0.s2d_tails_lo_f_0.sa_F1 sg13_hv_pmos ad=1.9p pd=10.38u as=3.4p ps=20.68u w=10u l=1u
X77 iovdd s2d_block_0.s2d_tails_hi_f_0.vbp s2d_block_0.s2d_tails_hi_f_0.sa_A2 iovdd sg13_hv_pmos ad=1.7p pd=10.68u as=1.7p ps=10.68u w=5u l=6u
X78 s2d_block_0.s2d_tails_hi_f_0.sa_A2 pad s2d_block_0.s2d_casc_n_f_0.y s2d_block_0.s2d_tails_hi_f_0.sa_A2 sg13_hv_pmos ad=3.4p pd=20.68u as=1.9p ps=10.38u w=10u l=1u
X79 iovss s2d_block_0.sinks_6x6_s2d_c3_core_0.vbn s2d_block_0.s2d_casc_n_f_0.yc iovss sg13_hv_nmos ad=2.04p pd=12.68u as=2.04p ps=12.68u w=6u l=6u
X80 iovss s2d_block_0.sinks_6x6_s2d_c3_core_0.vbn iovss iovss sg13_hv_nmos ad=0.68p pd=4.68u as=0 ps=0 w=2u l=6u
X81 s2d_block_0.s2d_tails_hi_f_0.sb_M2 a_14374_27822# iovss rhigh l=12.65u w=0.5u
X82 s2d_block_0.s2d_casc_n_f_0.yc s2d_block_0.sinks_6x6_s2d_c3_core_0.vbn iovss iovss sg13_hv_nmos ad=2.04p pd=12.68u as=2.04p ps=12.68u w=6u l=6u
X83 iovss s2d_block_0.sinks_6x6_s2d_c3_core_0.vbn s2d_block_0.s2d_casc_n_f_0.y iovss sg13_hv_nmos ad=2.04p pd=12.68u as=2.04p ps=12.68u w=6u l=6u
X84 iovdd s2d_block_0.s2d_tails_hi_f_0.vbp s2d_block_0.s2d_tails_hi_f_0.sa_A1 iovdd sg13_hv_pmos ad=1.7p pd=10.68u as=1.7p ps=10.68u w=5u l=6u
X85 a_11758_26870# a_14374_25646# iovss rhigh l=12.65u w=0.5u
X86 s2d_block_0.s2d_casc_n_f_0.vbnc s2d_block_0.s2d_tails_hi_f_0.vbp iovdd iovdd sg13_hv_pmos ad=0.68p pd=4.68u as=0.68p ps=4.68u w=2u l=6u
X87 s2d_block_0.s2d_tails_hi_f_0.sb_F2 a_14374_27550# iovss rhigh l=12.65u w=0.5u
X88 iovdd s2d_block_0.s2d_tails_hi_f_0.vbp iovdd iovdd sg13_hv_pmos ad=1.7p pd=10.68u as=0 ps=0 w=5u l=6u
X89 pad Clamp_P_M1_0.gate iovdd iovdd sg13_hv_pmos ad=3.9294p pd=7.84u as=2.1312p ps=7.3u w=6.66u l=0.6u
X90 pad Clamp_P_M1_0.gate iovdd iovdd sg13_hv_pmos ad=3.9294p pd=7.84u as=2.1312p ps=7.3u w=6.66u l=0.6u
X91 a_11758_26598# a_14374_25918# iovss rhigh l=12.65u w=0.5u
X92 iovss s2d_block_0.sinks_6x6_s2d_c3_core_0.vbn s2d_block_0.s2d_casc_n_f_0.x iovss sg13_hv_nmos ad=2.04p pd=12.68u as=2.04p ps=12.68u w=6u l=6u
X93 s2d_block_0.s2d_loads_f_0.dd s2d_block_0.s2d_loads_f_0.vcmfb iovdd iovdd sg13_hv_pmos ad=2.04p pd=12.68u as=2.04p ps=12.68u w=6u l=4u
X94 pad Clamp_P_M1_0.gate iovdd iovdd sg13_hv_pmos ad=3.9294p pd=7.84u as=2.1312p ps=7.3u w=6.66u l=0.6u
X95 iovss Clamp_N_M1_0.gate pad iovss sg13_hv_nmos ad=1.408p pd=5.04u as=2.596p ps=5.58u w=4.4u l=0.6u
X96 iovdd s2d_block_0.s2d_loads_f_0.vcmfb iovdd iovdd sg13_hv_pmos ad=0.34p pd=2.68u as=0 ps=0 w=1u l=4u
X97 pad iovdd dpantenna l=1.26u w=27.78u
X98 pad Clamp_P_M1_0.gate iovdd iovdd sg13_hv_pmos ad=3.9294p pd=7.84u as=2.1312p ps=7.3u w=6.66u l=0.6u
X99 iovdd s2d_block_0.s2d_loads_f_0.vcmfb s2d_block_0.s2d_loads_f_0.ln iovdd sg13_hv_pmos ad=2.04p pd=12.68u as=2.04p ps=12.68u w=6u l=4u
X100 iovss Clamp_N_M1_0.gate pad iovss sg13_hv_nmos ad=2.068p pd=9.74u as=2.596p ps=5.58u w=4.4u l=0.6u
X101 s2d_block_0.s2d_loads_f_0.lp s2d_block_0.s2d_loads_f_0.vcmfb iovdd iovdd sg13_hv_pmos ad=2.04p pd=12.68u as=2.04p ps=12.68u w=6u l=4u
X102 iovdd s2d_block_0.s2d_loads_f_0.vcmfb s2d_block_0.s2d_loads_f_0.ln iovdd sg13_hv_pmos ad=2.04p pd=12.68u as=2.04p ps=12.68u w=6u l=4u
X103 iovdd s2d_block_0.s2d_casc_p_f_0.vbpc iovdd iovdd sg13_hv_pmos ad=0.34p pd=2.68u as=0 ps=0 w=1u l=4u
X104 pad Clamp_N_M1_0.gate iovss iovss sg13_hv_nmos ad=2.596p pd=5.58u as=1.408p ps=5.04u w=4.4u l=0.6u
X105 s2d_block_0.s2d_tails_lo_f_0.sa_M2 outn s2d_block_0.s2d_casc_n_f_0.yc s2d_block_0.s2d_tails_lo_f_0.sa_M2 sg13_hv_pmos ad=3.4p pd=20.68u as=1.9p ps=10.38u w=10u l=1u
X106 iovdd s2d_block_0.s2d_casc_p_f_0.vbpc s2d_block_0.s2d_casc_p_f_0.vbpc iovdd sg13_hv_pmos ad=0.34p pd=2.68u as=0.34p ps=2.68u w=1u l=4u
X107 iovdd s2d_block_0.s2d_loads_f_0.vcmfb iovdd iovdd sg13_hv_pmos ad=0.34p pd=2.68u as=0 ps=0 w=1u l=4u
X108 s2d_block_0.s2d_casc_n_f_0.y s2d_block_0.sinks_6x6_s2d_c3_core_0.vbn iovss iovss sg13_hv_nmos ad=2.04p pd=12.68u as=2.04p ps=12.68u w=6u l=6u
X109 iovss outp iovss iovss sg13_hv_nmos ad=4.08p pd=24.68u as=0 ps=0 w=12u l=12u
X110 iovss outn iovss iovss sg13_hv_nmos ad=4.08p pd=24.68u as=0 ps=0 w=12u l=12u
X111 iovdd s2d_block_0.s2d_tails_hi_f_0.vbp s2d_block_0.s2d_tails_hi_f_0.sb_F2 iovdd sg13_hv_pmos ad=1.7p pd=10.68u as=1.7p ps=10.68u w=5u l=6u
X112 s2d_block_0.s2d_casc_n_f_0.x outp s2d_block_0.s2d_tails_hi_f_0.sb_F1 s2d_block_0.s2d_tails_hi_f_0.sb_F1 sg13_hv_pmos ad=1.9p pd=10.38u as=3.4p ps=20.68u w=10u l=1u
X113 s2d_block_0.s2d_casc_n_f_0.xc vcm s2d_block_0.s2d_tails_lo_f_0.sb_M1 s2d_block_0.s2d_tails_lo_f_0.sb_M1 sg13_hv_pmos ad=1.9p pd=10.38u as=3.4p ps=20.68u w=10u l=1u
X114 iovss s2d_block_0.sinks_6x6_s2d_c3_core_0.vbn iovss iovss sg13_hv_nmos ad=0.68p pd=4.68u as=0 ps=0 w=2u l=6u
X115 iovdd s2d_block_0.s2d_casc_p_f_0.vbpc iovdd iovdd sg13_hv_pmos ad=0.34p pd=2.68u as=0 ps=0 w=1u l=4u
X116 a_11758_26326# a_14374_26190# iovss rhigh l=12.65u w=0.5u
X117 s2d_block_0.s2d_tails_lo_f_0.sb_A1 vref s2d_block_0.s2d_casc_n_f_0.x s2d_block_0.s2d_tails_lo_f_0.sb_A1 sg13_hv_pmos ad=3.4p pd=20.68u as=1.9p ps=10.38u w=10u l=1u
X118 s2d_block_0.s2d_casc_n_f_0.x s2d_block_0.sinks_6x6_s2d_c3_core_0.vbn iovss iovss sg13_hv_nmos ad=2.04p pd=12.68u as=2.04p ps=12.68u w=6u l=6u
X119 iovdd Clamp_P_M1_0.gate pad iovdd sg13_hv_pmos ad=2.1312p pd=7.3u as=3.9294p ps=7.84u w=6.66u l=0.6u
X120 s2d_block_0.s2d_tails_lo_f_0.sb_M1 a_14374_27686# iovss rhigh l=12.65u w=0.5u
X121 iovss s2d_block_0.sinks_6x6_s2d_c3_core_0.vbn iovss iovss sg13_hv_nmos ad=0.68p pd=4.68u as=0 ps=0 w=2u l=6u
X122 iovdd Clamp_P_M1_0.gate pad iovdd sg13_hv_pmos ad=2.1312p pd=7.3u as=3.9294p ps=7.84u w=6.66u l=0.6u
X123 s2d_block_0.s2d_tails_hi_f_0.sa_A1 pad s2d_block_0.s2d_casc_n_f_0.y s2d_block_0.s2d_tails_hi_f_0.sa_A1 sg13_hv_pmos ad=3.4p pd=20.68u as=1.9p ps=10.38u w=10u l=1u
X124 s2d_block_0.s2d_tails_lo_f_0.sb_M1 s2d_block_0.s2d_tails_hi_f_0.vbp iovdd iovdd sg13_hv_pmos ad=1.7p pd=10.68u as=1.7p ps=10.68u w=5u l=6u
X125 pad Clamp_P_M1_0.gate iovdd iovdd sg13_hv_pmos ad=3.9294p pd=7.84u as=2.1312p ps=7.3u w=6.66u l=0.6u
X126 iovdd iovdd iovdd iovdd sg13_hv_pmos ad=3.4p pd=20.68u as=0 ps=0 w=10u l=1u
X127 a_11758_26326# a_14374_27822# iovss rhigh l=12.65u w=0.5u
X128 s2d_block_0.s2d_casc_n_f_0.xc s2d_block_0.sinks_6x6_s2d_c3_core_0.vbn iovss iovss sg13_hv_nmos ad=2.04p pd=12.68u as=2.04p ps=12.68u w=6u l=6u
X129 pad Clamp_N_M1_0.gate iovss iovss sg13_hv_nmos ad=2.596p pd=5.58u as=1.408p ps=5.04u w=4.4u l=0.6u
X130 pad Clamp_N_M1_0.gate iovss iovss sg13_hv_nmos ad=2.596p pd=5.58u as=1.408p ps=5.04u w=4.4u l=0.6u
X131 iovdd Clamp_P_M1_0.gate pad iovdd sg13_hv_pmos ad=2.1312p pd=7.3u as=3.9294p ps=7.84u w=6.66u l=0.6u
X132 s2d_block_0.bias_tree_noab_n_c3_0.ni en_3v3_b iref iovdd sg13_hv_pmos ad=0.34p pd=2.68u as=0.34p ps=2.68u w=1u l=0.45u
X133 pad Clamp_P_M1_0.gate iovdd iovdd sg13_hv_pmos ad=3.9294p pd=7.84u as=3.1302p ps=14.26u w=6.66u l=0.6u
X134 pad Clamp_N_M1_0.gate iovss iovss sg13_hv_nmos ad=2.596p pd=5.58u as=1.408p ps=5.04u w=4.4u l=0.6u
X135 a_11758_26462# a_14374_26054# iovss rhigh l=12.65u w=0.5u
X136 s2d_block_0.s2d_loads_f_0.dd s2d_block_0.s2d_loads_f_0.vcmfb iovdd iovdd sg13_hv_pmos ad=2.04p pd=12.68u as=2.04p ps=12.68u w=6u l=4u
X137 iovss s2d_block_0.sinks_6x6_s2d_c3_core_0.vbn iovss iovss sg13_hv_nmos ad=0.68p pd=4.68u as=0 ps=0 w=2u l=6u
X138 iovdd iovdd iovdd iovdd sg13_hv_pmos ad=1.9p pd=10.38u as=0 ps=0 w=10u l=1u
X139 s2d_block_0.s2d_loads_f_0.vcmfb s2d_block_0.s2d_casc_p_f_0.vbpc s2d_block_0.s2d_loads_f_0.dd iovdd sg13_hv_pmos ad=5.1p pd=30.68u as=5.1p ps=30.68u w=15u l=3u
X140 iovdd s2d_block_0.s2d_tails_hi_f_0.vbp s2d_block_0.s2d_tails_hi_f_0.vbp iovdd sg13_hv_pmos ad=1.7p pd=10.68u as=1.7p ps=10.68u w=5u l=6u
X141 s2d_block_0.bias_tree_noab_n_c3_0.ni s2d_block_0.bias_tree_noab_n_c3_0.ni iovss iovss sg13_hv_nmos ad=2.04p pd=12.68u as=2.04p ps=12.68u w=6u l=6u
X142 iovdd Clamp_P_M1_0.gate pad iovdd sg13_hv_pmos ad=2.1312p pd=7.3u as=3.9294p ps=7.84u w=6.66u l=0.6u
X143 s2d_block_0.s2d_tails_lo_f_0.sa_M2 s2d_block_0.s2d_tails_hi_f_0.vbp iovdd iovdd sg13_hv_pmos ad=1.7p pd=10.68u as=1.7p ps=10.68u w=5u l=6u
X144 outn s2d_block_0.s2d_casc_n_f_0.vbnc s2d_block_0.s2d_casc_n_f_0.y iovss sg13_hv_nmos ad=5.1p pd=30.68u as=5.1p ps=30.68u w=15u l=3u
X145 iovdd Clamp_P_M1_0.gate pad iovdd sg13_hv_pmos ad=2.1312p pd=7.3u as=3.9294p ps=7.84u w=6.66u l=0.6u
X146 iovdd Clamp_P_M1_0.gate pad iovdd sg13_hv_pmos ad=2.1312p pd=7.3u as=3.9294p ps=7.84u w=6.66u l=0.6u
X147 s2d_block_0.s2d_casc_n_f_0.yc s2d_block_0.sinks_6x6_s2d_c3_core_0.vbn iovss iovss sg13_hv_nmos ad=2.04p pd=12.68u as=2.04p ps=12.68u w=6u l=6u
X148 s2d_block_0.s2d_casc_n_f_0.xc vcm s2d_block_0.s2d_tails_hi_f_0.sb_M2 s2d_block_0.s2d_tails_hi_f_0.sb_M2 sg13_hv_pmos ad=1.9p pd=10.38u as=3.4p ps=20.68u w=10u l=1u
X149 s2d_block_0.s2d_casc_n_f_0.y outn s2d_block_0.s2d_tails_lo_f_0.sa_F2 s2d_block_0.s2d_tails_lo_f_0.sa_F2 sg13_hv_pmos ad=1.9p pd=10.38u as=3.4p ps=20.68u w=10u l=1u
X150 s2d_block_0.s2d_tails_hi_f_0.sa_M1 outp s2d_block_0.s2d_casc_n_f_0.yc s2d_block_0.s2d_tails_hi_f_0.sa_M1 sg13_hv_pmos ad=3.4p pd=20.68u as=1.9p ps=10.38u w=10u l=1u
X151 pad Clamp_P_M1_0.gate iovdd iovdd sg13_hv_pmos ad=3.9294p pd=7.84u as=2.1312p ps=7.3u w=6.66u l=0.6u
X152 s2d_block_0.s2d_tails_lo_f_0.sa_F2 a_14374_25918# iovss rhigh l=12.65u w=0.5u
X153 s2d_block_0.sinks_6x6_s2d_c3_core_0.vbn s2d_block_0.sinks_6x6_s2d_c3_core_0.vbn iovss iovss sg13_hv_nmos ad=2.04p pd=12.68u as=2.04p ps=12.68u w=6u l=6u
X154 iovdd Clamp_P_M1_0.gate pad iovdd sg13_hv_pmos ad=2.1312p pd=7.3u as=3.9294p ps=7.84u w=6.66u l=0.6u
X155 iovss s2d_block_0.s2d_casc_n_f_0.vbnc iovss iovss sg13_hv_nmos ad=0.68p pd=4.68u as=0 ps=0 w=2u l=3u
X156 s2d_block_0.s2d_tails_lo_f_0.sa_F2 s2d_block_0.s2d_tails_hi_f_0.vbp iovdd iovdd sg13_hv_pmos ad=1.7p pd=10.68u as=1.7p ps=10.68u w=5u l=6u
X157 iovss Clamp_N_M1_0.gate pad iovss sg13_hv_nmos ad=1.408p pd=5.04u as=2.596p ps=5.58u w=4.4u l=0.6u
X158 s2d_block_0.s2d_tails_lo_f_0.sb_A2 vref s2d_block_0.s2d_casc_n_f_0.x s2d_block_0.s2d_tails_lo_f_0.sb_A2 sg13_hv_pmos ad=3.4p pd=20.68u as=1.9p ps=10.38u w=10u l=1u
X159 pad Clamp_N_M1_0.gate iovss iovss sg13_hv_nmos ad=2.596p pd=5.58u as=1.408p ps=5.04u w=4.4u l=0.6u
X160 a_11758_26462# a_14374_27686# iovss rhigh l=12.65u w=0.5u
X161 s2d_block_0.s2d_casc_n_f_0.x s2d_block_0.sinks_6x6_s2d_c3_core_0.vbn iovss iovss sg13_hv_nmos ad=2.04p pd=12.68u as=2.04p ps=12.68u w=6u l=6u
X162 iovdd Clamp_P_M1_0.gate pad iovdd sg13_hv_pmos ad=2.1312p pd=7.3u as=3.9294p ps=7.84u w=6.66u l=0.6u
X163 s2d_block_0.s2d_tails_hi_f_0.vbp s2d_block_0.bias_tree_noab_n_c3_0.ni iovss iovss sg13_hv_nmos ad=2.04p pd=12.68u as=2.04p ps=12.68u w=6u l=6u
X164 pad Clamp_P_M1_0.gate iovdd iovdd sg13_hv_pmos ad=3.9294p pd=7.84u as=3.1302p ps=14.26u w=6.66u l=0.6u
X165 iovdd iovdd iovdd iovdd sg13_hv_pmos ad=3.4p pd=20.68u as=0 ps=0 w=10u l=1u
X166 iovss s2d_block_0.sinks_6x6_s2d_c3_core_0.vbn s2d_block_0.s2d_casc_n_f_0.xc iovss sg13_hv_nmos ad=2.04p pd=12.68u as=2.04p ps=12.68u w=6u l=6u
X167 Clamp_N_M1_0.gate iovss iovss rppd l=3.54u w=0.5u
X168 iovdd Clamp_P_M1_0.gate pad iovdd sg13_hv_pmos ad=2.1312p pd=7.3u as=3.9294p ps=7.84u w=6.66u l=0.6u
X169 iovss s2d_block_0.s2d_casc_n_f_0.vbnc iovss iovss sg13_hv_nmos ad=0.68p pd=4.68u as=0 ps=0 w=2u l=3u
X170 iovdd iovdd iovdd iovdd sg13_hv_pmos ad=1.9p pd=10.38u as=0 ps=0 w=10u l=1u
X171 s2d_block_0.s2d_tails_lo_f_0.sb_A1 s2d_block_0.s2d_tails_hi_f_0.vbp iovdd iovdd sg13_hv_pmos ad=1.7p pd=10.68u as=1.7p ps=10.68u w=5u l=6u
X172 pad Clamp_P_M1_0.gate iovdd iovdd sg13_hv_pmos ad=3.9294p pd=7.84u as=2.1312p ps=7.3u w=6.66u l=0.6u
X173 a_11758_26734# a_14374_27414# iovss rhigh l=12.65u w=0.5u
X174 pad Clamp_P_M1_0.gate iovdd iovdd sg13_hv_pmos ad=3.9294p pd=7.84u as=2.1312p ps=7.3u w=6.66u l=0.6u
X175 iovdd Clamp_P_M1_0.gate pad iovdd sg13_hv_pmos ad=2.1312p pd=7.3u as=3.9294p ps=7.84u w=6.66u l=0.6u
X176 iovdd Clamp_P_M1_0.gate pad iovdd sg13_hv_pmos ad=3.1302p pd=14.26u as=3.9294p ps=7.84u w=6.66u l=0.6u
X177 outn s2d_block_0.s2d_casc_p_f_0.vbpc s2d_block_0.s2d_loads_f_0.ln iovdd sg13_hv_pmos ad=5.1p pd=30.68u as=5.1p ps=30.68u w=15u l=3u
X178 s2d_block_0.s2d_casc_n_f_0.y pad s2d_block_0.s2d_tails_hi_f_0.sa_A2 s2d_block_0.s2d_tails_hi_f_0.sa_A2 sg13_hv_pmos ad=1.9p pd=10.38u as=3.4p ps=20.68u w=10u l=1u
X179 pad Clamp_P_M1_0.gate iovdd iovdd sg13_hv_pmos ad=3.9294p pd=7.84u as=2.1312p ps=7.3u w=6.66u l=0.6u
X180 iovss Clamp_N_M1_0.gate pad iovss sg13_hv_nmos ad=1.408p pd=5.04u as=2.596p ps=5.58u w=4.4u l=0.6u
X181 s2d_block_0.s2d_casc_n_f_0.yc outn s2d_block_0.s2d_tails_lo_f_0.sa_M2 s2d_block_0.s2d_tails_lo_f_0.sa_M2 sg13_hv_pmos ad=1.9p pd=10.38u as=3.4p ps=20.68u w=10u l=1u
X182 s2d_block_0.s2d_tails_lo_f_0.sb_A2 s2d_block_0.s2d_tails_hi_f_0.vbp iovdd iovdd sg13_hv_pmos ad=1.7p pd=10.68u as=1.7p ps=10.68u w=5u l=6u
X183 iovss s2d_block_0.sinks_6x6_s2d_c3_core_0.vbn s2d_block_0.s2d_casc_n_f_0.x iovss sg13_hv_nmos ad=2.04p pd=12.68u as=2.04p ps=12.68u w=6u l=6u
X184 iovss Clamp_N_M1_0.gate pad iovss sg13_hv_nmos ad=1.408p pd=5.04u as=2.596p ps=5.58u w=4.4u l=0.6u
X185 s2d_block_0.s2d_loads_f_0.lp s2d_block_0.s2d_loads_f_0.vcmfb iovdd iovdd sg13_hv_pmos ad=2.04p pd=12.68u as=2.04p ps=12.68u w=6u l=4u
X186 s2d_block_0.sinks_6x6_s2d_c3_core_0.vbn s2d_block_0.s2d_tails_hi_f_0.vbp iovdd iovdd sg13_hv_pmos ad=1.7p pd=10.68u as=1.7p ps=10.68u w=5u l=6u
X187 s2d_block_0.s2d_tails_lo_f_0.sb_M1 vcm s2d_block_0.s2d_casc_n_f_0.xc s2d_block_0.s2d_tails_lo_f_0.sb_M1 sg13_hv_pmos ad=3.4p pd=20.68u as=1.9p ps=10.38u w=10u l=1u
X188 outp s2d_block_0.s2d_casc_n_f_0.vbnc s2d_block_0.s2d_casc_n_f_0.x iovss sg13_hv_nmos ad=5.1p pd=30.68u as=5.1p ps=30.68u w=15u l=3u
X189 s2d_block_0.s2d_tails_hi_f_0.sa_M1 a_14374_26054# iovss rhigh l=12.65u w=0.5u
X190 iovss Clamp_N_M1_0.gate pad iovss sg13_hv_nmos ad=1.408p pd=5.04u as=2.596p ps=5.58u w=4.4u l=0.6u
X191 iovss s2d_block_0.s2d_casc_n_f_0.vbnc iovss iovss sg13_hv_nmos ad=0.68p pd=4.68u as=0 ps=0 w=2u l=3u
X192 iovss s2d_block_0.sinks_6x6_s2d_c3_core_0.vbn s2d_block_0.s2d_casc_n_f_0.x iovss sg13_hv_nmos ad=2.04p pd=12.68u as=2.04p ps=12.68u w=6u l=6u
X193 iovss s2d_block_0.sinks_6x6_s2d_c3_core_0.vbn iovss iovss sg13_hv_nmos ad=0.68p pd=4.68u as=0 ps=0 w=2u l=6u
X194 iovdd s2d_block_0.s2d_loads_f_0.vcmfb iovdd iovdd sg13_hv_pmos ad=0.34p pd=2.68u as=0 ps=0 w=1u l=4u
X195 outn en_3v3_b vcm iovss sg13_hv_nmos ad=0.34p pd=2.68u as=0.19p ps=1.38u w=1u l=0.45u
X196 s2d_block_0.s2d_tails_hi_f_0.sb_F2 vcm s2d_block_0.s2d_casc_n_f_0.x s2d_block_0.s2d_tails_hi_f_0.sb_F2 sg13_hv_pmos ad=3.4p pd=20.68u as=1.9p ps=10.38u w=10u l=1u
X197 iovss s2d_block_0.sinks_6x6_s2d_c3_core_0.vbn iovss iovss sg13_hv_nmos ad=0.68p pd=4.68u as=0 ps=0 w=2u l=6u
X198 s2d_block_0.s2d_casc_n_f_0.x s2d_block_0.sinks_6x6_s2d_c3_core_0.vbn iovss iovss sg13_hv_nmos ad=2.04p pd=12.68u as=2.04p ps=12.68u w=6u l=6u
X199 s2d_block_0.s2d_casc_n_f_0.y pad s2d_block_0.s2d_tails_hi_f_0.sa_A1 s2d_block_0.s2d_tails_hi_f_0.sa_A1 sg13_hv_pmos ad=1.9p pd=10.38u as=3.4p ps=20.68u w=10u l=1u
X200 s2d_block_0.s2d_tails_lo_f_0.sb_A1 a_14374_27142# iovss rhigh l=12.65u w=0.5u
X201 iovdd s2d_block_0.s2d_loads_f_0.vcmfb s2d_block_0.s2d_loads_f_0.dd iovdd sg13_hv_pmos ad=2.04p pd=12.68u as=2.04p ps=12.68u w=6u l=4u
X202 iovdd iovdd iovdd iovdd sg13_hv_pmos ad=1.9p pd=10.38u as=0 ps=0 w=10u l=1u
X203 iovdd Clamp_P_M1_0.gate pad iovdd sg13_hv_pmos ad=2.1312p pd=7.3u as=3.9294p ps=7.84u w=6.66u l=0.6u
X204 iovdd s2d_block_0.s2d_loads_f_0.vcmfb iovdd iovdd sg13_hv_pmos ad=0.34p pd=2.68u as=0 ps=0 w=1u l=4u
X205 a_11758_26598# a_14374_27550# iovss rhigh l=12.65u w=0.5u
X206 s2d_block_0.s2d_casc_n_f_0.xc s2d_block_0.s2d_casc_n_f_0.vbnc s2d_block_0.s2d_loads_f_0.vcmfb iovss sg13_hv_nmos ad=5.1p pd=30.68u as=5.1p ps=30.68u w=15u l=3u
X207 pad Clamp_P_M1_0.gate iovdd iovdd sg13_hv_pmos ad=3.9294p pd=7.84u as=2.1312p ps=7.3u w=6.66u l=0.6u
X208 s2d_block_0.s2d_tails_lo_f_0.sa_F1 s2d_block_0.s2d_tails_hi_f_0.vbp iovdd iovdd sg13_hv_pmos ad=1.7p pd=10.68u as=1.7p ps=10.68u w=5u l=6u
X209 iovdd Clamp_P_M1_0.gate pad iovdd sg13_hv_pmos ad=3.1302p pd=14.26u as=3.9294p ps=7.84u w=6.66u l=0.6u
X210 outp s2d_block_0.s2d_casc_p_f_0.vbpc s2d_block_0.s2d_loads_f_0.lp iovdd sg13_hv_pmos ad=5.1p pd=30.68u as=5.1p ps=30.68u w=15u l=3u
X211 iovdd s2d_block_0.s2d_tails_hi_f_0.vbp iovdd iovdd sg13_hv_pmos ad=0.68p pd=4.68u as=0 ps=0 w=2u l=6u
X212 a_11758_26870# a_14374_27278# iovss rhigh l=12.65u w=0.5u
X213 s2d_block_0.s2d_casc_n_f_0.vbnc s2d_block_0.s2d_casc_n_f_0.vbnc iovss iovss sg13_hv_nmos ad=0.34p pd=2.68u as=0.34p ps=2.68u w=1u l=8u
X214 pad Clamp_P_M1_0.gate iovdd iovdd sg13_hv_pmos ad=3.9294p pd=7.84u as=2.1312p ps=7.3u w=6.66u l=0.6u
X215 iovss s2d_block_0.sinks_6x6_s2d_c3_core_0.vbn s2d_block_0.s2d_casc_n_f_0.yc iovss sg13_hv_nmos ad=2.04p pd=12.68u as=2.04p ps=12.68u w=6u l=6u
X216 iovss Clamp_N_M1_0.gate pad iovss sg13_hv_nmos ad=1.408p pd=5.04u as=2.596p ps=5.58u w=4.4u l=0.6u
X217 s2d_block_0.s2d_tails_lo_f_0.sa_M2 a_14374_26190# iovss rhigh l=12.65u w=0.5u
X218 s2d_block_0.s2d_loads_f_0.vcmfb s2d_block_0.s2d_casc_n_f_0.vbnc s2d_block_0.s2d_casc_n_f_0.xc iovss sg13_hv_nmos ad=5.1p pd=30.68u as=5.1p ps=30.68u w=15u l=3u
X219 iovss pad dantenna l=1.26u w=27.78u
X220 s2d_block_0.s2d_loads_f_0.dd s2d_block_0.s2d_casc_p_f_0.vbpc s2d_block_0.s2d_loads_f_0.vcmfb iovdd sg13_hv_pmos ad=5.1p pd=30.68u as=5.1p ps=30.68u w=15u l=3u
X221 iovdd iovdd iovdd iovdd sg13_hv_pmos ad=3.4p pd=20.68u as=0 ps=0 w=10u l=1u
X222 s2d_block_0.s2d_casc_n_f_0.x vref s2d_block_0.s2d_tails_lo_f_0.sb_A1 s2d_block_0.s2d_tails_lo_f_0.sb_A1 sg13_hv_pmos ad=1.9p pd=10.38u as=3.4p ps=20.68u w=10u l=1u
X223 iovss Clamp_N_M1_0.gate pad iovss sg13_hv_nmos ad=1.408p pd=5.04u as=2.596p ps=5.58u w=4.4u l=0.6u
X224 iovss s2d_block_0.sinks_6x6_s2d_c3_core_0.vbn iovss iovss sg13_hv_nmos ad=0.68p pd=4.68u as=0 ps=0 w=2u l=6u
C0 s2d_block_0.s2d_tails_hi_f_0.sb_F1 s2d_block_0.s2d_tails_hi_f_0.vbp 0.2455f
C1 s2d_block_0.s2d_tails_lo_f_0.sb_M1 s2d_block_0.s2d_tails_lo_f_0.sa_F2 0.05732f
C2 s2d_block_0.s2d_casc_n_f_0.vbnc s2d_block_0.s2d_casc_n_f_0.yc 1.55613f
C3 outn s2d_block_0.s2d_casc_n_f_0.x 0.03219f
C4 a_11844_26190# s2d_block_0.s2d_tails_lo_f_0.sa_M2 0.0194f
C5 s2d_block_0.s2d_tails_hi_f_0.sa_M1 s2d_block_0.s2d_tails_hi_f_0.vbp 0.41199f
C6 s2d_block_0.s2d_tails_lo_f_0.sb_A2 s2d_block_0.s2d_tails_hi_f_0.sb_M2 1.43713f
C7 a_14374_27686# a_14374_27550# 0.55763f
C8 iovdd s2d_block_0.s2d_casc_n_f_0.xc 11.114f
C9 s2d_block_0.s2d_tails_hi_f_0.sb_F2 s2d_block_0.s2d_casc_n_f_0.xc 0.03286f
C10 a_14374_27414# a_11844_28366# 0.02713f
C11 s2d_block_0.s2d_tails_hi_f_0.sb_F1 outn 2.08525f
C12 pad s2d_block_0.s2d_tails_lo_f_0.sb_A1 0.02754f
C13 s2d_block_0.s2d_tails_hi_f_0.sa_A1 s2d_block_0.s2d_tails_lo_f_0.sa_F2 0.04602f
C14 en_3v3_b en_3v3 0.28127f
C15 s2d_block_0.s2d_casc_p_f_0.vbpc s2d_block_0.s2d_tails_hi_f_0.sb_M2 0.02427f
C16 outn s2d_block_0.s2d_tails_hi_f_0.sa_M1 0.0232f
C17 outp s2d_block_0.s2d_tails_lo_f_0.sb_A2 0.86322f
C18 vref s2d_block_0.s2d_casc_n_f_0.y 1.67038f
C19 a_14374_26190# a_14374_26054# 0.33426f
C20 a_11844_25782# a_14374_25782# 0.02713f
C21 outp s2d_block_0.s2d_casc_p_f_0.vbpc 1.4238f
C22 iref s2d_block_0.s2d_casc_p_f_0.vbpc 0.23455f
C23 a_14374_25918# a_11844_26598# 0.02719f
C24 s2d_block_0.s2d_tails_hi_f_0.sb_F2 a_11844_25374# 0.02389f
C25 s2d_block_0.s2d_tails_lo_f_0.sb_A1 s2d_block_0.s2d_tails_lo_f_0.sa_F2 0.21993f
C26 s2d_block_0.s2d_casc_n_f_0.xc s2d_block_0.s2d_tails_lo_f_0.sb_M1 1.17345f
C27 s2d_block_0.s2d_tails_lo_f_0.sa_M2 s2d_block_0.s2d_casc_n_f_0.yc 1.21104f
C28 a_11844_26734# a_11844_26870# 0.63642f
C29 s2d_block_0.s2d_tails_hi_f_0.sb_F2 a_11844_27278# 0.02318f
C30 vdd s2d_block_0.s2d_tails_hi_f_0.vbp 3.45659f
C31 s2d_block_0.s2d_tails_hi_f_0.sb_F1 a_11844_28638# 0.01626f
C32 vref s2d_block_0.s2d_casc_n_f_0.yc 0.03751f
C33 s2d_block_0.s2d_casc_n_f_0.y s2d_block_0.s2d_tails_hi_f_0.sa_A2 1.08046f
C34 a_11844_28638# s2d_block_0.s2d_tails_hi_f_0.sa_M1 0.02158f
C35 s2d_block_0.sinks_6x6_s2d_c3_core_0.vbn s2d_block_0.s2d_tails_hi_f_0.vbp 0.26763f
C36 s2d_block_0.s2d_casc_p_f_0.vbpc s2d_block_0.s2d_tails_lo_f_0.sb_A2 0.04675f
C37 a_14374_25782# s2d_block_0.sinks_6x6_s2d_c3_core_0.vbn 0.01214f
C38 a_11844_27142# a_14374_27142# 0.02707f
C39 a_11844_27278# a_14374_27278# 0.0271f
C40 pad vcm 0.3255f
C41 vdd outn 4.12076f
C42 s2d_block_0.s2d_loads_f_0.dd s2d_block_0.s2d_casc_n_f_0.xc 0.55573f
C43 s2d_block_0.s2d_tails_hi_f_0.sb_F2 iovdd 7.01741f
C44 s2d_block_0.s2d_tails_lo_f_0.sa_F1 s2d_block_0.s2d_casc_n_f_0.y 1.19633f
C45 a_11844_25374# s2d_block_0.s2d_tails_lo_f_0.sb_M1 0.01449f
C46 en_3v3 vcm 0.11407f
C47 outn s2d_block_0.sinks_6x6_s2d_c3_core_0.vbn 0.0235f
C48 a_11758_26462# s2d_block_0.s2d_tails_lo_f_0.sb_M1 0.04781f
C49 a_11844_28366# a_11844_28502# 0.63642f
C50 s2d_block_0.s2d_casc_n_f_0.x s2d_block_0.s2d_casc_n_f_0.y 22.009f
C51 a_11844_26190# s2d_block_0.s2d_tails_hi_f_0.sa_M1 0.03973f
C52 s2d_block_0.s2d_tails_lo_f_0.sa_F1 s2d_block_0.s2d_casc_n_f_0.yc 0.02338f
C53 a_11844_27822# a_11844_27958# 0.63642f
C54 s2d_block_0.s2d_tails_lo_f_0.sb_A1 s2d_block_0.s2d_casc_n_f_0.xc 0.04313f
C55 s2d_block_0.s2d_tails_hi_f_0.sa_A1 a_11844_25374# 0.01837f
C56 vdd s2d_block_0.bias_tree_noab_n_c3_0.ni 1.76708f
C57 s2d_block_0.s2d_tails_hi_f_0.sb_F1 s2d_block_0.s2d_casc_n_f_0.y 0.22739f
C58 s2d_block_0.s2d_tails_hi_f_0.vbp s2d_block_0.s2d_tails_hi_f_0.sb_M2 0.57373f
C59 s2d_block_0.s2d_casc_n_f_0.x s2d_block_0.s2d_casc_n_f_0.yc 5.29006f
C60 a_14374_25782# a_14374_25646# 1.00966f
C61 iovdd s2d_block_0.s2d_tails_lo_f_0.sb_M1 1.22552f
C62 Clamp_N_M1_0.gate s2d_block_0.s2d_casc_n_f_0.vbnc 0.01177f
C63 a_14374_25510# a_11844_27006# 0.02707f
C64 s2d_block_0.s2d_tails_hi_f_0.sb_F2 s2d_block_0.s2d_tails_lo_f_0.sb_M1 0.80863f
C65 a_11758_27006# a_11758_26870# 0.33426f
C66 s2d_block_0.sinks_6x6_s2d_c3_core_0.vbn s2d_block_0.bias_tree_noab_n_c3_0.ni 0.01864f
C67 s2d_block_0.s2d_tails_hi_f_0.sb_F2 a_11844_25646# 0.02158f
C68 s2d_block_0.s2d_tails_hi_f_0.sb_F1 s2d_block_0.s2d_casc_n_f_0.yc 0.08747f
C69 vdd a_11844_27550# 0.01806f
C70 a_11844_28774# a_11844_28638# 0.63642f
C71 outn s2d_block_0.s2d_tails_hi_f_0.sb_M2 0.0267f
C72 a_11844_26054# a_11844_25918# 0.63642f
C73 s2d_block_0.s2d_tails_hi_f_0.sa_A1 iovdd 1.52034f
C74 outp s2d_block_0.s2d_tails_hi_f_0.vbp 0.19183f
C75 s2d_block_0.s2d_tails_hi_f_0.sb_F2 s2d_block_0.s2d_tails_hi_f_0.sa_A1 0.41711f
C76 iref s2d_block_0.s2d_tails_hi_f_0.vbp 0.12001f
C77 s2d_block_0.s2d_casc_n_f_0.yc s2d_block_0.s2d_tails_hi_f_0.sa_M1 1.0972f
C78 s2d_block_0.s2d_tails_hi_f_0.sb_F2 a_11844_26734# 0.02221f
C79 a_11758_26326# s2d_block_0.s2d_tails_lo_f_0.sa_M2 0.26248f
C80 a_11758_26462# s2d_block_0.s2d_tails_lo_f_0.sb_A1 0.02995f
C81 iovdd s2d_block_0.s2d_loads_f_0.dd 10.6422f
C82 outp outn 6.05194f
C83 vcm s2d_block_0.s2d_casc_n_f_0.xc 1.31473f
C84 s2d_block_0.s2d_loads_f_0.ln s2d_block_0.sinks_6x6_s2d_c3_core_0.vbn 0.01344f
C85 iovdd en_3v3_b 0.41196f
C86 s2d_block_0.s2d_loads_f_0.lp s2d_block_0.s2d_casc_n_f_0.xc 0.26366f
C87 s2d_block_0.s2d_tails_lo_f_0.sb_A2 s2d_block_0.s2d_tails_hi_f_0.vbp 0.35797f
C88 iovdd s2d_block_0.s2d_tails_lo_f_0.sb_A1 4.00867f
C89 s2d_block_0.s2d_tails_hi_f_0.sb_F2 s2d_block_0.s2d_tails_lo_f_0.sb_A1 0.0325f
C90 pad s2d_block_0.s2d_tails_lo_f_0.sa_M2 0.07823f
C91 vdd s2d_block_0.s2d_casc_n_f_0.y 0.06408f
C92 s2d_block_0.s2d_tails_hi_f_0.sa_A1 s2d_block_0.s2d_tails_lo_f_0.sb_M1 1.47019f
C93 s2d_block_0.s2d_casc_p_f_0.vbpc s2d_block_0.s2d_tails_hi_f_0.vbp 3.8698f
C94 s2d_block_0.s2d_tails_hi_f_0.sa_A1 a_11844_25646# 0.01445f
C95 outn s2d_block_0.s2d_tails_lo_f_0.sb_A2 0.04441f
C96 a_11844_27142# a_11844_27278# 0.63642f
C97 a_11844_27958# s2d_block_0.s2d_tails_hi_f_0.sb_M2 0.01935f
C98 vref pad 0.12553f
C99 a_11844_27414# a_11758_26734# 0.01944f
C100 s2d_block_0.s2d_loads_f_0.vcmfb s2d_block_0.s2d_casc_n_f_0.xc 1.61182f
C101 s2d_block_0.s2d_casc_n_f_0.y s2d_block_0.sinks_6x6_s2d_c3_core_0.vbn 11.4419f
C102 a_11758_26598# a_11758_26462# 1.00966f
C103 iref s2d_block_0.bias_tree_noab_n_c3_0.ni 0.20242f
C104 vdd s2d_block_0.s2d_casc_n_f_0.yc 0.02686f
C105 outn s2d_block_0.s2d_casc_p_f_0.vbpc 7.61108f
C106 a_11844_26054# a_14374_26054# 0.02728f
C107 a_11844_25918# s2d_block_0.s2d_tails_hi_f_0.sa_A2 0.0208f
C108 s2d_block_0.sinks_6x6_s2d_c3_core_0.vbn s2d_block_0.s2d_casc_n_f_0.yc 5.71059f
C109 s2d_block_0.s2d_tails_lo_f_0.sb_A1 s2d_block_0.s2d_tails_lo_f_0.sb_M1 0.45675f
C110 s2d_block_0.s2d_casc_n_f_0.xc s2d_block_0.s2d_casc_n_f_0.vbnc 5.59245f
C111 s2d_block_0.s2d_tails_lo_f_0.sa_M2 s2d_block_0.s2d_tails_lo_f_0.sa_F2 0.93094f
C112 s2d_block_0.s2d_tails_hi_f_0.sb_F2 a_11844_27142# 0.02279f
C113 a_14374_27414# s2d_block_0.sinks_6x6_s2d_c3_core_0.vbn 0.0119f
C114 s2d_block_0.s2d_tails_hi_f_0.sb_F1 a_11844_28502# 0.04221f
C115 pad s2d_block_0.s2d_tails_hi_f_0.sa_A2 2.83313f
C116 vref s2d_block_0.s2d_tails_lo_f_0.sa_F2 0.07479f
C117 vdd a_11844_27006# 0.01077f
C118 outp s2d_block_0.s2d_loads_f_0.ln 0.02987f
C119 pad s2d_block_0.s2d_tails_lo_f_0.sa_F1 0.06589f
C120 s2d_block_0.s2d_tails_hi_f_0.sa_A1 s2d_block_0.s2d_tails_lo_f_0.sb_A1 0.04713f
C121 iovdd vcm 2.7753f
C122 s2d_block_0.s2d_tails_hi_f_0.sb_F2 vcm 2.83453f
C123 a_11844_28502# s2d_block_0.s2d_tails_hi_f_0.sa_M1 0.02158f
C124 s2d_block_0.s2d_casc_p_f_0.vbpc s2d_block_0.bias_tree_noab_n_c3_0.ni 0.54432f
C125 iovdd s2d_block_0.s2d_loads_f_0.lp 9.55312f
C126 a_14374_25510# a_14374_27142# 0.27561f
C127 pad Clamp_P_M1_0.gate 19.5174f
C128 pad s2d_block_0.s2d_casc_n_f_0.x 0.07862f
C129 s2d_block_0.s2d_tails_hi_f_0.sb_F1 a_11844_25918# 0.0102f
C130 s2d_block_0.s2d_tails_lo_f_0.sa_F2 s2d_block_0.s2d_tails_hi_f_0.sa_A2 0.02005f
C131 s2d_block_0.s2d_casc_n_f_0.yc s2d_block_0.s2d_tails_hi_f_0.sb_M2 0.28733f
C132 a_11758_26598# s2d_block_0.s2d_tails_lo_f_0.sb_M1 0.04807f
C133 outp s2d_block_0.s2d_casc_n_f_0.y 0.03405f
C134 s2d_block_0.s2d_tails_hi_f_0.sb_F1 pad 0.25447f
C135 a_11844_25918# s2d_block_0.s2d_tails_hi_f_0.sa_M1 0.03426f
C136 iovdd s2d_block_0.s2d_loads_f_0.vcmfb 46.5827f
C137 a_11844_27550# a_11844_27686# 0.63642f
C138 s2d_block_0.s2d_tails_lo_f_0.sa_M2 s2d_block_0.s2d_casc_n_f_0.xc 0.23201f
C139 s2d_block_0.s2d_tails_lo_f_0.sa_F1 s2d_block_0.s2d_tails_lo_f_0.sa_F2 1.9391f
C140 a_11844_27822# a_11758_26326# 0.01932f
C141 a_11844_27958# a_11844_28094# 0.63642f
C142 s2d_block_0.s2d_loads_f_0.ln s2d_block_0.s2d_casc_p_f_0.vbpc 1.72075f
C143 vcm s2d_block_0.s2d_tails_lo_f_0.sb_M1 2.76648f
C144 pad s2d_block_0.s2d_tails_hi_f_0.sa_M1 0.07327f
C145 vref s2d_block_0.s2d_casc_n_f_0.xc 0.03603f
C146 outp s2d_block_0.s2d_casc_n_f_0.yc 0.85572f
C147 s2d_block_0.s2d_casc_n_f_0.x s2d_block_0.s2d_tails_lo_f_0.sa_F2 0.15244f
C148 iovdd s2d_block_0.s2d_casc_n_f_0.vbnc 22.6805f
C149 s2d_block_0.s2d_casc_n_f_0.y s2d_block_0.s2d_tails_lo_f_0.sb_A2 0.34721f
C150 s2d_block_0.s2d_tails_hi_f_0.sb_F2 a_11844_28366# 0.01762f
C151 s2d_block_0.s2d_tails_hi_f_0.sb_F1 s2d_block_0.s2d_tails_lo_f_0.sa_F2 3.20673f
C152 vdd a_11844_27414# 0.01616f
C153 s2d_block_0.s2d_tails_hi_f_0.sa_A1 vcm 0.02624f
C154 vdd a_11758_26326# 0.01425f
C155 outn s2d_block_0.s2d_tails_hi_f_0.vbp 0.35916f
C156 a_11844_25782# a_11844_25918# 0.63642f
C157 a_11844_26190# a_11844_26326# 0.63642f
C158 s2d_block_0.s2d_loads_f_0.dd s2d_block_0.s2d_loads_f_0.lp 3.89965f
C159 s2d_block_0.s2d_tails_lo_f_0.sa_F2 s2d_block_0.s2d_tails_hi_f_0.sa_M1 0.29686f
C160 s2d_block_0.s2d_casc_n_f_0.yc s2d_block_0.s2d_tails_lo_f_0.sb_A2 0.0238f
C161 s2d_block_0.s2d_tails_hi_f_0.sb_F2 a_11844_26054# 0.02158f
C162 s2d_block_0.s2d_tails_hi_f_0.sb_F2 a_11844_26598# 0.02196f
C163 a_11758_26598# s2d_block_0.s2d_tails_lo_f_0.sb_A1 0.01794f
C164 en_3v3_b vcm 0.50727f
C165 s2d_block_0.s2d_tails_lo_f_0.sa_F1 s2d_block_0.s2d_casc_n_f_0.xc 0.04682f
C166 s2d_block_0.s2d_casc_p_f_0.vbpc s2d_block_0.s2d_casc_n_f_0.yc 0.05993f
C167 pad vdd 0.09288f
C168 s2d_block_0.s2d_loads_f_0.dd s2d_block_0.s2d_loads_f_0.vcmfb 1.40683f
C169 s2d_block_0.bias_tree_noab_n_c3_0.ni s2d_block_0.s2d_tails_hi_f_0.vbp 0.46959f
C170 s2d_block_0.s2d_casc_n_f_0.x s2d_block_0.s2d_casc_n_f_0.xc 0.32431f
C171 iovdd s2d_block_0.s2d_tails_lo_f_0.sa_M2 1.97442f
C172 a_14374_27822# a_14374_27686# 0.33426f
C173 Clamp_N_M1_0.gate s2d_block_0.sinks_6x6_s2d_c3_core_0.vbn 0.02015f
C174 s2d_block_0.s2d_tails_hi_f_0.sb_F2 s2d_block_0.s2d_tails_lo_f_0.sa_M2 0.36456f
C175 vdd en_3v3 1.37224f
C176 a_14374_27550# a_11844_28230# 0.02719f
C177 pad s2d_block_0.sinks_6x6_s2d_c3_core_0.vbn 0.07772f
C178 vref iovdd 0.92461f
C179 s2d_block_0.s2d_tails_hi_f_0.sb_F1 s2d_block_0.s2d_casc_n_f_0.xc 0.02742f
C180 s2d_block_0.s2d_tails_hi_f_0.sb_F2 vref 0.35903f
C181 outn s2d_block_0.bias_tree_noab_n_c3_0.ni 0.0188f
C182 a_11758_26326# s2d_block_0.s2d_tails_hi_f_0.sb_M2 0.26248f
C183 a_14374_27142# s2d_block_0.sinks_6x6_s2d_c3_core_0.vbn 0.02814f
C184 s2d_block_0.s2d_casc_n_f_0.xc s2d_block_0.s2d_tails_hi_f_0.sa_M1 0.21204f
C185 a_14374_26054# a_11844_26462# 0.02728f
C186 a_11844_26598# a_11844_26734# 0.63642f
C187 s2d_block_0.s2d_tails_lo_f_0.sa_M2 s2d_block_0.s2d_tails_lo_f_0.sb_M1 0.59445f
C188 s2d_block_0.sinks_6x6_s2d_c3_core_0.vbn s2d_block_0.s2d_tails_lo_f_0.sa_F2 3.85824f
C189 iovdd s2d_block_0.s2d_tails_hi_f_0.sa_A2 2.76796f
C190 s2d_block_0.s2d_tails_hi_f_0.sb_F2 s2d_block_0.s2d_tails_hi_f_0.sa_A2 0.02442f
C191 s2d_block_0.s2d_tails_hi_f_0.sb_F1 a_11844_25374# 0.01737f
C192 pad s2d_block_0.s2d_tails_hi_f_0.sb_M2 0.06476f
C193 vref s2d_block_0.s2d_tails_lo_f_0.sb_M1 0.07439f
C194 iovdd s2d_block_0.s2d_tails_lo_f_0.sa_F1 1.86555f
C195 a_7760_4632# a_8120_4634# 0.05849f
C196 s2d_block_0.s2d_loads_f_0.ln outn 0.36237f
C197 s2d_block_0.s2d_tails_hi_f_0.sa_A1 s2d_block_0.s2d_tails_lo_f_0.sa_M2 0.05843f
C198 a_11844_28502# s2d_block_0.s2d_tails_lo_f_0.sb_A2 0.02094f
C199 s2d_block_0.s2d_casc_n_f_0.y s2d_block_0.s2d_tails_hi_f_0.vbp 0.07156f
C200 iovdd Clamp_P_M1_0.gate 44.7526f
C201 iovdd s2d_block_0.s2d_casc_n_f_0.x 8.59882f
C202 s2d_block_0.s2d_tails_hi_f_0.sb_F2 s2d_block_0.s2d_casc_n_f_0.x 4.74734f
C203 s2d_block_0.s2d_tails_hi_f_0.sa_A1 vref 0.01051f
C204 pad outp 0.37132f
C205 vdd s2d_block_0.s2d_casc_n_f_0.xc 0.02686f
C206 s2d_block_0.s2d_tails_lo_f_0.sb_M1 s2d_block_0.s2d_tails_hi_f_0.sa_A2 0.04748f
C207 s2d_block_0.s2d_casc_n_f_0.yc s2d_block_0.s2d_tails_hi_f_0.vbp 0.07996f
C208 outn s2d_block_0.s2d_casc_n_f_0.y 0.87704f
C209 s2d_block_0.s2d_loads_f_0.lp s2d_block_0.s2d_loads_f_0.vcmfb 2.06469f
C210 s2d_block_0.s2d_tails_hi_f_0.sb_F2 s2d_block_0.s2d_tails_hi_f_0.sb_F1 6.07872f
C211 s2d_block_0.s2d_tails_hi_f_0.sb_F1 iovdd 3.46185f
C212 a_11758_26734# s2d_block_0.s2d_tails_lo_f_0.sb_M1 0.04819f
C213 outp en_3v3 0.10044f
C214 iref en_3v3 0.26074f
C215 a_11844_25646# s2d_block_0.s2d_tails_hi_f_0.sa_A2 0.08082f
C216 s2d_block_0.sinks_6x6_s2d_c3_core_0.vbn s2d_block_0.s2d_casc_n_f_0.xc 5.64586f
C217 s2d_block_0.s2d_tails_lo_f_0.sa_M2 s2d_block_0.s2d_tails_lo_f_0.sb_A1 0.16443f
C218 s2d_block_0.s2d_tails_lo_f_0.sa_F1 s2d_block_0.s2d_tails_lo_f_0.sb_M1 1.43359f
C219 iovdd s2d_block_0.s2d_tails_hi_f_0.sa_M1 0.68866f
C220 s2d_block_0.s2d_tails_hi_f_0.sb_F2 s2d_block_0.s2d_tails_hi_f_0.sa_M1 0.02465f
C221 outn s2d_block_0.s2d_casc_n_f_0.yc 0.87595f
C222 pad s2d_block_0.s2d_tails_lo_f_0.sb_A2 0.0387f
C223 s2d_block_0.s2d_tails_hi_f_0.sa_A1 s2d_block_0.s2d_tails_hi_f_0.sa_A2 5.41603f
C224 vref s2d_block_0.s2d_tails_lo_f_0.sb_A1 2.83346f
C225 outp s2d_block_0.s2d_tails_lo_f_0.sa_F2 0.01977f
C226 a_14374_25918# a_14374_25782# 0.78325f
C227 a_14374_25646# a_11844_26870# 0.0271f
C228 a_11844_26462# a_11758_26462# 0.01935f
C229 a_11844_26870# a_11758_26870# 0.01953f
C230 a_11844_26326# a_11758_26326# 0.01932f
C231 a_11844_26598# a_11758_26598# 0.01938f
C232 a_11844_26734# a_11758_26734# 0.01944f
C233 a_11844_27006# a_11758_27006# 0.01971f
C234 s2d_block_0.s2d_tails_hi_f_0.sa_A1 s2d_block_0.s2d_tails_lo_f_0.sa_F1 0.0456f
C235 s2d_block_0.s2d_tails_hi_f_0.sb_F2 a_11844_27822# 0.03091f
C236 s2d_block_0.s2d_tails_hi_f_0.sb_F2 a_11844_28230# 0.14087f
C237 s2d_block_0.s2d_tails_hi_f_0.sb_F1 s2d_block_0.s2d_tails_lo_f_0.sb_M1 0.07854f
C238 vdd a_11844_27278# 0.01422f
C239 vdd a_11758_26462# 0.0103f
C240 en_3v3 s2d_block_0.s2d_casc_p_f_0.vbpc 0.15115f
C241 s2d_block_0.s2d_tails_hi_f_0.sa_A1 s2d_block_0.s2d_casc_n_f_0.x 0.30215f
C242 s2d_block_0.sinks_6x6_s2d_c3_core_0.vbn a_11844_25374# 0.03386f
C243 s2d_block_0.s2d_loads_f_0.vcmfb s2d_block_0.s2d_casc_n_f_0.vbnc 4.60294f
C244 s2d_block_0.s2d_tails_hi_f_0.sb_F1 a_11844_25646# 0.01133f
C245 s2d_block_0.s2d_tails_hi_f_0.sb_F2 a_11844_25782# 0.02158f
C246 s2d_block_0.s2d_tails_lo_f_0.sa_F2 s2d_block_0.s2d_tails_lo_f_0.sb_A2 0.0615f
C247 s2d_block_0.s2d_casc_n_f_0.xc s2d_block_0.s2d_tails_hi_f_0.sb_M2 1.1962f
C248 s2d_block_0.s2d_tails_lo_f_0.sb_M1 s2d_block_0.s2d_tails_hi_f_0.sa_M1 0.05443f
C249 s2d_block_0.s2d_tails_lo_f_0.sb_A1 s2d_block_0.s2d_tails_hi_f_0.sa_A2 0.03116f
C250 s2d_block_0.s2d_tails_hi_f_0.sb_F2 a_11844_26462# 0.02158f
C251 a_11758_26734# s2d_block_0.s2d_tails_lo_f_0.sb_A1 0.01181f
C252 s2d_block_0.s2d_tails_hi_f_0.sb_F1 s2d_block_0.s2d_tails_hi_f_0.sa_A1 0.1176f
C253 s2d_block_0.s2d_tails_lo_f_0.sa_F1 s2d_block_0.s2d_tails_lo_f_0.sb_A1 0.84022f
C254 s2d_block_0.s2d_casc_p_f_0.vbpc s2d_block_0.s2d_tails_lo_f_0.sa_F2 0.02327f
C255 s2d_block_0.s2d_tails_hi_f_0.sb_F2 vdd 0.10947f
C256 vdd iovdd 5.97164f
C257 s2d_block_0.s2d_tails_hi_f_0.sa_A1 s2d_block_0.s2d_tails_hi_f_0.sa_M1 0.17778f
C258 outp s2d_block_0.s2d_casc_n_f_0.xc 0.12002f
C259 s2d_block_0.s2d_casc_n_f_0.x s2d_block_0.s2d_tails_lo_f_0.sb_A1 1.08045f
C260 iovdd s2d_block_0.sinks_6x6_s2d_c3_core_0.vbn 14.9428f
C261 s2d_block_0.s2d_tails_hi_f_0.sb_F2 s2d_block_0.sinks_6x6_s2d_c3_core_0.vbn 0.5387f
C262 vref vcm 0.29438f
C263 s2d_block_0.s2d_loads_f_0.ln s2d_block_0.s2d_casc_n_f_0.yc 0.8848f
C264 s2d_block_0.s2d_tails_hi_f_0.sb_F1 s2d_block_0.s2d_tails_lo_f_0.sb_A1 0.52239f
C265 a_11844_27278# a_11758_26870# 0.01953f
C266 a_11844_25782# a_11844_25646# 0.63642f
C267 a_14374_27278# s2d_block_0.sinks_6x6_s2d_c3_core_0.vbn 0.01757f
C268 a_11758_26734# a_11758_26598# 0.78325f
C269 s2d_block_0.s2d_tails_lo_f_0.sb_A1 s2d_block_0.s2d_tails_hi_f_0.sa_M1 0.02784f
C270 vcm s2d_block_0.s2d_tails_hi_f_0.sa_A2 0.02476f
C271 s2d_block_0.sinks_6x6_s2d_c3_core_0.vbn s2d_block_0.s2d_tails_lo_f_0.sb_M1 0.15983f
C272 s2d_block_0.s2d_casc_n_f_0.y s2d_block_0.s2d_casc_n_f_0.yc 1.84321f
C273 s2d_block_0.s2d_casc_n_f_0.xc s2d_block_0.s2d_casc_p_f_0.vbpc 0.11566f
C274 iovdd s2d_block_0.s2d_tails_hi_f_0.sb_M2 0.96539f
C275 vcm s2d_block_0.s2d_tails_lo_f_0.sa_F1 2.76655f
C276 s2d_block_0.s2d_tails_hi_f_0.sb_F2 s2d_block_0.s2d_tails_hi_f_0.sb_M2 0.03285f
C277 s2d_block_0.s2d_tails_hi_f_0.sa_A1 vdd 0.10518f
C278 pad s2d_block_0.s2d_tails_hi_f_0.vbp 0.03551f
C279 s2d_block_0.s2d_tails_hi_f_0.sa_A1 a_11844_28774# 0.01266f
C280 vcm s2d_block_0.s2d_casc_n_f_0.x 0.63386f
C281 en_3v3 s2d_block_0.s2d_tails_hi_f_0.vbp 0.03985f
C282 iovdd a_8120_4634# 0.08872f
C283 s2d_block_0.s2d_loads_f_0.dd s2d_block_0.sinks_6x6_s2d_c3_core_0.vbn 0.01093f
C284 pad outn 0.07331f
C285 vdd en_3v3_b 2.65677f
C286 outp iovdd 12.3886f
C287 s2d_block_0.s2d_tails_hi_f_0.sb_F2 outp 0.06799f
C288 iref iovdd 0.39141f
C289 s2d_block_0.s2d_tails_hi_f_0.sb_F1 vcm 0.24994f
C290 a_11844_28502# a_11844_28638# 0.63642f
C291 en_3v3 outn 2.58957f
C292 s2d_block_0.s2d_tails_lo_f_0.sb_M1 s2d_block_0.s2d_tails_hi_f_0.sb_M2 0.34748f
C293 s2d_block_0.s2d_tails_lo_f_0.sa_F2 s2d_block_0.s2d_tails_hi_f_0.vbp 0.35611f
C294 en_3v3_b s2d_block_0.sinks_6x6_s2d_c3_core_0.vbn 0.79062f
C295 a_11758_26870# s2d_block_0.s2d_tails_lo_f_0.sb_M1 0.0482f
C296 vcm s2d_block_0.s2d_tails_hi_f_0.sa_M1 0.14677f
C297 s2d_block_0.s2d_casc_n_f_0.x s2d_block_0.s2d_loads_f_0.vcmfb 0.25703f
C298 a_11844_27414# a_11844_27550# 0.63642f
C299 a_14374_25646# a_11844_25646# 0.0271f
C300 a_11844_27686# a_11758_26462# 0.01935f
C301 iovdd s2d_block_0.s2d_tails_lo_f_0.sb_A2 1.27584f
C302 s2d_block_0.s2d_tails_hi_f_0.sb_F2 s2d_block_0.s2d_tails_lo_f_0.sb_A2 2.29219f
C303 outn s2d_block_0.s2d_tails_lo_f_0.sa_F2 2.79068f
C304 s2d_block_0.s2d_tails_hi_f_0.sa_A1 s2d_block_0.s2d_tails_hi_f_0.sb_M2 0.13856f
C305 vref s2d_block_0.s2d_tails_lo_f_0.sa_M2 0.06384f
C306 s2d_block_0.s2d_casc_n_f_0.x s2d_block_0.s2d_casc_n_f_0.vbnc 2.98545f
C307 outp s2d_block_0.s2d_tails_lo_f_0.sb_M1 0.86918f
C308 iovdd s2d_block_0.s2d_casc_p_f_0.vbpc 35.0861f
C309 s2d_block_0.s2d_tails_hi_f_0.sb_F2 s2d_block_0.s2d_casc_p_f_0.vbpc 0.02698f
C310 en_3v3 s2d_block_0.bias_tree_noab_n_c3_0.ni 0.06138f
C311 s2d_block_0.s2d_tails_hi_f_0.sb_F2 a_11844_27686# 0.02672f
C312 s2d_block_0.s2d_tails_hi_f_0.sb_F2 a_11844_28094# 0.07914f
C313 vdd a_11844_27142# 0.01241f
C314 a_14374_27142# a_11844_28638# 0.02707f
C315 s2d_block_0.s2d_tails_hi_f_0.sa_A1 outp 0.01644f
C316 s2d_block_0.s2d_tails_hi_f_0.sb_F1 a_11844_28366# 0.12708f
C317 s2d_block_0.s2d_casc_n_f_0.xc s2d_block_0.s2d_tails_hi_f_0.vbp 0.09249f
C318 s2d_block_0.s2d_tails_lo_f_0.sa_M2 s2d_block_0.s2d_tails_hi_f_0.sa_A2 0.03149f
C319 s2d_block_0.s2d_tails_lo_f_0.sb_A1 s2d_block_0.s2d_tails_hi_f_0.sb_M2 0.08784f
C320 s2d_block_0.s2d_tails_hi_f_0.sb_F2 a_11844_26326# 0.02158f
C321 outp s2d_block_0.s2d_loads_f_0.dd 0.0242f
C322 vdd vcm 1.91855f
C323 s2d_block_0.s2d_tails_lo_f_0.sa_F1 s2d_block_0.s2d_tails_lo_f_0.sa_M2 1.4446f
C324 s2d_block_0.s2d_casc_p_f_0.vbpc s2d_block_0.s2d_tails_lo_f_0.sb_M1 0.01817f
C325 outp en_3v3_b 1.72266f
C326 iref en_3v3_b 1.56328f
C327 s2d_block_0.s2d_loads_f_0.lp s2d_block_0.sinks_6x6_s2d_c3_core_0.vbn 0.25039f
C328 a_11844_25510# a_11844_25374# 0.63642f
C329 outn s2d_block_0.s2d_casc_n_f_0.xc 0.33309f
C330 a_11844_28094# s2d_block_0.s2d_tails_lo_f_0.sb_M1 0.02626f
C331 s2d_block_0.s2d_tails_hi_f_0.sa_A1 s2d_block_0.s2d_tails_lo_f_0.sb_A2 3.43851f
C332 vref s2d_block_0.s2d_tails_lo_f_0.sa_F1 0.06209f
C333 a_11844_26054# s2d_block_0.s2d_tails_hi_f_0.sa_M1 0.09778f
C334 outp s2d_block_0.s2d_tails_lo_f_0.sb_A1 0.98539f
C335 a_11844_27550# a_14374_27550# 0.02719f
C336 a_11844_27822# a_14374_27822# 0.02746f
C337 a_11844_27414# a_14374_27414# 0.02713f
C338 a_11844_26598# s2d_block_0.s2d_tails_hi_f_0.sa_M1 0.01029f
C339 a_11844_27686# a_14374_27686# 0.02728f
C340 a_14374_27686# a_11844_28094# 0.02728f
C341 a_11844_28230# a_11844_28366# 0.63642f
C342 pad s2d_block_0.s2d_casc_n_f_0.y 1.37827f
C343 s2d_block_0.s2d_tails_hi_f_0.sa_A1 s2d_block_0.s2d_casc_p_f_0.vbpc 0.02514f
C344 vref s2d_block_0.s2d_casc_n_f_0.x 1.49531f
C345 s2d_block_0.s2d_tails_hi_f_0.sb_F1 s2d_block_0.s2d_tails_lo_f_0.sa_M2 0.06369f
C346 s2d_block_0.s2d_loads_f_0.dd s2d_block_0.s2d_casc_p_f_0.vbpc 1.62631f
C347 s2d_block_0.s2d_loads_f_0.vcmfb s2d_block_0.sinks_6x6_s2d_c3_core_0.vbn 0.04166f
C348 pad s2d_block_0.s2d_casc_n_f_0.yc 0.06508f
C349 s2d_block_0.s2d_tails_hi_f_0.sb_F1 vref 0.05463f
C350 vdd s2d_block_0.s2d_casc_n_f_0.vbnc 1.187f
C351 s2d_block_0.s2d_tails_lo_f_0.sb_A1 s2d_block_0.s2d_tails_lo_f_0.sb_A2 0.36686f
C352 s2d_block_0.s2d_tails_lo_f_0.sa_M2 s2d_block_0.s2d_tails_hi_f_0.sa_M1 0.33016f
C353 s2d_block_0.s2d_tails_lo_f_0.sa_F1 s2d_block_0.s2d_tails_hi_f_0.sa_A2 0.31556f
C354 s2d_block_0.s2d_tails_hi_f_0.sb_F2 a_11844_25510# 0.02158f
C355 vcm s2d_block_0.s2d_tails_hi_f_0.sb_M2 2.97323f
C356 a_14374_25918# a_11844_25918# 0.02719f
C357 a_14374_26190# a_11844_26326# 0.02746f
C358 a_11844_26462# a_11844_26598# 0.63642f
C359 s2d_block_0.sinks_6x6_s2d_c3_core_0.vbn s2d_block_0.s2d_casc_n_f_0.vbnc 7.23477f
C360 s2d_block_0.s2d_casc_n_f_0.y s2d_block_0.s2d_tails_lo_f_0.sa_F2 1.20108f
C361 s2d_block_0.s2d_tails_lo_f_0.sb_A1 s2d_block_0.s2d_casc_p_f_0.vbpc 0.02425f
C362 s2d_block_0.s2d_casc_n_f_0.x s2d_block_0.s2d_tails_hi_f_0.sa_A2 0.19349f
C363 iovdd s2d_block_0.s2d_tails_hi_f_0.vbp 67.0717f
C364 s2d_block_0.s2d_tails_hi_f_0.sb_F2 s2d_block_0.s2d_tails_hi_f_0.vbp 0.75445f
C365 s2d_block_0.s2d_casc_n_f_0.x s2d_block_0.s2d_tails_lo_f_0.sa_F1 0.17877f
C366 s2d_block_0.s2d_tails_hi_f_0.sb_F1 s2d_block_0.s2d_tails_hi_f_0.sa_A2 0.28064f
C367 s2d_block_0.s2d_tails_lo_f_0.sa_F2 s2d_block_0.s2d_casc_n_f_0.yc 0.01813f
C368 outp vcm 9.47391f
C369 outp s2d_block_0.s2d_loads_f_0.lp 0.34422f
C370 iovdd outn 17.1112f
C371 s2d_block_0.s2d_tails_hi_f_0.sb_F2 outn 0.1826f
C372 s2d_block_0.s2d_loads_f_0.ln s2d_block_0.s2d_casc_n_f_0.xc 0.17914f
C373 s2d_block_0.s2d_tails_hi_f_0.sb_F1 s2d_block_0.s2d_tails_lo_f_0.sa_F1 1.04342f
C374 s2d_block_0.s2d_tails_hi_f_0.sa_M1 s2d_block_0.s2d_tails_hi_f_0.sa_A2 2.31964f
C375 a_14374_27550# a_14374_27414# 0.78325f
C376 a_11844_25510# a_11844_25646# 0.63642f
C377 s2d_block_0.s2d_tails_hi_f_0.sb_F1 s2d_block_0.s2d_casc_n_f_0.x 1.40651f
C378 s2d_block_0.s2d_tails_lo_f_0.sb_M1 s2d_block_0.s2d_tails_hi_f_0.vbp 0.26594f
C379 a_8120_4634# s2d_block_0.s2d_loads_f_0.vcmfb 0.01054f
C380 a_11758_27006# s2d_block_0.s2d_tails_lo_f_0.sb_M1 0.04688f
C381 s2d_block_0.s2d_tails_hi_f_0.sa_A1 a_11844_25510# 0.0665f
C382 vcm s2d_block_0.s2d_tails_lo_f_0.sb_A2 0.25963f
C383 outp s2d_block_0.s2d_loads_f_0.vcmfb 10.7502f
C384 vref vdd 1.72018f
C385 s2d_block_0.s2d_casc_n_f_0.y s2d_block_0.s2d_casc_n_f_0.xc 7.99643f
C386 iovdd s2d_block_0.bias_tree_noab_n_c3_0.ni 0.15021f
C387 outn s2d_block_0.s2d_tails_lo_f_0.sb_M1 0.03057f
C388 s2d_block_0.s2d_loads_f_0.lp s2d_block_0.s2d_casc_p_f_0.vbpc 1.79896f
C389 s2d_block_0.s2d_tails_hi_f_0.sa_A1 s2d_block_0.s2d_tails_hi_f_0.vbp 0.29449f
C390 a_14374_26054# a_14374_25918# 0.55763f
C391 a_11844_25782# s2d_block_0.s2d_tails_hi_f_0.sa_A2 0.03941f
C392 outp s2d_block_0.s2d_casc_n_f_0.vbnc 9.68843f
C393 a_14374_25782# a_11844_26734# 0.02713f
C394 s2d_block_0.s2d_tails_hi_f_0.sb_F1 s2d_block_0.s2d_tails_hi_f_0.sa_M1 1.21732f
C395 a_11844_26870# a_11844_27006# 0.63642f
C396 s2d_block_0.s2d_casc_n_f_0.xc s2d_block_0.s2d_casc_n_f_0.yc 12.1225f
C397 a_11844_25782# s2d_block_0.s2d_tails_lo_f_0.sa_F1 0.01924f
C398 s2d_block_0.s2d_tails_hi_f_0.sb_F2 a_11844_27550# 0.0248f
C399 s2d_block_0.s2d_tails_hi_f_0.sb_F2 a_11844_27958# 0.04246f
C400 vdd s2d_block_0.s2d_tails_hi_f_0.sa_A2 0.1052f
C401 s2d_block_0.s2d_tails_hi_f_0.sa_A1 outn 0.02153f
C402 en_3v3_b s2d_block_0.s2d_tails_hi_f_0.vbp 0.22518f
C403 s2d_block_0.s2d_loads_f_0.vcmfb s2d_block_0.s2d_casc_p_f_0.vbpc 2.11215f
C404 s2d_block_0.s2d_tails_hi_f_0.sb_F1 a_11844_28230# 0.03104f
C405 s2d_block_0.s2d_loads_f_0.dd outn 0.03137f
C406 a_7760_4632# Clamp_N_M1_0.gate 0.02705f
C407 iovdd s2d_block_0.s2d_loads_f_0.ln 9.1759f
C408 s2d_block_0.s2d_tails_lo_f_0.sb_A1 s2d_block_0.s2d_tails_hi_f_0.vbp 0.9893f
C409 a_14374_25510# s2d_block_0.sinks_6x6_s2d_c3_core_0.vbn 0.03952f
C410 s2d_block_0.s2d_tails_hi_f_0.sb_F2 a_11844_26190# 0.02158f
C411 en_3v3_b outn 0.23705f
C412 s2d_block_0.s2d_tails_hi_f_0.sb_F1 a_11844_25782# 0.0102f
C413 vdd s2d_block_0.s2d_casc_n_f_0.x 0.04852f
C414 pad Clamp_N_M1_0.gate 7.47057f
C415 outn s2d_block_0.s2d_tails_lo_f_0.sb_A1 0.03508f
C416 s2d_block_0.s2d_casc_n_f_0.x s2d_block_0.sinks_6x6_s2d_c3_core_0.vbn 11.6306f
C417 a_11844_25782# s2d_block_0.s2d_tails_hi_f_0.sa_M1 0.01333f
C418 s2d_block_0.s2d_tails_hi_f_0.sb_F1 vdd 0.10873f
C419 outp s2d_block_0.s2d_tails_lo_f_0.sa_M2 0.54122f
C420 a_11844_26462# s2d_block_0.s2d_tails_hi_f_0.sa_M1 0.01273f
C421 iovdd s2d_block_0.s2d_casc_n_f_0.y 15.5797f
C422 s2d_block_0.s2d_tails_hi_f_0.sb_F2 s2d_block_0.s2d_casc_n_f_0.y 0.45356f
C423 s2d_block_0.s2d_tails_hi_f_0.sa_A1 a_11844_28638# 0.01046f
C424 vref outp 0.3077f
C425 vdd s2d_block_0.s2d_tails_hi_f_0.sa_M1 0.10508f
C426 a_11844_25918# s2d_block_0.s2d_tails_lo_f_0.sa_F2 0.01924f
C427 s2d_block_0.s2d_tails_hi_f_0.sb_F1 s2d_block_0.sinks_6x6_s2d_c3_core_0.vbn 0.50564f
C428 s2d_block_0.s2d_tails_hi_f_0.sb_M2 s2d_block_0.s2d_tails_hi_f_0.sa_A2 0.30715f
C429 en_3v3_b s2d_block_0.bias_tree_noab_n_c3_0.ni 0.29376f
C430 a_14374_25646# a_14374_25510# 1.23642f
C431 a_11844_27142# a_11758_27006# 0.01971f
C432 s2d_block_0.s2d_tails_hi_f_0.sb_F2 s2d_block_0.s2d_casc_n_f_0.yc 0.45586f
C433 iovdd s2d_block_0.s2d_casc_n_f_0.yc 10.8054f
C434 a_11758_26870# a_11758_26734# 0.55763f
C435 a_11844_28774# s2d_block_0.s2d_tails_hi_f_0.sa_M1 0.0238f
C436 pad s2d_block_0.s2d_tails_lo_f_0.sa_F2 0.01954f
C437 vdd a_11844_27822# 0.02082f
C438 vcm s2d_block_0.s2d_tails_hi_f_0.vbp 0.77904f
C439 a_14374_26190# a_11844_26190# 0.02746f
C440 vref s2d_block_0.s2d_tails_lo_f_0.sb_A2 2.89541f
C441 s2d_block_0.s2d_tails_lo_f_0.sa_M2 s2d_block_0.s2d_casc_p_f_0.vbpc 0.02058f
C442 s2d_block_0.s2d_tails_lo_f_0.sb_A1 a_11844_28638# 0.02111f
C443 s2d_block_0.s2d_loads_f_0.dd s2d_block_0.s2d_loads_f_0.ln 12.7936f
C444 outp s2d_block_0.s2d_tails_hi_f_0.sa_A2 0.02196f
C445 a_14374_27414# a_14374_27278# 1.00966f
C446 s2d_block_0.s2d_tails_hi_f_0.sb_F2 a_11844_27006# 0.02253f
C447 outp s2d_block_0.s2d_tails_lo_f_0.sa_F1 0.15517f
C448 vcm outn 6.98968f
C449 a_8120_4634# Clamp_P_M1_0.gate 0.03336f
C450 outn s2d_block_0.s2d_loads_f_0.lp 0.10561f
C451 s2d_block_0.s2d_tails_hi_f_0.sb_F1 s2d_block_0.s2d_tails_hi_f_0.sb_M2 0.03169f
C452 s2d_block_0.s2d_tails_lo_f_0.sb_M1 s2d_block_0.s2d_casc_n_f_0.yc 0.22904f
C453 s2d_block_0.s2d_tails_hi_f_0.sa_A1 s2d_block_0.s2d_casc_n_f_0.y 1.19158f
C454 outp s2d_block_0.s2d_casc_n_f_0.x 0.87989f
C455 s2d_block_0.s2d_tails_hi_f_0.sa_M1 s2d_block_0.s2d_tails_hi_f_0.sb_M2 1.08556f
C456 s2d_block_0.s2d_tails_lo_f_0.sb_A2 s2d_block_0.s2d_tails_hi_f_0.sa_A2 0.08815f
C457 Clamp_N_M1_0.gate s2d_block_0.s2d_casc_n_f_0.xc 0.01061f
C458 pad s2d_block_0.s2d_casc_n_f_0.xc 0.0794f
C459 vdd s2d_block_0.sinks_6x6_s2d_c3_core_0.vbn 1.34414f
C460 s2d_block_0.s2d_tails_lo_f_0.sa_F1 s2d_block_0.s2d_tails_lo_f_0.sb_A2 0.25628f
C461 s2d_block_0.s2d_tails_hi_f_0.sb_F1 outp 2.87685f
C462 s2d_block_0.s2d_casc_n_f_0.vbnc s2d_block_0.s2d_tails_hi_f_0.vbp 0.11962f
C463 s2d_block_0.s2d_casc_p_f_0.vbpc s2d_block_0.s2d_tails_hi_f_0.sa_A2 0.02597f
C464 outn s2d_block_0.s2d_loads_f_0.vcmfb 4.45704f
C465 s2d_block_0.s2d_loads_f_0.dd s2d_block_0.s2d_casc_n_f_0.yc 1.54595f
C466 a_11844_27278# a_11844_27414# 0.63642f
C467 a_11844_27550# a_11758_26598# 0.01938f
C468 s2d_block_0.s2d_casc_n_f_0.y s2d_block_0.s2d_tails_lo_f_0.sb_A1 0.19349f
C469 s2d_block_0.s2d_tails_lo_f_0.sa_F1 s2d_block_0.s2d_casc_p_f_0.vbpc 0.01535f
C470 a_11758_26462# a_11758_26326# 1.23642f
C471 s2d_block_0.s2d_casc_n_f_0.x s2d_block_0.s2d_tails_lo_f_0.sb_A2 1.26802f
C472 outp s2d_block_0.s2d_tails_hi_f_0.sa_M1 3.63692f
C473 outn s2d_block_0.s2d_casc_n_f_0.vbnc 9.68851f
C474 s2d_block_0.s2d_tails_hi_f_0.sb_F1 s2d_block_0.s2d_tails_lo_f_0.sb_A2 0.58509f
C475 s2d_block_0.s2d_casc_n_f_0.xc s2d_block_0.s2d_tails_lo_f_0.sa_F2 0.01761f
C476 s2d_block_0.s2d_tails_lo_f_0.sb_A1 s2d_block_0.s2d_casc_n_f_0.yc 0.03102f
C477 s2d_block_0.s2d_tails_hi_f_0.sb_F2 a_11844_27414# 0.02378f
C478 vdd s2d_block_0.s2d_tails_hi_f_0.sb_M2 0.09122f
C479 s2d_block_0.s2d_tails_lo_f_0.sb_A2 s2d_block_0.s2d_tails_hi_f_0.sa_M1 0.23951f
C480 s2d_block_0.s2d_tails_hi_f_0.sb_F1 s2d_block_0.s2d_casc_p_f_0.vbpc 0.11357f
C481 s2d_block_0.s2d_loads_f_0.ln s2d_block_0.s2d_loads_f_0.lp 5.83659f
C482 a_14374_27278# a_11844_28502# 0.0271f
C483 iovdd a_7760_4632# 0.04371f
C484 s2d_block_0.s2d_casc_p_f_0.vbpc s2d_block_0.s2d_tails_hi_f_0.sa_M1 0.02579f
C485 a_14374_25646# s2d_block_0.sinks_6x6_s2d_c3_core_0.vbn 0.01791f
C486 s2d_block_0.s2d_tails_lo_f_0.sa_M2 s2d_block_0.s2d_tails_hi_f_0.vbp 0.4559f
C487 s2d_block_0.s2d_tails_hi_f_0.sb_F2 a_11844_25918# 0.02158f
C488 iovdd Clamp_N_M1_0.gate 0.31292f
C489 vdd outp 4.60703f
C490 vref s2d_block_0.s2d_tails_hi_f_0.vbp 0.10217f
C491 pad iovdd 45.5897f
C492 vdd iref 1.71255f
C493 s2d_block_0.s2d_tails_hi_f_0.sb_F2 pad 0.22487f
C494 vcm s2d_block_0.s2d_casc_n_f_0.y 0.63563f
C495 s2d_block_0.s2d_loads_f_0.ln s2d_block_0.s2d_loads_f_0.vcmfb 1.8425f
C496 outn s2d_block_0.s2d_tails_lo_f_0.sa_M2 3.08404f
C497 a_11758_26326# s2d_block_0.s2d_tails_lo_f_0.sb_M1 0.04825f
C498 iovdd en_3v3 0.36737f
C499 outp s2d_block_0.sinks_6x6_s2d_c3_core_0.vbn 0.0236f
C500 a_11844_26326# s2d_block_0.s2d_tails_hi_f_0.sa_M1 0.01916f
C501 a_11844_25510# s2d_block_0.s2d_tails_hi_f_0.sa_A2 0.01204f
C502 a_14374_25510# a_11844_25510# 0.02707f
C503 a_11844_27686# a_11844_27822# 0.63642f
C504 a_14374_27822# a_11844_27958# 0.02746f
C505 a_11844_28094# a_11844_28230# 0.63642f
C506 vref outn 5.68618f
C507 s2d_block_0.s2d_tails_hi_f_0.sa_A1 a_11844_28502# 0.01046f
C508 vcm s2d_block_0.s2d_casc_n_f_0.yc 0.10607f
C509 s2d_block_0.s2d_loads_f_0.lp s2d_block_0.s2d_casc_n_f_0.yc 0.21417f
C510 s2d_block_0.s2d_tails_hi_f_0.vbp s2d_block_0.s2d_tails_hi_f_0.sa_A2 0.27394f
C511 a_11844_27142# a_11844_27006# 0.63642f
C512 iovdd s2d_block_0.s2d_tails_lo_f_0.sa_F2 5.2742f
C513 a_14374_27278# a_14374_27142# 1.23642f
C514 s2d_block_0.s2d_loads_f_0.vcmfb s2d_block_0.s2d_casc_n_f_0.y 0.21086f
C515 s2d_block_0.s2d_tails_hi_f_0.sb_F2 s2d_block_0.s2d_tails_lo_f_0.sa_F2 1.64077f
C516 vdd s2d_block_0.s2d_casc_p_f_0.vbpc 0.38387f
C517 pad s2d_block_0.s2d_tails_lo_f_0.sb_M1 0.0582f
C518 s2d_block_0.s2d_tails_lo_f_0.sa_F1 s2d_block_0.s2d_tails_hi_f_0.vbp 0.26261f
C519 vdd a_11844_27686# 0.0197f
C520 outn s2d_block_0.s2d_tails_hi_f_0.sa_A2 0.0227f
C521 a_11844_26054# a_11844_26190# 0.63642f
C522 s2d_block_0.s2d_casc_n_f_0.xc a_11844_25374# 0.01124f
C523 s2d_block_0.sinks_6x6_s2d_c3_core_0.vbn s2d_block_0.s2d_casc_p_f_0.vbpc 0.03673f
C524 s2d_block_0.s2d_casc_n_f_0.y s2d_block_0.s2d_casc_n_f_0.vbnc 2.09561f
C525 a_11844_26326# a_11844_26462# 0.63642f
C526 s2d_block_0.s2d_loads_f_0.vcmfb s2d_block_0.s2d_casc_n_f_0.yc 0.20847f
C527 s2d_block_0.s2d_tails_hi_f_0.sb_F1 a_11844_25510# 0.01318f
C528 s2d_block_0.s2d_casc_n_f_0.x s2d_block_0.s2d_tails_hi_f_0.vbp 0.07574f
C529 outp s2d_block_0.s2d_tails_hi_f_0.sb_M2 0.84971f
C530 outn s2d_block_0.s2d_tails_lo_f_0.sa_F1 0.02799f
C531 s2d_block_0.s2d_tails_hi_f_0.sa_A1 pad 2.83511f
C532 s2d_block_0.s2d_tails_hi_f_0.sb_F2 a_11844_26870# 0.02235f
C533 a_11758_26326# s2d_block_0.s2d_tails_lo_f_0.sb_A1 0.05685f
C534 iref iovss 2.67053f
C535 vdd iovss 0.20836p
C536 s2d_block_0.s2d_loads_f_0.dd iovss 3.19021f
C537 s2d_block_0.s2d_loads_f_0.ln iovss 9.89804f
C538 s2d_block_0.s2d_loads_f_0.lp iovss 6.22746f
C539 a_14374_26190# iovss 1.16641f
C540 a_14374_26054# iovss 1.29287f
C541 a_14374_25918# iovss 1.39935f
C542 a_14374_25782# iovss 1.46247f
C543 a_14374_25646# iovss 1.47687f
C544 a_14374_25510# iovss 2.66141f
C545 a_11758_27006# iovss 1.03056f
C546 a_11758_26870# iovss 1.10629f
C547 a_11758_26734# iovss 1.21292f
C548 a_11758_26598# iovss 1.3156f
C549 a_11758_26462# iovss 1.38801f
C550 a_11758_26326# iovss 2.409f
C551 a_14374_27822# iovss 1.06639f
C552 a_14374_27686# iovss 1.18649f
C553 a_14374_27550# iovss 1.26601f
C554 a_14374_27414# iovss 1.34504f
C555 a_14374_27278# iovss 1.42889f
C556 a_14374_27142# iovss 2.67699f
C557 s2d_block_0.s2d_casc_n_f_0.xc iovss 83.8826f
C558 s2d_block_0.s2d_casc_n_f_0.yc iovss 47.58514f
C559 s2d_block_0.s2d_casc_n_f_0.x iovss 32.88367f
C560 s2d_block_0.s2d_casc_n_f_0.y iovss 39.41771f
C561 s2d_block_0.s2d_tails_lo_f_0.sa_M2 iovss 2.67627f
C562 s2d_block_0.s2d_tails_lo_f_0.sb_M1 iovss 3.81297f
C563 s2d_block_0.s2d_tails_lo_f_0.sb_A1 iovss 3.85353f
C564 s2d_block_0.s2d_tails_lo_f_0.sa_F2 iovss 19.38396f
C565 s2d_block_0.s2d_tails_lo_f_0.sa_F1 iovss 6.60435f
C566 s2d_block_0.s2d_tails_lo_f_0.sb_A2 iovss 9.08991f
C567 s2d_block_0.s2d_tails_hi_f_0.sb_M2 iovss 4.72933f
C568 s2d_block_0.s2d_tails_hi_f_0.sa_M1 iovss 7.29322f
C569 s2d_block_0.s2d_tails_hi_f_0.sa_A2 iovss 4.56941f
C570 s2d_block_0.s2d_tails_hi_f_0.sb_F1 iovss 24.34209f
C571 s2d_block_0.s2d_tails_hi_f_0.sb_F2 iovss 8.68036f
C572 s2d_block_0.s2d_tails_hi_f_0.sa_A1 iovss 5.54355f
.ends
