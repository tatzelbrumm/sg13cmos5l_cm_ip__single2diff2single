* generated by scripts/cace/pex_for_sim.py from /tmp/claude-0/-home-user-sg13cmos5l-cm-ip--single2diff2single/9625f5bb-27cd-530e-a9cf-d1aa15a8223d/scratchpad/agents/F/work/B3/run7/pex/sg13cmos5l_IOPadSingle2Diff.pex.spice: 28 capacitor-only nodes tied to iovss through 1e12 Ohm
* PEX produced on Wed Nov  4 18:04:35 UTC 2026 using /usr/local/bin/sak-pex.sh with m=2 and s=1
* NGSPICE file created from sg13cmos5l_IOPadSingle2Diff.ext - technology: ihp-sg13cmos5l

.subckt sg13cmos5l_IOPadSingle2Diff vdd iovss pad iovdd vref outp outn vcm en_3v3
+ en_3v3_b iref
X0 iovdd s2d_block_0.s2d_tails_hi_f_0.vbp iovdd iovdd sg13_hv_pmos ad=1.7p pd=10.68u as=0.65663n ps=2.66142m w=5u l=6u
X1 iovss iovss iovss rhigh l=12.65u w=0.5u
X2 s2d_block_0.s2d_loads_f_0.ln s2d_block_0.s2d_loads_f_0.vcmfb iovdd iovdd sg13_hv_pmos ad=2.04p pd=12.68u as=2.04p ps=12.68u w=6u l=4u
X3 s2d_block_0.s2d_loads_f_0.ln s2d_block_0.s2d_casc_p_f_0.vbpc outn iovdd sg13_hv_pmos ad=5.1p pd=30.68u as=5.1p ps=30.68u w=15u l=3u
X4 s2d_block_0.s2d_tails_hi_f_0.sa_A2 a_14374_25646# iovss rhigh l=12.65u w=0.5u
X5 s2d_block_0.s2d_casc_n_f_0.xc s2d_block_0.sinks_6x6_s2d_c3_core_0.vbn iovss iovss sg13_hv_nmos ad=2.04p pd=12.68u as=2.04p ps=12.68u w=6u l=6u
X6 iovdd s2d_block_0.s2d_casc_n_f_0.vbnc s2d_block_0.s2d_casc_n_f_0.yc iovss sg13_hv_nmos ad=5.1p pd=30.68u as=5.1p ps=30.68u w=15u l=3u
X7 Clamp_P_M1_0.gate iovdd iovss rppd l=12.9u w=0.5u
X8 s2d_block_0.s2d_loads_f_0.ln s2d_block_0.s2d_loads_f_0.vcmfb iovdd iovdd sg13_hv_pmos ad=2.04p pd=12.68u as=2.04p ps=12.68u w=6u l=4u
X9 s2d_block_0.s2d_casc_p_f_0.vbpc s2d_block_0.bias_tree_noab_n_c3_0.ni iovss iovss sg13_hv_nmos ad=0.816p pd=5.48u as=0.816p ps=5.48u w=2.4u l=6u
X10 a_11758_27006# a_14374_25510# iovss rhigh l=12.65u w=0.5u
X11 s2d_block_0.s2d_tails_lo_f_0.sa_F1 vcm s2d_block_0.s2d_casc_n_f_0.y s2d_block_0.s2d_tails_lo_f_0.sa_F1 sg13_hv_pmos ad=3.4p pd=20.68u as=1.9p ps=10.38u w=10u l=1u
X12 iovss s2d_block_0.sinks_6x6_s2d_c3_core_0.vbn iovss iovss sg13_hv_nmos ad=0.68p pd=4.68u as=0.75674n ps=2.78086m w=2u l=6u
X13 iovdd Clamp_P_M1_0.gate pad iovdd sg13_hv_pmos ad=2.1312p pd=7.3u as=3.9294p ps=7.84u w=6.66u l=0.6u
X14 iovss s2d_block_0.sinks_6x6_s2d_c3_core_0.vbn s2d_block_0.s2d_casc_n_f_0.xc iovss sg13_hv_nmos ad=2.04p pd=12.68u as=2.04p ps=12.68u w=6u l=6u
X15 s2d_block_0.bias_tree_noab_n_c3_0.ni en_3v3_b iovss iovss sg13_hv_nmos ad=0.34p pd=2.68u as=0.34p ps=2.68u w=1u l=0.45u
X16 iovdd Clamp_P_M1_0.gate pad iovdd sg13_hv_pmos ad=2.1312p pd=7.3u as=3.9294p ps=7.84u w=6.66u l=0.6u
X17 iovss s2d_block_0.sinks_6x6_s2d_c3_core_0.vbn iovss iovss sg13_hv_nmos ad=2.04p pd=12.68u as=0 ps=0 w=6u l=6u
X18 s2d_block_0.s2d_casc_n_f_0.x s2d_block_0.s2d_casc_n_f_0.vbnc outp iovss sg13_hv_nmos ad=5.1p pd=30.68u as=5.1p ps=30.68u w=15u l=3u
X19 s2d_block_0.s2d_casc_n_f_0.x vref s2d_block_0.s2d_tails_lo_f_0.sb_A2 s2d_block_0.s2d_tails_lo_f_0.sb_A2 sg13_hv_pmos ad=1.9p pd=10.38u as=3.4p ps=20.68u w=10u l=1u
X20 iovdd Clamp_P_M1_0.gate pad iovdd sg13_hv_pmos ad=2.1312p pd=7.3u as=3.9294p ps=7.84u w=6.66u l=0.6u
X21 s2d_block_0.s2d_tails_hi_f_0.sb_F1 outp s2d_block_0.s2d_casc_n_f_0.x s2d_block_0.s2d_tails_hi_f_0.sb_F1 sg13_hv_pmos ad=3.4p pd=20.68u as=1.9p ps=10.38u w=10u l=1u
X22 iovdd iovdd iovdd iovdd sg13_hv_pmos ad=1.9p pd=10.38u as=0 ps=0 w=10u l=1u
X23 iovdd s2d_block_0.s2d_tails_hi_f_0.vbp iovdd iovdd sg13_hv_pmos ad=1.7p pd=10.68u as=0 ps=0 w=5u l=6u
X24 s2d_block_0.s2d_casc_n_f_0.y s2d_block_0.sinks_6x6_s2d_c3_core_0.vbn iovss iovss sg13_hv_nmos ad=2.04p pd=12.68u as=2.04p ps=12.68u w=6u l=6u
X25 s2d_block_0.s2d_tails_lo_f_0.sb_A2 a_14374_27278# iovss rhigh l=12.65u w=0.5u
X26 iovdd s2d_block_0.s2d_loads_f_0.vcmfb s2d_block_0.s2d_loads_f_0.dd iovdd sg13_hv_pmos ad=2.04p pd=12.68u as=2.04p ps=12.68u w=6u l=4u
X27 pad Clamp_N_M1_0.gate iovss iovss sg13_hv_nmos ad=2.596p pd=5.58u as=1.408p ps=5.04u w=4.4u l=0.6u
X28 pad Clamp_N_M1_0.gate iovss iovss sg13_hv_nmos ad=2.596p pd=5.58u as=2.068p ps=9.74u w=4.4u l=0.6u
X29 iovdd s2d_block_0.s2d_loads_f_0.vcmfb s2d_block_0.s2d_loads_f_0.lp iovdd sg13_hv_pmos ad=2.04p pd=12.68u as=2.04p ps=12.68u w=6u l=4u
X30 pad Clamp_N_M1_0.gate iovss iovss sg13_hv_nmos ad=2.596p pd=5.58u as=1.408p ps=5.04u w=4.4u l=0.6u
X31 vcm en_3v3_b outp iovss sg13_hv_nmos ad=0.19p pd=1.38u as=0.34p ps=2.68u w=1u l=0.45u
X32 s2d_block_0.s2d_tails_lo_f_0.sa_F1 a_14374_25782# iovss rhigh l=12.65u w=0.5u
X33 a_11758_27006# a_14374_27142# iovss rhigh l=12.65u w=0.5u
X34 iovdd iovdd iovdd iovdd sg13_hv_pmos ad=3.4p pd=20.68u as=0 ps=0 w=10u l=1u
X35 pad Clamp_P_M1_0.gate iovdd iovdd sg13_hv_pmos ad=3.9294p pd=7.84u as=2.1312p ps=7.3u w=6.66u l=0.6u
X36 s2d_block_0.s2d_loads_f_0.lp s2d_block_0.s2d_casc_p_f_0.vbpc outp iovdd sg13_hv_pmos ad=5.1p pd=30.68u as=5.1p ps=30.68u w=15u l=3u
X37 iovdd s2d_block_0.s2d_tails_hi_f_0.vbp s2d_block_0.s2d_tails_hi_f_0.sa_M1 iovdd sg13_hv_pmos ad=1.7p pd=10.68u as=1.7p ps=10.68u w=5u l=6u
X38 s2d_block_0.s2d_casc_n_f_0.y s2d_block_0.sinks_6x6_s2d_c3_core_0.vbn iovss iovss sg13_hv_nmos ad=2.04p pd=12.68u as=2.04p ps=12.68u w=6u l=6u
X39 iovdd Clamp_P_M1_0.gate pad iovdd sg13_hv_pmos ad=2.1312p pd=7.3u as=3.9294p ps=7.84u w=6.66u l=0.6u
X40 iovdd Clamp_P_M1_0.gate pad iovdd sg13_hv_pmos ad=2.1312p pd=7.3u as=3.9294p ps=7.84u w=6.66u l=0.6u
X41 iref en_3v3 s2d_block_0.bias_tree_noab_n_c3_0.ni iovss sg13_hv_nmos ad=0.34p pd=2.68u as=0.34p ps=2.68u w=1u l=0.45u
X42 iovdd Clamp_P_M1_0.gate pad iovdd sg13_hv_pmos ad=2.1312p pd=7.3u as=3.9294p ps=7.84u w=6.66u l=0.6u
X43 pad iovdd dpantenna l=1.26u w=27.78u
X44 pad Clamp_P_M1_0.gate iovdd iovdd sg13_hv_pmos ad=3.9294p pd=7.84u as=2.1312p ps=7.3u w=6.66u l=0.6u
X45 s2d_block_0.s2d_casc_n_f_0.x vcm s2d_block_0.s2d_tails_hi_f_0.sb_F2 s2d_block_0.s2d_tails_hi_f_0.sb_F2 sg13_hv_pmos ad=1.9p pd=10.38u as=3.4p ps=20.68u w=10u l=1u
X46 s2d_block_0.s2d_tails_hi_f_0.sa_A1 a_14374_25510# iovss rhigh l=12.65u w=0.5u
X47 iovss s2d_block_0.sinks_6x6_s2d_c3_core_0.vbn s2d_block_0.s2d_casc_n_f_0.y iovss sg13_hv_nmos ad=2.04p pd=12.68u as=2.04p ps=12.68u w=6u l=6u
X48 s2d_block_0.s2d_tails_hi_f_0.sb_F1 a_14374_27414# iovss rhigh l=12.65u w=0.5u
X49 s2d_block_0.s2d_tails_lo_f_0.sa_F2 outn s2d_block_0.s2d_casc_n_f_0.y s2d_block_0.s2d_tails_lo_f_0.sa_F2 sg13_hv_pmos ad=3.4p pd=20.68u as=1.9p ps=10.38u w=10u l=1u
X50 iovss s2d_block_0.bias_tree_noab_n_c3_0.ni iovss iovss sg13_hv_nmos ad=0.816p pd=5.48u as=0 ps=0 w=2.4u l=6u
X51 s2d_block_0.s2d_casc_n_f_0.y s2d_block_0.s2d_casc_n_f_0.vbnc outn iovss sg13_hv_nmos ad=5.1p pd=30.68u as=5.1p ps=30.68u w=15u l=3u
X52 pad Clamp_N_M1_0.gate iovss iovss sg13_hv_nmos ad=2.596p pd=5.58u as=1.408p ps=5.04u w=4.4u l=0.6u
X53 iovss s2d_block_0.s2d_casc_n_f_0.vbnc iovss iovss sg13_hv_nmos ad=0.68p pd=4.68u as=0 ps=0 w=2u l=3u
X54 iovss pad dantenna l=1.26u w=27.78u
X55 pad Clamp_N_M1_0.gate iovss iovss sg13_hv_nmos ad=2.596p pd=5.58u as=1.408p ps=5.04u w=4.4u l=0.6u
X56 vcm en_3v3 outp iovdd sg13_hv_pmos ad=0.19p pd=1.38u as=0.34p ps=2.68u w=1u l=0.45u
X57 outn en_3v3 vcm iovdd sg13_hv_pmos ad=0.34p pd=2.68u as=0.19p ps=1.38u w=1u l=0.45u
X58 iovdd s2d_block_0.s2d_tails_hi_f_0.vbp s2d_block_0.s2d_tails_hi_f_0.sb_M2 iovdd sg13_hv_pmos ad=1.7p pd=10.68u as=1.7p ps=10.68u w=5u l=6u
X59 iovss s2d_block_0.sinks_6x6_s2d_c3_core_0.vbn s2d_block_0.s2d_casc_n_f_0.y iovss sg13_hv_nmos ad=2.04p pd=12.68u as=2.04p ps=12.68u w=6u l=6u
X60 pad Clamp_P_M1_0.gate iovdd iovdd sg13_hv_pmos ad=3.9294p pd=7.84u as=2.1312p ps=7.3u w=6.66u l=0.6u
X61 iovdd s2d_block_0.s2d_tails_hi_f_0.vbp s2d_block_0.s2d_tails_hi_f_0.sb_F1 iovdd sg13_hv_pmos ad=1.7p pd=10.68u as=1.7p ps=10.68u w=5u l=6u
X62 iovdd s2d_block_0.s2d_loads_f_0.vcmfb s2d_block_0.s2d_loads_f_0.lp iovdd sg13_hv_pmos ad=2.04p pd=12.68u as=2.04p ps=12.68u w=6u l=4u
X63 iovdd Clamp_P_M1_0.gate pad iovdd sg13_hv_pmos ad=2.1312p pd=7.3u as=3.9294p ps=7.84u w=6.66u l=0.6u
X64 a_11758_26734# a_14374_25782# iovss rhigh l=12.65u w=0.5u
X65 pad Clamp_P_M1_0.gate iovdd iovdd sg13_hv_pmos ad=3.9294p pd=7.84u as=2.1312p ps=7.3u w=6.66u l=0.6u
X66 pad Clamp_P_M1_0.gate iovdd iovdd sg13_hv_pmos ad=3.9294p pd=7.84u as=2.1312p ps=7.3u w=6.66u l=0.6u
X67 pad Clamp_P_M1_0.gate iovdd iovdd sg13_hv_pmos ad=3.9294p pd=7.84u as=2.1312p ps=7.3u w=6.66u l=0.6u
X68 s2d_block_0.s2d_tails_hi_f_0.sb_M2 vcm s2d_block_0.s2d_casc_n_f_0.xc s2d_block_0.s2d_tails_hi_f_0.sb_M2 sg13_hv_pmos ad=3.4p pd=20.68u as=1.9p ps=10.38u w=10u l=1u
X69 pad Clamp_P_M1_0.gate iovdd iovdd sg13_hv_pmos ad=3.9294p pd=7.84u as=2.1312p ps=7.3u w=6.66u l=0.6u
X70 iovss Clamp_N_M1_0.gate pad iovss sg13_hv_nmos ad=1.408p pd=5.04u as=2.596p ps=5.58u w=4.4u l=0.6u
X71 iovss Clamp_N_M1_0.gate pad iovss sg13_hv_nmos ad=1.408p pd=5.04u as=2.596p ps=5.58u w=4.4u l=0.6u
X72 iovss iovss iovss rhigh l=12.65u w=0.5u
X73 s2d_block_0.s2d_casc_n_f_0.yc s2d_block_0.s2d_casc_n_f_0.vbnc iovdd iovss sg13_hv_nmos ad=5.1p pd=30.68u as=5.1p ps=30.68u w=15u l=3u
X74 iovdd s2d_block_0.s2d_casc_p_f_0.vbpc iovdd iovdd sg13_hv_pmos ad=0.34p pd=2.68u as=0 ps=0 w=1u l=4u
X75 s2d_block_0.s2d_casc_n_f_0.yc outp s2d_block_0.s2d_tails_hi_f_0.sa_M1 s2d_block_0.s2d_tails_hi_f_0.sa_M1 sg13_hv_pmos ad=1.9p pd=10.38u as=3.4p ps=20.68u w=10u l=1u
X76 s2d_block_0.s2d_casc_n_f_0.y vcm s2d_block_0.s2d_tails_lo_f_0.sa_F1 s2d_block_0.s2d_tails_lo_f_0.sa_F1 sg13_hv_pmos ad=1.9p pd=10.38u as=3.4p ps=20.68u w=10u l=1u
X77 iovdd s2d_block_0.s2d_tails_hi_f_0.vbp s2d_block_0.s2d_tails_hi_f_0.sa_A2 iovdd sg13_hv_pmos ad=1.7p pd=10.68u as=1.7p ps=10.68u w=5u l=6u
X78 s2d_block_0.s2d_tails_hi_f_0.sa_A2 pad s2d_block_0.s2d_casc_n_f_0.y s2d_block_0.s2d_tails_hi_f_0.sa_A2 sg13_hv_pmos ad=3.4p pd=20.68u as=1.9p ps=10.38u w=10u l=1u
X79 iovss s2d_block_0.sinks_6x6_s2d_c3_core_0.vbn s2d_block_0.s2d_casc_n_f_0.yc iovss sg13_hv_nmos ad=2.04p pd=12.68u as=2.04p ps=12.68u w=6u l=6u
X80 iovss s2d_block_0.sinks_6x6_s2d_c3_core_0.vbn iovss iovss sg13_hv_nmos ad=0.68p pd=4.68u as=0 ps=0 w=2u l=6u
X81 s2d_block_0.s2d_tails_hi_f_0.sb_M2 a_14374_27822# iovss rhigh l=12.65u w=0.5u
X82 s2d_block_0.s2d_casc_n_f_0.yc s2d_block_0.sinks_6x6_s2d_c3_core_0.vbn iovss iovss sg13_hv_nmos ad=2.04p pd=12.68u as=2.04p ps=12.68u w=6u l=6u
X83 iovss s2d_block_0.sinks_6x6_s2d_c3_core_0.vbn s2d_block_0.s2d_casc_n_f_0.y iovss sg13_hv_nmos ad=2.04p pd=12.68u as=2.04p ps=12.68u w=6u l=6u
X84 iovdd s2d_block_0.s2d_tails_hi_f_0.vbp s2d_block_0.s2d_tails_hi_f_0.sa_A1 iovdd sg13_hv_pmos ad=1.7p pd=10.68u as=1.7p ps=10.68u w=5u l=6u
X85 a_11758_26870# a_14374_25646# iovss rhigh l=12.65u w=0.5u
X86 s2d_block_0.s2d_casc_n_f_0.vbnc s2d_block_0.s2d_tails_hi_f_0.vbp iovdd iovdd sg13_hv_pmos ad=0.68p pd=4.68u as=0.68p ps=4.68u w=2u l=6u
X87 s2d_block_0.s2d_tails_hi_f_0.sb_F2 a_14374_27550# iovss rhigh l=12.65u w=0.5u
X88 iovdd s2d_block_0.s2d_tails_hi_f_0.vbp iovdd iovdd sg13_hv_pmos ad=1.7p pd=10.68u as=0 ps=0 w=5u l=6u
X89 pad Clamp_P_M1_0.gate iovdd iovdd sg13_hv_pmos ad=3.9294p pd=7.84u as=2.1312p ps=7.3u w=6.66u l=0.6u
X90 pad Clamp_P_M1_0.gate iovdd iovdd sg13_hv_pmos ad=3.9294p pd=7.84u as=2.1312p ps=7.3u w=6.66u l=0.6u
X91 a_11758_26598# a_14374_25918# iovss rhigh l=12.65u w=0.5u
X92 iovss s2d_block_0.sinks_6x6_s2d_c3_core_0.vbn s2d_block_0.s2d_casc_n_f_0.x iovss sg13_hv_nmos ad=2.04p pd=12.68u as=2.04p ps=12.68u w=6u l=6u
X93 s2d_block_0.s2d_loads_f_0.dd s2d_block_0.s2d_loads_f_0.vcmfb iovdd iovdd sg13_hv_pmos ad=2.04p pd=12.68u as=2.04p ps=12.68u w=6u l=4u
X94 pad Clamp_P_M1_0.gate iovdd iovdd sg13_hv_pmos ad=3.9294p pd=7.84u as=2.1312p ps=7.3u w=6.66u l=0.6u
X95 iovss Clamp_N_M1_0.gate pad iovss sg13_hv_nmos ad=1.408p pd=5.04u as=2.596p ps=5.58u w=4.4u l=0.6u
X96 iovdd s2d_block_0.s2d_loads_f_0.vcmfb iovdd iovdd sg13_hv_pmos ad=0.34p pd=2.68u as=0 ps=0 w=1u l=4u
X97 pad iovdd dpantenna l=1.26u w=27.78u
X98 pad Clamp_P_M1_0.gate iovdd iovdd sg13_hv_pmos ad=3.9294p pd=7.84u as=2.1312p ps=7.3u w=6.66u l=0.6u
X99 iovdd s2d_block_0.s2d_loads_f_0.vcmfb s2d_block_0.s2d_loads_f_0.ln iovdd sg13_hv_pmos ad=2.04p pd=12.68u as=2.04p ps=12.68u w=6u l=4u
X100 iovss Clamp_N_M1_0.gate pad iovss sg13_hv_nmos ad=2.068p pd=9.74u as=2.596p ps=5.58u w=4.4u l=0.6u
X101 s2d_block_0.s2d_loads_f_0.lp s2d_block_0.s2d_loads_f_0.vcmfb iovdd iovdd sg13_hv_pmos ad=2.04p pd=12.68u as=2.04p ps=12.68u w=6u l=4u
X102 iovdd s2d_block_0.s2d_loads_f_0.vcmfb s2d_block_0.s2d_loads_f_0.ln iovdd sg13_hv_pmos ad=2.04p pd=12.68u as=2.04p ps=12.68u w=6u l=4u
X103 iovdd s2d_block_0.s2d_casc_p_f_0.vbpc iovdd iovdd sg13_hv_pmos ad=0.34p pd=2.68u as=0 ps=0 w=1u l=4u
X104 pad Clamp_N_M1_0.gate iovss iovss sg13_hv_nmos ad=2.596p pd=5.58u as=1.408p ps=5.04u w=4.4u l=0.6u
X105 s2d_block_0.s2d_tails_lo_f_0.sa_M2 outn s2d_block_0.s2d_casc_n_f_0.yc s2d_block_0.s2d_tails_lo_f_0.sa_M2 sg13_hv_pmos ad=3.4p pd=20.68u as=1.9p ps=10.38u w=10u l=1u
X106 iovdd s2d_block_0.s2d_casc_p_f_0.vbpc s2d_block_0.s2d_casc_p_f_0.vbpc iovdd sg13_hv_pmos ad=0.34p pd=2.68u as=0.34p ps=2.68u w=1u l=4u
X107 iovdd s2d_block_0.s2d_loads_f_0.vcmfb iovdd iovdd sg13_hv_pmos ad=0.34p pd=2.68u as=0 ps=0 w=1u l=4u
X108 s2d_block_0.s2d_casc_n_f_0.y s2d_block_0.sinks_6x6_s2d_c3_core_0.vbn iovss iovss sg13_hv_nmos ad=2.04p pd=12.68u as=2.04p ps=12.68u w=6u l=6u
X109 iovss outp iovss iovss sg13_hv_nmos ad=4.08p pd=24.68u as=0 ps=0 w=12u l=12u
X110 iovss outn iovss iovss sg13_hv_nmos ad=4.08p pd=24.68u as=0 ps=0 w=12u l=12u
X111 iovdd s2d_block_0.s2d_tails_hi_f_0.vbp s2d_block_0.s2d_tails_hi_f_0.sb_F2 iovdd sg13_hv_pmos ad=1.7p pd=10.68u as=1.7p ps=10.68u w=5u l=6u
X112 s2d_block_0.s2d_casc_n_f_0.x outp s2d_block_0.s2d_tails_hi_f_0.sb_F1 s2d_block_0.s2d_tails_hi_f_0.sb_F1 sg13_hv_pmos ad=1.9p pd=10.38u as=3.4p ps=20.68u w=10u l=1u
X113 s2d_block_0.s2d_casc_n_f_0.xc vcm s2d_block_0.s2d_tails_lo_f_0.sb_M1 s2d_block_0.s2d_tails_lo_f_0.sb_M1 sg13_hv_pmos ad=1.9p pd=10.38u as=3.4p ps=20.68u w=10u l=1u
X114 iovss s2d_block_0.sinks_6x6_s2d_c3_core_0.vbn iovss iovss sg13_hv_nmos ad=0.68p pd=4.68u as=0 ps=0 w=2u l=6u
X115 iovdd s2d_block_0.s2d_casc_p_f_0.vbpc iovdd iovdd sg13_hv_pmos ad=0.34p pd=2.68u as=0 ps=0 w=1u l=4u
X116 a_11758_26326# a_14374_26190# iovss rhigh l=12.65u w=0.5u
X117 s2d_block_0.s2d_tails_lo_f_0.sb_A1 vref s2d_block_0.s2d_casc_n_f_0.x s2d_block_0.s2d_tails_lo_f_0.sb_A1 sg13_hv_pmos ad=3.4p pd=20.68u as=1.9p ps=10.38u w=10u l=1u
X118 s2d_block_0.s2d_casc_n_f_0.x s2d_block_0.sinks_6x6_s2d_c3_core_0.vbn iovss iovss sg13_hv_nmos ad=2.04p pd=12.68u as=2.04p ps=12.68u w=6u l=6u
X119 iovdd Clamp_P_M1_0.gate pad iovdd sg13_hv_pmos ad=2.1312p pd=7.3u as=3.9294p ps=7.84u w=6.66u l=0.6u
X120 s2d_block_0.s2d_tails_lo_f_0.sb_M1 a_14374_27686# iovss rhigh l=12.65u w=0.5u
X121 iovss s2d_block_0.sinks_6x6_s2d_c3_core_0.vbn iovss iovss sg13_hv_nmos ad=0.68p pd=4.68u as=0 ps=0 w=2u l=6u
X122 iovdd Clamp_P_M1_0.gate pad iovdd sg13_hv_pmos ad=2.1312p pd=7.3u as=3.9294p ps=7.84u w=6.66u l=0.6u
X123 s2d_block_0.s2d_tails_hi_f_0.sa_A1 pad s2d_block_0.s2d_casc_n_f_0.y s2d_block_0.s2d_tails_hi_f_0.sa_A1 sg13_hv_pmos ad=3.4p pd=20.68u as=1.9p ps=10.38u w=10u l=1u
X124 s2d_block_0.s2d_tails_lo_f_0.sb_M1 s2d_block_0.s2d_tails_hi_f_0.vbp iovdd iovdd sg13_hv_pmos ad=1.7p pd=10.68u as=1.7p ps=10.68u w=5u l=6u
X125 pad Clamp_P_M1_0.gate iovdd iovdd sg13_hv_pmos ad=3.9294p pd=7.84u as=2.1312p ps=7.3u w=6.66u l=0.6u
X126 iovdd iovdd iovdd iovdd sg13_hv_pmos ad=3.4p pd=20.68u as=0 ps=0 w=10u l=1u
X127 a_11758_26326# a_14374_27822# iovss rhigh l=12.65u w=0.5u
X128 s2d_block_0.s2d_casc_n_f_0.xc s2d_block_0.sinks_6x6_s2d_c3_core_0.vbn iovss iovss sg13_hv_nmos ad=2.04p pd=12.68u as=2.04p ps=12.68u w=6u l=6u
X129 pad Clamp_N_M1_0.gate iovss iovss sg13_hv_nmos ad=2.596p pd=5.58u as=1.408p ps=5.04u w=4.4u l=0.6u
X130 pad Clamp_N_M1_0.gate iovss iovss sg13_hv_nmos ad=2.596p pd=5.58u as=1.408p ps=5.04u w=4.4u l=0.6u
X131 iovdd Clamp_P_M1_0.gate pad iovdd sg13_hv_pmos ad=2.1312p pd=7.3u as=3.9294p ps=7.84u w=6.66u l=0.6u
X132 s2d_block_0.bias_tree_noab_n_c3_0.ni en_3v3_b iref iovdd sg13_hv_pmos ad=0.34p pd=2.68u as=0.34p ps=2.68u w=1u l=0.45u
X133 pad Clamp_P_M1_0.gate iovdd iovdd sg13_hv_pmos ad=3.9294p pd=7.84u as=3.1302p ps=14.26u w=6.66u l=0.6u
X134 pad Clamp_N_M1_0.gate iovss iovss sg13_hv_nmos ad=2.596p pd=5.58u as=1.408p ps=5.04u w=4.4u l=0.6u
X135 a_11758_26462# a_14374_26054# iovss rhigh l=12.65u w=0.5u
X136 s2d_block_0.s2d_loads_f_0.dd s2d_block_0.s2d_loads_f_0.vcmfb iovdd iovdd sg13_hv_pmos ad=2.04p pd=12.68u as=2.04p ps=12.68u w=6u l=4u
X137 iovss s2d_block_0.sinks_6x6_s2d_c3_core_0.vbn iovss iovss sg13_hv_nmos ad=0.68p pd=4.68u as=0 ps=0 w=2u l=6u
X138 iovdd iovdd iovdd iovdd sg13_hv_pmos ad=1.9p pd=10.38u as=0 ps=0 w=10u l=1u
X139 s2d_block_0.s2d_loads_f_0.vcmfb s2d_block_0.s2d_casc_p_f_0.vbpc s2d_block_0.s2d_loads_f_0.dd iovdd sg13_hv_pmos ad=5.1p pd=30.68u as=5.1p ps=30.68u w=15u l=3u
X140 iovdd s2d_block_0.s2d_tails_hi_f_0.vbp s2d_block_0.s2d_tails_hi_f_0.vbp iovdd sg13_hv_pmos ad=1.7p pd=10.68u as=1.7p ps=10.68u w=5u l=6u
X141 s2d_block_0.bias_tree_noab_n_c3_0.ni s2d_block_0.bias_tree_noab_n_c3_0.ni iovss iovss sg13_hv_nmos ad=2.04p pd=12.68u as=2.04p ps=12.68u w=6u l=6u
X142 iovdd Clamp_P_M1_0.gate pad iovdd sg13_hv_pmos ad=2.1312p pd=7.3u as=3.9294p ps=7.84u w=6.66u l=0.6u
X143 s2d_block_0.s2d_tails_lo_f_0.sa_M2 s2d_block_0.s2d_tails_hi_f_0.vbp iovdd iovdd sg13_hv_pmos ad=1.7p pd=10.68u as=1.7p ps=10.68u w=5u l=6u
X144 outn s2d_block_0.s2d_casc_n_f_0.vbnc s2d_block_0.s2d_casc_n_f_0.y iovss sg13_hv_nmos ad=5.1p pd=30.68u as=5.1p ps=30.68u w=15u l=3u
X145 iovdd Clamp_P_M1_0.gate pad iovdd sg13_hv_pmos ad=2.1312p pd=7.3u as=3.9294p ps=7.84u w=6.66u l=0.6u
X146 iovdd Clamp_P_M1_0.gate pad iovdd sg13_hv_pmos ad=2.1312p pd=7.3u as=3.9294p ps=7.84u w=6.66u l=0.6u
X147 s2d_block_0.s2d_casc_n_f_0.yc s2d_block_0.sinks_6x6_s2d_c3_core_0.vbn iovss iovss sg13_hv_nmos ad=2.04p pd=12.68u as=2.04p ps=12.68u w=6u l=6u
X148 s2d_block_0.s2d_casc_n_f_0.xc vcm s2d_block_0.s2d_tails_hi_f_0.sb_M2 s2d_block_0.s2d_tails_hi_f_0.sb_M2 sg13_hv_pmos ad=1.9p pd=10.38u as=3.4p ps=20.68u w=10u l=1u
X149 s2d_block_0.s2d_casc_n_f_0.y outn s2d_block_0.s2d_tails_lo_f_0.sa_F2 s2d_block_0.s2d_tails_lo_f_0.sa_F2 sg13_hv_pmos ad=1.9p pd=10.38u as=3.4p ps=20.68u w=10u l=1u
X150 s2d_block_0.s2d_tails_hi_f_0.sa_M1 outp s2d_block_0.s2d_casc_n_f_0.yc s2d_block_0.s2d_tails_hi_f_0.sa_M1 sg13_hv_pmos ad=3.4p pd=20.68u as=1.9p ps=10.38u w=10u l=1u
X151 pad Clamp_P_M1_0.gate iovdd iovdd sg13_hv_pmos ad=3.9294p pd=7.84u as=2.1312p ps=7.3u w=6.66u l=0.6u
X152 s2d_block_0.s2d_tails_lo_f_0.sa_F2 a_14374_25918# iovss rhigh l=12.65u w=0.5u
X153 s2d_block_0.sinks_6x6_s2d_c3_core_0.vbn s2d_block_0.sinks_6x6_s2d_c3_core_0.vbn iovss iovss sg13_hv_nmos ad=2.04p pd=12.68u as=2.04p ps=12.68u w=6u l=6u
X154 iovdd Clamp_P_M1_0.gate pad iovdd sg13_hv_pmos ad=2.1312p pd=7.3u as=3.9294p ps=7.84u w=6.66u l=0.6u
X155 iovss s2d_block_0.s2d_casc_n_f_0.vbnc iovss iovss sg13_hv_nmos ad=0.68p pd=4.68u as=0 ps=0 w=2u l=3u
X156 s2d_block_0.s2d_tails_lo_f_0.sa_F2 s2d_block_0.s2d_tails_hi_f_0.vbp iovdd iovdd sg13_hv_pmos ad=1.7p pd=10.68u as=1.7p ps=10.68u w=5u l=6u
X157 iovss Clamp_N_M1_0.gate pad iovss sg13_hv_nmos ad=1.408p pd=5.04u as=2.596p ps=5.58u w=4.4u l=0.6u
X158 s2d_block_0.s2d_tails_lo_f_0.sb_A2 vref s2d_block_0.s2d_casc_n_f_0.x s2d_block_0.s2d_tails_lo_f_0.sb_A2 sg13_hv_pmos ad=3.4p pd=20.68u as=1.9p ps=10.38u w=10u l=1u
X159 pad Clamp_N_M1_0.gate iovss iovss sg13_hv_nmos ad=2.596p pd=5.58u as=1.408p ps=5.04u w=4.4u l=0.6u
X160 a_11758_26462# a_14374_27686# iovss rhigh l=12.65u w=0.5u
X161 s2d_block_0.s2d_casc_n_f_0.x s2d_block_0.sinks_6x6_s2d_c3_core_0.vbn iovss iovss sg13_hv_nmos ad=2.04p pd=12.68u as=2.04p ps=12.68u w=6u l=6u
X162 iovdd Clamp_P_M1_0.gate pad iovdd sg13_hv_pmos ad=2.1312p pd=7.3u as=3.9294p ps=7.84u w=6.66u l=0.6u
X163 s2d_block_0.s2d_tails_hi_f_0.vbp s2d_block_0.bias_tree_noab_n_c3_0.ni iovss iovss sg13_hv_nmos ad=2.04p pd=12.68u as=2.04p ps=12.68u w=6u l=6u
X164 pad Clamp_P_M1_0.gate iovdd iovdd sg13_hv_pmos ad=3.9294p pd=7.84u as=3.1302p ps=14.26u w=6.66u l=0.6u
X165 iovdd iovdd iovdd iovdd sg13_hv_pmos ad=3.4p pd=20.68u as=0 ps=0 w=10u l=1u
X166 iovss s2d_block_0.sinks_6x6_s2d_c3_core_0.vbn s2d_block_0.s2d_casc_n_f_0.xc iovss sg13_hv_nmos ad=2.04p pd=12.68u as=2.04p ps=12.68u w=6u l=6u
X167 Clamp_N_M1_0.gate iovss iovss rppd l=3.54u w=0.5u
X168 iovdd Clamp_P_M1_0.gate pad iovdd sg13_hv_pmos ad=2.1312p pd=7.3u as=3.9294p ps=7.84u w=6.66u l=0.6u
X169 iovss s2d_block_0.s2d_casc_n_f_0.vbnc iovss iovss sg13_hv_nmos ad=0.68p pd=4.68u as=0 ps=0 w=2u l=3u
X170 iovdd iovdd iovdd iovdd sg13_hv_pmos ad=1.9p pd=10.38u as=0 ps=0 w=10u l=1u
X171 s2d_block_0.s2d_tails_lo_f_0.sb_A1 s2d_block_0.s2d_tails_hi_f_0.vbp iovdd iovdd sg13_hv_pmos ad=1.7p pd=10.68u as=1.7p ps=10.68u w=5u l=6u
X172 pad Clamp_P_M1_0.gate iovdd iovdd sg13_hv_pmos ad=3.9294p pd=7.84u as=2.1312p ps=7.3u w=6.66u l=0.6u
X173 a_11758_26734# a_14374_27414# iovss rhigh l=12.65u w=0.5u
X174 pad Clamp_P_M1_0.gate iovdd iovdd sg13_hv_pmos ad=3.9294p pd=7.84u as=2.1312p ps=7.3u w=6.66u l=0.6u
X175 iovdd Clamp_P_M1_0.gate pad iovdd sg13_hv_pmos ad=2.1312p pd=7.3u as=3.9294p ps=7.84u w=6.66u l=0.6u
X176 iovdd Clamp_P_M1_0.gate pad iovdd sg13_hv_pmos ad=3.1302p pd=14.26u as=3.9294p ps=7.84u w=6.66u l=0.6u
X177 outn s2d_block_0.s2d_casc_p_f_0.vbpc s2d_block_0.s2d_loads_f_0.ln iovdd sg13_hv_pmos ad=5.1p pd=30.68u as=5.1p ps=30.68u w=15u l=3u
X178 s2d_block_0.s2d_casc_n_f_0.y pad s2d_block_0.s2d_tails_hi_f_0.sa_A2 s2d_block_0.s2d_tails_hi_f_0.sa_A2 sg13_hv_pmos ad=1.9p pd=10.38u as=3.4p ps=20.68u w=10u l=1u
X179 pad Clamp_P_M1_0.gate iovdd iovdd sg13_hv_pmos ad=3.9294p pd=7.84u as=2.1312p ps=7.3u w=6.66u l=0.6u
X180 iovss Clamp_N_M1_0.gate pad iovss sg13_hv_nmos ad=1.408p pd=5.04u as=2.596p ps=5.58u w=4.4u l=0.6u
X181 s2d_block_0.s2d_casc_n_f_0.yc outn s2d_block_0.s2d_tails_lo_f_0.sa_M2 s2d_block_0.s2d_tails_lo_f_0.sa_M2 sg13_hv_pmos ad=1.9p pd=10.38u as=3.4p ps=20.68u w=10u l=1u
X182 s2d_block_0.s2d_tails_lo_f_0.sb_A2 s2d_block_0.s2d_tails_hi_f_0.vbp iovdd iovdd sg13_hv_pmos ad=1.7p pd=10.68u as=1.7p ps=10.68u w=5u l=6u
X183 iovss s2d_block_0.sinks_6x6_s2d_c3_core_0.vbn s2d_block_0.s2d_casc_n_f_0.x iovss sg13_hv_nmos ad=2.04p pd=12.68u as=2.04p ps=12.68u w=6u l=6u
X184 iovss Clamp_N_M1_0.gate pad iovss sg13_hv_nmos ad=1.408p pd=5.04u as=2.596p ps=5.58u w=4.4u l=0.6u
X185 s2d_block_0.s2d_loads_f_0.lp s2d_block_0.s2d_loads_f_0.vcmfb iovdd iovdd sg13_hv_pmos ad=2.04p pd=12.68u as=2.04p ps=12.68u w=6u l=4u
X186 s2d_block_0.sinks_6x6_s2d_c3_core_0.vbn s2d_block_0.s2d_tails_hi_f_0.vbp iovdd iovdd sg13_hv_pmos ad=1.7p pd=10.68u as=1.7p ps=10.68u w=5u l=6u
X187 s2d_block_0.s2d_tails_lo_f_0.sb_M1 vcm s2d_block_0.s2d_casc_n_f_0.xc s2d_block_0.s2d_tails_lo_f_0.sb_M1 sg13_hv_pmos ad=3.4p pd=20.68u as=1.9p ps=10.38u w=10u l=1u
X188 outp s2d_block_0.s2d_casc_n_f_0.vbnc s2d_block_0.s2d_casc_n_f_0.x iovss sg13_hv_nmos ad=5.1p pd=30.68u as=5.1p ps=30.68u w=15u l=3u
X189 s2d_block_0.s2d_tails_hi_f_0.sa_M1 a_14374_26054# iovss rhigh l=12.65u w=0.5u
X190 iovss Clamp_N_M1_0.gate pad iovss sg13_hv_nmos ad=1.408p pd=5.04u as=2.596p ps=5.58u w=4.4u l=0.6u
X191 iovss s2d_block_0.s2d_casc_n_f_0.vbnc iovss iovss sg13_hv_nmos ad=0.68p pd=4.68u as=0 ps=0 w=2u l=3u
X192 iovss s2d_block_0.sinks_6x6_s2d_c3_core_0.vbn s2d_block_0.s2d_casc_n_f_0.x iovss sg13_hv_nmos ad=2.04p pd=12.68u as=2.04p ps=12.68u w=6u l=6u
X193 iovss s2d_block_0.sinks_6x6_s2d_c3_core_0.vbn iovss iovss sg13_hv_nmos ad=0.68p pd=4.68u as=0 ps=0 w=2u l=6u
X194 iovdd s2d_block_0.s2d_loads_f_0.vcmfb iovdd iovdd sg13_hv_pmos ad=0.34p pd=2.68u as=0 ps=0 w=1u l=4u
X195 outn en_3v3_b vcm iovss sg13_hv_nmos ad=0.34p pd=2.68u as=0.19p ps=1.38u w=1u l=0.45u
X196 s2d_block_0.s2d_tails_hi_f_0.sb_F2 vcm s2d_block_0.s2d_casc_n_f_0.x s2d_block_0.s2d_tails_hi_f_0.sb_F2 sg13_hv_pmos ad=3.4p pd=20.68u as=1.9p ps=10.38u w=10u l=1u
X197 iovss s2d_block_0.sinks_6x6_s2d_c3_core_0.vbn iovss iovss sg13_hv_nmos ad=0.68p pd=4.68u as=0 ps=0 w=2u l=6u
X198 s2d_block_0.s2d_casc_n_f_0.x s2d_block_0.sinks_6x6_s2d_c3_core_0.vbn iovss iovss sg13_hv_nmos ad=2.04p pd=12.68u as=2.04p ps=12.68u w=6u l=6u
X199 s2d_block_0.s2d_casc_n_f_0.y pad s2d_block_0.s2d_tails_hi_f_0.sa_A1 s2d_block_0.s2d_tails_hi_f_0.sa_A1 sg13_hv_pmos ad=1.9p pd=10.38u as=3.4p ps=20.68u w=10u l=1u
X200 s2d_block_0.s2d_tails_lo_f_0.sb_A1 a_14374_27142# iovss rhigh l=12.65u w=0.5u
X201 iovdd s2d_block_0.s2d_loads_f_0.vcmfb s2d_block_0.s2d_loads_f_0.dd iovdd sg13_hv_pmos ad=2.04p pd=12.68u as=2.04p ps=12.68u w=6u l=4u
X202 iovdd iovdd iovdd iovdd sg13_hv_pmos ad=1.9p pd=10.38u as=0 ps=0 w=10u l=1u
X203 iovdd Clamp_P_M1_0.gate pad iovdd sg13_hv_pmos ad=2.1312p pd=7.3u as=3.9294p ps=7.84u w=6.66u l=0.6u
X204 iovdd s2d_block_0.s2d_loads_f_0.vcmfb iovdd iovdd sg13_hv_pmos ad=0.34p pd=2.68u as=0 ps=0 w=1u l=4u
X205 a_11758_26598# a_14374_27550# iovss rhigh l=12.65u w=0.5u
X206 s2d_block_0.s2d_casc_n_f_0.xc s2d_block_0.s2d_casc_n_f_0.vbnc s2d_block_0.s2d_loads_f_0.vcmfb iovss sg13_hv_nmos ad=5.1p pd=30.68u as=5.1p ps=30.68u w=15u l=3u
X207 pad Clamp_P_M1_0.gate iovdd iovdd sg13_hv_pmos ad=3.9294p pd=7.84u as=2.1312p ps=7.3u w=6.66u l=0.6u
X208 s2d_block_0.s2d_tails_lo_f_0.sa_F1 s2d_block_0.s2d_tails_hi_f_0.vbp iovdd iovdd sg13_hv_pmos ad=1.7p pd=10.68u as=1.7p ps=10.68u w=5u l=6u
X209 iovdd Clamp_P_M1_0.gate pad iovdd sg13_hv_pmos ad=3.1302p pd=14.26u as=3.9294p ps=7.84u w=6.66u l=0.6u
X210 outp s2d_block_0.s2d_casc_p_f_0.vbpc s2d_block_0.s2d_loads_f_0.lp iovdd sg13_hv_pmos ad=5.1p pd=30.68u as=5.1p ps=30.68u w=15u l=3u
X211 iovdd s2d_block_0.s2d_tails_hi_f_0.vbp iovdd iovdd sg13_hv_pmos ad=0.68p pd=4.68u as=0 ps=0 w=2u l=6u
X212 a_11758_26870# a_14374_27278# iovss rhigh l=12.65u w=0.5u
X213 s2d_block_0.s2d_casc_n_f_0.vbnc s2d_block_0.s2d_casc_n_f_0.vbnc iovss iovss sg13_hv_nmos ad=0.34p pd=2.68u as=0.34p ps=2.68u w=1u l=8u
X214 pad Clamp_P_M1_0.gate iovdd iovdd sg13_hv_pmos ad=3.9294p pd=7.84u as=2.1312p ps=7.3u w=6.66u l=0.6u
X215 iovss s2d_block_0.sinks_6x6_s2d_c3_core_0.vbn s2d_block_0.s2d_casc_n_f_0.yc iovss sg13_hv_nmos ad=2.04p pd=12.68u as=2.04p ps=12.68u w=6u l=6u
X216 iovss Clamp_N_M1_0.gate pad iovss sg13_hv_nmos ad=1.408p pd=5.04u as=2.596p ps=5.58u w=4.4u l=0.6u
X217 s2d_block_0.s2d_tails_lo_f_0.sa_M2 a_14374_26190# iovss rhigh l=12.65u w=0.5u
X218 s2d_block_0.s2d_loads_f_0.vcmfb s2d_block_0.s2d_casc_n_f_0.vbnc s2d_block_0.s2d_casc_n_f_0.xc iovss sg13_hv_nmos ad=5.1p pd=30.68u as=5.1p ps=30.68u w=15u l=3u
X219 iovss pad dantenna l=1.26u w=27.78u
X220 s2d_block_0.s2d_loads_f_0.dd s2d_block_0.s2d_casc_p_f_0.vbpc s2d_block_0.s2d_loads_f_0.vcmfb iovdd sg13_hv_pmos ad=5.1p pd=30.68u as=5.1p ps=30.68u w=15u l=3u
X221 iovdd iovdd iovdd iovdd sg13_hv_pmos ad=3.4p pd=20.68u as=0 ps=0 w=10u l=1u
X222 s2d_block_0.s2d_casc_n_f_0.x vref s2d_block_0.s2d_tails_lo_f_0.sb_A1 s2d_block_0.s2d_tails_lo_f_0.sb_A1 sg13_hv_pmos ad=1.9p pd=10.38u as=3.4p ps=20.68u w=10u l=1u
X223 iovss Clamp_N_M1_0.gate pad iovss sg13_hv_nmos ad=1.408p pd=5.04u as=2.596p ps=5.58u w=4.4u l=0.6u
X224 iovss s2d_block_0.sinks_6x6_s2d_c3_core_0.vbn iovss iovss sg13_hv_nmos ad=0.68p pd=4.68u as=0 ps=0 w=2u l=6u
C0 s2d_block_0.s2d_casc_n_f_0.yc s2d_block_0.s2d_tails_hi_f_0.sb_F1 0.08747f
C1 a_11844_25374# s2d_block_0.s2d_casc_n_f_0.xc 0.01124f
C2 vdd s2d_block_0.s2d_casc_n_f_0.yc 0.02686f
C3 s2d_block_0.s2d_tails_hi_f_0.sb_F2 s2d_block_0.s2d_casc_n_f_0.yc 0.45586f
C4 vref outn 5.68618f
C5 s2d_block_0.s2d_tails_hi_f_0.sa_A2 iovdd 2.76407f
C6 vref pad 0.12553f
C7 s2d_block_0.s2d_tails_hi_f_0.sa_A2 s2d_block_0.s2d_tails_hi_f_0.sb_F1 0.28064f
C8 vcm s2d_block_0.s2d_casc_n_f_0.x 0.63386f
C9 s2d_block_0.s2d_loads_f_0.ln s2d_block_0.s2d_loads_f_0.lp 5.83659f
C10 s2d_block_0.s2d_tails_lo_f_0.sb_A1 s2d_block_0.s2d_tails_lo_f_0.sb_A2 0.36686f
C11 s2d_block_0.s2d_tails_lo_f_0.sa_M2 s2d_block_0.s2d_tails_hi_f_0.sa_M1 0.33016f
C12 s2d_block_0.s2d_tails_hi_f_0.sa_A2 vdd 0.1052f
C13 outp s2d_block_0.s2d_casc_n_f_0.vbnc 9.68843f
C14 s2d_block_0.s2d_tails_hi_f_0.sb_F2 s2d_block_0.s2d_tails_hi_f_0.sa_A2 0.02442f
C15 a_11844_28638# a_11844_28774# 0.63642f
C16 s2d_block_0.s2d_loads_f_0.dd s2d_block_0.s2d_casc_p_f_0.vbpc 1.62631f
C17 iovdd s2d_block_0.s2d_tails_hi_f_0.sb_M2 0.96214f
C18 a_11844_25782# s2d_block_0.s2d_tails_lo_f_0.sa_F1 0.01924f
C19 a_11758_26462# a_11844_27686# 0.01935f
C20 s2d_block_0.s2d_tails_hi_f_0.sb_M2 s2d_block_0.s2d_tails_hi_f_0.sb_F1 0.03169f
C21 s2d_block_0.s2d_tails_lo_f_0.sa_F2 s2d_block_0.s2d_tails_lo_f_0.sa_M2 0.93094f
C22 Clamp_N_M1_0.gate s2d_block_0.s2d_casc_n_f_0.xc 0.01061f
C23 vdd s2d_block_0.s2d_tails_hi_f_0.sb_M2 0.09122f
C24 s2d_block_0.s2d_tails_hi_f_0.sb_F2 s2d_block_0.s2d_tails_hi_f_0.sb_M2 0.03285f
C25 s2d_block_0.s2d_loads_f_0.ln s2d_block_0.sinks_6x6_s2d_c3_core_0.vbn 0.01344f
C26 vcm s2d_block_0.s2d_casc_n_f_0.xc 1.31473f
C27 vref s2d_block_0.s2d_tails_lo_f_0.sa_F1 0.06209f
C28 s2d_block_0.s2d_tails_hi_f_0.sa_A1 s2d_block_0.s2d_tails_hi_f_0.sa_M1 0.17778f
C29 a_11844_26190# s2d_block_0.s2d_tails_hi_f_0.sa_M1 0.03973f
C30 a_11844_26462# a_11844_26598# 0.63642f
C31 s2d_block_0.s2d_casc_n_f_0.yc s2d_block_0.s2d_tails_lo_f_0.sa_M2 1.21104f
C32 outn s2d_block_0.s2d_tails_lo_f_0.sb_A1 0.03508f
C33 pad s2d_block_0.s2d_tails_lo_f_0.sb_A1 0.02754f
C34 s2d_block_0.s2d_tails_hi_f_0.sa_A1 s2d_block_0.s2d_tails_lo_f_0.sa_F2 0.04602f
C35 vref s2d_block_0.s2d_casc_n_f_0.y 1.67038f
C36 vdd a_11758_26462# 0.0103f
C37 s2d_block_0.s2d_tails_hi_f_0.sa_A2 s2d_block_0.s2d_tails_lo_f_0.sa_M2 0.03149f
C38 outp s2d_block_0.s2d_tails_hi_f_0.sa_M1 3.64047f
C39 s2d_block_0.s2d_loads_f_0.lp s2d_block_0.sinks_6x6_s2d_c3_core_0.vbn 0.25039f
C40 a_11844_25646# s2d_block_0.s2d_tails_hi_f_0.sb_F1 0.01133f
C41 s2d_block_0.s2d_tails_hi_f_0.sa_A2 a_11844_25510# 0.01204f
C42 s2d_block_0.s2d_tails_hi_f_0.sb_F2 a_11844_25646# 0.02158f
C43 s2d_block_0.s2d_tails_lo_f_0.sb_M1 s2d_block_0.s2d_tails_hi_f_0.sa_M1 0.05443f
C44 s2d_block_0.s2d_casc_n_f_0.xc s2d_block_0.s2d_casc_p_f_0.vbpc 0.11566f
C45 s2d_block_0.s2d_tails_lo_f_0.sb_A1 s2d_block_0.s2d_tails_lo_f_0.sa_F1 0.84022f
C46 outp s2d_block_0.s2d_tails_lo_f_0.sa_F2 0.01951f
C47 en_3v3_b iovdd 0.41196f
C48 a_11844_27958# s2d_block_0.s2d_tails_hi_f_0.sb_M2 0.01935f
C49 s2d_block_0.s2d_tails_hi_f_0.sa_A2 s2d_block_0.s2d_tails_hi_f_0.sa_A1 5.41603f
C50 s2d_block_0.s2d_tails_lo_f_0.sa_F2 s2d_block_0.s2d_tails_lo_f_0.sb_M1 0.05732f
C51 s2d_block_0.s2d_casc_n_f_0.y s2d_block_0.s2d_tails_lo_f_0.sb_A1 0.19349f
C52 en_3v3_b vdd 2.65677f
C53 outp s2d_block_0.s2d_casc_n_f_0.yc 0.85589f
C54 a_11844_28638# s2d_block_0.s2d_tails_hi_f_0.sb_F1 0.01626f
C55 iovdd s2d_block_0.s2d_tails_hi_f_0.vbp 67.0717f
C56 a_11758_26598# s2d_block_0.s2d_tails_lo_f_0.sb_A1 0.01794f
C57 s2d_block_0.s2d_tails_hi_f_0.sa_A1 s2d_block_0.s2d_tails_hi_f_0.sb_M2 0.13856f
C58 a_14374_27414# s2d_block_0.sinks_6x6_s2d_c3_core_0.vbn 0.0119f
C59 s2d_block_0.s2d_tails_hi_f_0.vbp s2d_block_0.s2d_tails_hi_f_0.sb_F1 0.2455f
C60 s2d_block_0.s2d_casc_n_f_0.yc s2d_block_0.s2d_tails_lo_f_0.sb_M1 0.22904f
C61 vdd s2d_block_0.s2d_tails_hi_f_0.vbp 3.45659f
C62 s2d_block_0.s2d_tails_hi_f_0.sb_F2 s2d_block_0.s2d_tails_hi_f_0.vbp 0.75445f
C63 a_11844_28094# a_14374_27686# 0.02728f
C64 s2d_block_0.s2d_tails_hi_f_0.sa_A2 outp 0.02586f
C65 s2d_block_0.s2d_loads_f_0.dd s2d_block_0.s2d_casc_n_f_0.xc 0.55573f
C66 a_14374_25510# a_14374_27142# 0.27561f
C67 s2d_block_0.s2d_tails_hi_f_0.sa_A2 s2d_block_0.s2d_tails_lo_f_0.sb_M1 0.04748f
C68 a_11844_26870# a_11844_27006# 0.63642f
C69 outp s2d_block_0.s2d_tails_hi_f_0.sb_M2 0.85296f
C70 a_11844_25646# a_11844_25510# 0.63642f
C71 a_11844_27414# a_11844_27550# 0.63642f
C72 s2d_block_0.s2d_tails_lo_f_0.sb_M1 s2d_block_0.s2d_tails_hi_f_0.sb_M2 0.34748f
C73 s2d_block_0.s2d_tails_hi_f_0.sa_A1 a_11844_25646# 0.01445f
C74 iovdd s2d_block_0.s2d_tails_lo_f_0.sb_A2 1.27591f
C75 outn s2d_block_0.s2d_loads_f_0.vcmfb 4.45704f
C76 a_11844_26326# a_14374_26190# 0.02746f
C77 a_11844_25918# a_14374_25918# 0.02719f
C78 s2d_block_0.s2d_casc_n_f_0.vbnc s2d_block_0.sinks_6x6_s2d_c3_core_0.vbn 7.23477f
C79 s2d_block_0.s2d_tails_hi_f_0.vbp s2d_block_0.s2d_tails_lo_f_0.sa_M2 0.4559f
C80 s2d_block_0.s2d_tails_hi_f_0.sb_F1 s2d_block_0.s2d_tails_lo_f_0.sb_A2 0.58509f
C81 s2d_block_0.s2d_casc_n_f_0.x s2d_block_0.s2d_casc_n_f_0.xc 0.32431f
C82 s2d_block_0.s2d_tails_hi_f_0.sb_F2 a_11844_26734# 0.02221f
C83 s2d_block_0.s2d_tails_hi_f_0.sb_F2 s2d_block_0.s2d_tails_lo_f_0.sb_A2 2.29219f
C84 a_11758_26462# s2d_block_0.s2d_tails_lo_f_0.sb_M1 0.04781f
C85 vdd a_11844_27278# 0.01422f
C86 s2d_block_0.s2d_tails_hi_f_0.sb_F2 a_11844_27278# 0.02318f
C87 s2d_block_0.s2d_tails_hi_f_0.sa_A1 a_11844_28638# 0.01046f
C88 iref s2d_block_0.bias_tree_noab_n_c3_0.ni 0.20242f
C89 s2d_block_0.s2d_tails_hi_f_0.sa_A1 s2d_block_0.s2d_tails_hi_f_0.vbp 0.29449f
C90 outn iovdd 17.1159f
C91 pad iovdd 40.2322f
C92 s2d_block_0.s2d_loads_f_0.ln s2d_block_0.s2d_casc_n_f_0.yc 0.8848f
C93 outn s2d_block_0.s2d_tails_hi_f_0.sb_F1 2.08525f
C94 pad s2d_block_0.s2d_tails_hi_f_0.sb_F1 0.25447f
C95 vref vcm 0.29438f
C96 outn vdd 4.12076f
C97 en_3v3_b outp 1.72266f
C98 s2d_block_0.s2d_tails_hi_f_0.sb_F2 outn 0.1826f
C99 pad vdd 0.09288f
C100 s2d_block_0.s2d_tails_hi_f_0.sb_F2 pad 0.22487f
C101 a_14374_27278# a_14374_27142# 1.23642f
C102 s2d_block_0.s2d_loads_f_0.vcmfb s2d_block_0.s2d_casc_n_f_0.y 0.21086f
C103 outp s2d_block_0.s2d_tails_hi_f_0.vbp 0.19183f
C104 iovdd s2d_block_0.s2d_tails_lo_f_0.sa_F1 1.86567f
C105 s2d_block_0.s2d_casc_n_f_0.yc s2d_block_0.s2d_loads_f_0.lp 0.21417f
C106 a_11758_26870# a_11758_26734# 0.55763f
C107 s2d_block_0.s2d_tails_lo_f_0.sa_F2 s2d_block_0.sinks_6x6_s2d_c3_core_0.vbn 3.85824f
C108 s2d_block_0.s2d_tails_lo_f_0.sa_F1 s2d_block_0.s2d_tails_hi_f_0.sb_F1 1.04342f
C109 s2d_block_0.s2d_tails_hi_f_0.vbp s2d_block_0.s2d_tails_lo_f_0.sb_M1 0.26594f
C110 a_11844_27822# a_14374_27822# 0.02746f
C111 a_11844_27414# a_14374_27414# 0.02713f
C112 a_11844_27686# a_14374_27686# 0.02728f
C113 a_11844_27550# a_14374_27550# 0.02719f
C114 iovdd s2d_block_0.s2d_casc_n_f_0.y 15.5794f
C115 s2d_block_0.s2d_tails_hi_f_0.sa_A1 s2d_block_0.s2d_tails_lo_f_0.sb_A2 3.43851f
C116 s2d_block_0.s2d_casc_n_f_0.y s2d_block_0.s2d_tails_hi_f_0.sb_F1 0.22739f
C117 a_11844_25918# s2d_block_0.s2d_tails_hi_f_0.sa_M1 0.03426f
C118 s2d_block_0.s2d_casc_n_f_0.yc s2d_block_0.sinks_6x6_s2d_c3_core_0.vbn 5.71059f
C119 outn s2d_block_0.s2d_tails_lo_f_0.sa_M2 3.08404f
C120 pad s2d_block_0.s2d_tails_lo_f_0.sa_M2 0.07823f
C121 vdd s2d_block_0.s2d_casc_n_f_0.y 0.06408f
C122 a_11844_26734# a_14374_25782# 0.02713f
C123 s2d_block_0.s2d_tails_hi_f_0.sb_F2 s2d_block_0.s2d_casc_n_f_0.y 0.45356f
C124 iref s2d_block_0.s2d_casc_p_f_0.vbpc 0.23455f
C125 a_11844_25918# s2d_block_0.s2d_tails_lo_f_0.sa_F2 0.01924f
C126 outp s2d_block_0.s2d_tails_lo_f_0.sb_A2 0.86315f
C127 s2d_block_0.s2d_tails_hi_f_0.sa_A1 outn 0.02153f
C128 s2d_block_0.s2d_tails_hi_f_0.sa_A1 pad 2.83511f
C129 s2d_block_0.s2d_tails_lo_f_0.sa_M2 s2d_block_0.s2d_tails_lo_f_0.sa_F1 1.4446f
C130 s2d_block_0.s2d_tails_lo_f_0.sb_A1 s2d_block_0.s2d_casc_p_f_0.vbpc 0.02425f
C131 pad Clamp_P_M1_0.gate 19.5174f
C132 en_3v3_b en_3v3 0.28127f
C133 a_11758_26326# s2d_block_0.s2d_tails_hi_f_0.sb_M2 0.26248f
C134 s2d_block_0.s2d_tails_hi_f_0.sa_A2 a_11844_25918# 0.0208f
C135 outn outp 6.04102f
C136 en_3v3 s2d_block_0.s2d_tails_hi_f_0.vbp 0.03985f
C137 pad outp 5.72883f
C138 a_11758_26734# s2d_block_0.s2d_tails_lo_f_0.sb_A1 0.01181f
C139 s2d_block_0.s2d_tails_hi_f_0.sa_A1 s2d_block_0.s2d_tails_lo_f_0.sa_F1 0.0456f
C140 s2d_block_0.s2d_casc_n_f_0.yc s2d_block_0.s2d_casc_n_f_0.vbnc 1.55613f
C141 outn s2d_block_0.s2d_tails_lo_f_0.sb_M1 0.03057f
C142 a_11758_26462# a_11758_26326# 1.23642f
C143 pad s2d_block_0.s2d_tails_lo_f_0.sb_M1 0.0582f
C144 a_14374_27550# a_14374_27414# 0.78325f
C145 vref s2d_block_0.s2d_casc_n_f_0.x 1.49531f
C146 s2d_block_0.s2d_tails_hi_f_0.sa_A1 s2d_block_0.s2d_casc_n_f_0.y 1.19158f
C147 outp s2d_block_0.s2d_tails_lo_f_0.sa_F1 0.15505f
C148 a_11758_27006# a_11844_27142# 0.01971f
C149 a_11844_25374# s2d_block_0.s2d_tails_hi_f_0.sb_F1 0.01737f
C150 en_3v3_b s2d_block_0.sinks_6x6_s2d_c3_core_0.vbn 0.79062f
C151 vref s2d_block_0.s2d_casc_n_f_0.xc 0.03603f
C152 s2d_block_0.s2d_tails_lo_f_0.sb_M1 s2d_block_0.s2d_tails_lo_f_0.sa_F1 1.43359f
C153 s2d_block_0.s2d_tails_lo_f_0.sa_F2 s2d_block_0.s2d_tails_hi_f_0.sa_M1 0.29686f
C154 s2d_block_0.s2d_tails_hi_f_0.sb_F2 a_11844_25374# 0.02389f
C155 outp s2d_block_0.s2d_casc_n_f_0.y 0.03439f
C156 iovdd s2d_block_0.bias_tree_noab_n_c3_0.ni 0.15021f
C157 a_11844_26190# a_14374_26190# 0.02746f
C158 s2d_block_0.s2d_casc_n_f_0.x s2d_block_0.s2d_tails_lo_f_0.sb_A1 1.08045f
C159 a_14374_26054# a_14374_25918# 0.55763f
C160 s2d_block_0.s2d_tails_hi_f_0.vbp s2d_block_0.sinks_6x6_s2d_c3_core_0.vbn 0.26763f
C161 s2d_block_0.s2d_casc_n_f_0.yc s2d_block_0.s2d_tails_hi_f_0.sa_M1 1.0972f
C162 vdd s2d_block_0.bias_tree_noab_n_c3_0.ni 1.76708f
C163 s2d_block_0.s2d_tails_hi_f_0.sb_F2 a_11844_26598# 0.02196f
C164 a_11758_26598# s2d_block_0.s2d_tails_lo_f_0.sb_M1 0.04807f
C165 vdd a_11844_27142# 0.01241f
C166 s2d_block_0.s2d_tails_hi_f_0.sb_F2 a_11844_27142# 0.02279f
C167 Clamp_N_M1_0.gate iovdd 0.31292f
C168 s2d_block_0.s2d_casc_n_f_0.yc s2d_block_0.s2d_tails_lo_f_0.sa_F2 0.01813f
C169 iovdd vcm 8.11465f
C170 s2d_block_0.s2d_tails_hi_f_0.sa_A2 s2d_block_0.s2d_tails_hi_f_0.sa_M1 2.31964f
C171 s2d_block_0.s2d_tails_lo_f_0.sb_A1 s2d_block_0.s2d_casc_n_f_0.xc 0.04313f
C172 vcm s2d_block_0.s2d_tails_hi_f_0.sb_F1 0.24994f
C173 outn en_3v3 2.58957f
C174 outn s2d_block_0.s2d_loads_f_0.ln 0.36237f
C175 s2d_block_0.s2d_loads_f_0.vcmfb s2d_block_0.s2d_casc_p_f_0.vbpc 2.11215f
C176 vdd vcm 1.91855f
C177 s2d_block_0.s2d_tails_hi_f_0.sb_F2 vcm 2.83453f
C178 s2d_block_0.s2d_tails_hi_f_0.sa_A2 s2d_block_0.s2d_tails_lo_f_0.sa_F2 0.02005f
C179 s2d_block_0.s2d_tails_hi_f_0.sb_M2 s2d_block_0.s2d_tails_hi_f_0.sa_M1 1.08556f
C180 a_11844_28094# a_11844_28230# 0.63642f
C181 a_11844_25374# a_11844_25510# 0.63642f
C182 s2d_block_0.s2d_tails_hi_f_0.sa_A1 a_11844_25374# 0.01837f
C183 iovdd s2d_block_0.s2d_casc_p_f_0.vbpc 35.0861f
C184 outn s2d_block_0.s2d_loads_f_0.lp 0.10561f
C185 s2d_block_0.s2d_tails_hi_f_0.vbp s2d_block_0.s2d_casc_n_f_0.vbnc 0.11962f
C186 a_11758_26598# a_11844_27550# 0.01938f
C187 s2d_block_0.s2d_casc_p_f_0.vbpc s2d_block_0.s2d_tails_hi_f_0.sb_F1 0.11357f
C188 s2d_block_0.s2d_casc_n_f_0.yc s2d_block_0.s2d_tails_hi_f_0.sb_M2 0.28733f
C189 vdd s2d_block_0.s2d_casc_p_f_0.vbpc 0.38387f
C190 s2d_block_0.s2d_tails_hi_f_0.sb_F2 s2d_block_0.s2d_casc_p_f_0.vbpc 0.02698f
C191 s2d_block_0.s2d_loads_f_0.dd s2d_block_0.s2d_loads_f_0.vcmfb 1.40683f
C192 a_11844_26326# a_11844_26462# 0.63642f
C193 outn s2d_block_0.sinks_6x6_s2d_c3_core_0.vbn 0.0235f
C194 pad s2d_block_0.sinks_6x6_s2d_c3_core_0.vbn 0.07772f
C195 s2d_block_0.s2d_tails_hi_f_0.sa_A2 s2d_block_0.s2d_tails_hi_f_0.sb_M2 0.30715f
C196 a_14374_25646# a_14374_25510# 1.23642f
C197 a_11844_25374# s2d_block_0.s2d_tails_lo_f_0.sb_M1 0.01449f
C198 s2d_block_0.s2d_tails_hi_f_0.sa_A1 vcm 0.02624f
C199 iovdd s2d_block_0.s2d_loads_f_0.dd 10.6422f
C200 s2d_block_0.s2d_casc_n_f_0.x s2d_block_0.s2d_loads_f_0.vcmfb 0.25703f
C201 a_11844_28502# a_14374_27278# 0.0271f
C202 a_11844_28638# s2d_block_0.s2d_tails_hi_f_0.sa_M1 0.02158f
C203 s2d_block_0.s2d_tails_lo_f_0.sa_M2 s2d_block_0.s2d_casc_p_f_0.vbpc 0.02058f
C204 s2d_block_0.s2d_tails_hi_f_0.vbp s2d_block_0.s2d_tails_hi_f_0.sa_M1 0.41199f
C205 s2d_block_0.s2d_tails_hi_f_0.sb_F2 a_11844_26054# 0.02158f
C206 s2d_block_0.s2d_tails_lo_f_0.sa_F2 s2d_block_0.s2d_tails_hi_f_0.vbp 0.35611f
C207 s2d_block_0.s2d_tails_hi_f_0.sa_A2 a_11844_25646# 0.08082f
C208 outp vcm 4.12593f
C209 s2d_block_0.s2d_loads_f_0.vcmfb s2d_block_0.s2d_casc_n_f_0.xc 1.61182f
C210 s2d_block_0.s2d_casc_n_f_0.y s2d_block_0.sinks_6x6_s2d_c3_core_0.vbn 11.4419f
C211 iovdd s2d_block_0.s2d_casc_n_f_0.x 8.59842f
C212 vcm s2d_block_0.s2d_tails_lo_f_0.sb_M1 2.76648f
C213 s2d_block_0.s2d_tails_hi_f_0.sa_A1 s2d_block_0.s2d_casc_p_f_0.vbpc 0.02514f
C214 s2d_block_0.s2d_casc_n_f_0.x s2d_block_0.s2d_tails_hi_f_0.sb_F1 1.40651f
C215 s2d_block_0.s2d_casc_n_f_0.yc s2d_block_0.s2d_tails_hi_f_0.vbp 0.07996f
C216 outn s2d_block_0.s2d_casc_n_f_0.vbnc 9.68851f
C217 vdd s2d_block_0.s2d_casc_n_f_0.x 0.04852f
C218 s2d_block_0.s2d_tails_hi_f_0.sb_F2 s2d_block_0.s2d_casc_n_f_0.x 4.74734f
C219 a_11844_27958# a_14374_27822# 0.02746f
C220 iovdd s2d_block_0.s2d_casc_n_f_0.xc 11.1139f
C221 s2d_block_0.s2d_tails_hi_f_0.sa_A2 s2d_block_0.s2d_tails_hi_f_0.vbp 0.27394f
C222 s2d_block_0.s2d_tails_lo_f_0.sb_A2 s2d_block_0.s2d_tails_hi_f_0.sa_M1 0.23951f
C223 s2d_block_0.s2d_casc_n_f_0.xc s2d_block_0.s2d_tails_hi_f_0.sb_F1 0.02742f
C224 a_11844_26734# a_11844_26870# 0.63642f
C225 outp s2d_block_0.s2d_casc_p_f_0.vbpc 1.4238f
C226 vdd s2d_block_0.s2d_casc_n_f_0.xc 0.02686f
C227 a_11844_27006# a_11844_27142# 0.63642f
C228 a_11844_27278# a_11844_27414# 0.63642f
C229 s2d_block_0.s2d_tails_hi_f_0.sb_F2 s2d_block_0.s2d_casc_n_f_0.xc 0.03286f
C230 a_11844_28230# s2d_block_0.s2d_tails_hi_f_0.sb_F1 0.03104f
C231 vref s2d_block_0.s2d_tails_lo_f_0.sb_A1 2.83346f
C232 s2d_block_0.s2d_tails_lo_f_0.sa_F2 s2d_block_0.s2d_tails_lo_f_0.sb_A2 0.0615f
C233 s2d_block_0.s2d_tails_lo_f_0.sb_M1 s2d_block_0.s2d_casc_p_f_0.vbpc 0.01817f
C234 s2d_block_0.s2d_tails_hi_f_0.vbp s2d_block_0.s2d_tails_hi_f_0.sb_M2 0.57373f
C235 s2d_block_0.s2d_tails_hi_f_0.sb_F2 a_11844_28230# 0.14087f
C236 en_3v3 s2d_block_0.bias_tree_noab_n_c3_0.ni 0.06138f
C237 a_11844_26190# a_11844_26054# 0.63642f
C238 s2d_block_0.s2d_casc_n_f_0.vbnc s2d_block_0.s2d_casc_n_f_0.y 2.09561f
C239 s2d_block_0.s2d_casc_n_f_0.yc s2d_block_0.s2d_tails_lo_f_0.sb_A2 0.0238f
C240 outn s2d_block_0.s2d_tails_hi_f_0.sa_M1 0.0232f
C241 pad s2d_block_0.s2d_tails_hi_f_0.sa_M1 0.07327f
C242 s2d_block_0.s2d_tails_hi_f_0.sb_F2 a_11844_26462# 0.02158f
C243 a_11844_28230# a_11844_28366# 0.63642f
C244 a_11758_26734# s2d_block_0.s2d_tails_lo_f_0.sb_M1 0.04819f
C245 outn s2d_block_0.s2d_tails_lo_f_0.sa_F2 2.79068f
C246 en_3v3 vcm 0.11407f
C247 outp s2d_block_0.s2d_loads_f_0.dd 0.0242f
C248 pad s2d_block_0.s2d_tails_lo_f_0.sa_F2 0.01954f
C249 s2d_block_0.s2d_tails_hi_f_0.sa_A2 s2d_block_0.s2d_tails_lo_f_0.sb_A2 0.08815f
C250 s2d_block_0.s2d_tails_lo_f_0.sa_M2 s2d_block_0.s2d_casc_n_f_0.xc 0.23201f
C251 s2d_block_0.s2d_tails_hi_f_0.sa_A1 s2d_block_0.s2d_casc_n_f_0.x 0.30215f
C252 a_11844_25374# s2d_block_0.sinks_6x6_s2d_c3_core_0.vbn 0.03386f
C253 outn s2d_block_0.s2d_casc_n_f_0.yc 0.87595f
C254 pad s2d_block_0.s2d_casc_n_f_0.yc 0.06508f
C255 s2d_block_0.s2d_tails_hi_f_0.sb_M2 s2d_block_0.s2d_tails_lo_f_0.sb_A2 1.43713f
C256 en_3v3_b s2d_block_0.s2d_tails_hi_f_0.vbp 0.22518f
C257 s2d_block_0.s2d_tails_lo_f_0.sa_F2 s2d_block_0.s2d_tails_lo_f_0.sa_F1 1.9391f
C258 s2d_block_0.sinks_6x6_s2d_c3_core_0.vbn s2d_block_0.bias_tree_noab_n_c3_0.ni 0.01864f
C259 s2d_block_0.s2d_tails_hi_f_0.sa_A2 outn 0.0227f
C260 outp s2d_block_0.s2d_casc_n_f_0.x 0.88028f
C261 s2d_block_0.s2d_tails_hi_f_0.sa_A2 pad 2.83313f
C262 en_3v3 s2d_block_0.s2d_casc_p_f_0.vbpc 0.15115f
C263 s2d_block_0.s2d_loads_f_0.ln s2d_block_0.s2d_casc_p_f_0.vbpc 1.72075f
C264 a_11758_27006# a_11758_26870# 0.33426f
C265 s2d_block_0.s2d_tails_lo_f_0.sa_F2 s2d_block_0.s2d_casc_n_f_0.y 1.20108f
C266 a_11844_27686# a_11844_27822# 0.63642f
C267 a_14374_25510# a_11844_25510# 0.02707f
C268 s2d_block_0.s2d_casc_n_f_0.yc s2d_block_0.s2d_tails_lo_f_0.sa_F1 0.02338f
C269 outn s2d_block_0.s2d_tails_hi_f_0.sb_M2 0.0267f
C270 Clamp_N_M1_0.gate s2d_block_0.sinks_6x6_s2d_c3_core_0.vbn 0.02015f
C271 pad s2d_block_0.s2d_tails_hi_f_0.sb_M2 0.06476f
C272 a_8120_4634# s2d_block_0.s2d_loads_f_0.vcmfb 0.01054f
C273 outp s2d_block_0.s2d_casc_n_f_0.xc 0.12019f
C274 s2d_block_0.s2d_casc_n_f_0.yc s2d_block_0.s2d_casc_n_f_0.y 1.84321f
C275 s2d_block_0.s2d_tails_hi_f_0.sa_A2 s2d_block_0.s2d_tails_lo_f_0.sa_F1 0.31556f
C276 a_11844_26598# a_14374_25918# 0.02719f
C277 s2d_block_0.s2d_tails_lo_f_0.sb_M1 s2d_block_0.s2d_casc_n_f_0.xc 1.17345f
C278 s2d_block_0.s2d_loads_f_0.lp s2d_block_0.s2d_casc_p_f_0.vbpc 1.79896f
C279 vdd a_11844_27822# 0.02082f
C280 s2d_block_0.s2d_tails_hi_f_0.sb_F2 a_11844_27822# 0.03091f
C281 s2d_block_0.s2d_tails_hi_f_0.sa_A2 s2d_block_0.s2d_casc_n_f_0.y 1.08046f
C282 iovdd a_8120_4634# 0.08872f
C283 s2d_block_0.s2d_loads_f_0.dd s2d_block_0.s2d_loads_f_0.ln 12.7936f
C284 a_11844_25782# s2d_block_0.s2d_tails_hi_f_0.sb_F1 0.0102f
C285 s2d_block_0.s2d_tails_hi_f_0.vbp s2d_block_0.s2d_tails_lo_f_0.sb_A2 0.35797f
C286 s2d_block_0.sinks_6x6_s2d_c3_core_0.vbn s2d_block_0.s2d_casc_p_f_0.vbpc 0.03673f
C287 s2d_block_0.s2d_tails_hi_f_0.sb_F2 a_11844_25782# 0.02158f
C288 vref iovdd 0.92651f
C289 vref s2d_block_0.s2d_tails_hi_f_0.sb_F1 0.05463f
C290 en_3v3_b outn 0.23705f
C291 a_14374_27142# s2d_block_0.sinks_6x6_s2d_c3_core_0.vbn 0.02814f
C292 vref vdd 1.72018f
C293 s2d_block_0.s2d_tails_hi_f_0.sb_F2 vref 0.35903f
C294 Clamp_N_M1_0.gate s2d_block_0.s2d_casc_n_f_0.vbnc 0.01177f
C295 iref iovdd 0.39141f
C296 s2d_block_0.s2d_loads_f_0.dd s2d_block_0.s2d_loads_f_0.lp 3.89965f
C297 a_11844_28502# s2d_block_0.s2d_tails_hi_f_0.sb_F1 0.04221f
C298 vdd iref 1.71255f
C299 outn s2d_block_0.s2d_tails_hi_f_0.vbp 0.35916f
C300 pad s2d_block_0.s2d_tails_hi_f_0.vbp 0.03551f
C301 a_11758_26598# a_11758_26462# 1.00966f
C302 a_11844_27958# a_11844_27822# 0.63642f
C303 a_14374_27686# a_14374_27550# 0.55763f
C304 iovdd s2d_block_0.s2d_tails_lo_f_0.sb_A1 4.00879f
C305 s2d_block_0.s2d_loads_f_0.dd s2d_block_0.sinks_6x6_s2d_c3_core_0.vbn 0.01093f
C306 s2d_block_0.s2d_loads_f_0.ln s2d_block_0.s2d_casc_n_f_0.xc 0.17914f
C307 s2d_block_0.s2d_tails_lo_f_0.sb_A1 s2d_block_0.s2d_tails_hi_f_0.sb_F1 0.52239f
C308 a_11844_26598# s2d_block_0.s2d_tails_hi_f_0.sa_M1 0.01029f
C309 a_11844_27006# a_14374_25510# 0.02707f
C310 a_11844_28366# a_11844_28502# 0.63642f
C311 s2d_block_0.s2d_tails_hi_f_0.sb_F2 s2d_block_0.s2d_tails_lo_f_0.sb_A1 0.0325f
C312 vref s2d_block_0.s2d_tails_lo_f_0.sa_M2 0.06384f
C313 s2d_block_0.s2d_tails_hi_f_0.vbp s2d_block_0.s2d_tails_lo_f_0.sa_F1 0.26261f
C314 s2d_block_0.s2d_tails_hi_f_0.sb_F2 a_11844_28094# 0.07914f
C315 a_11844_25918# a_11844_26054# 0.63642f
C316 vcm s2d_block_0.s2d_tails_hi_f_0.sa_M1 0.14677f
C317 a_14374_26190# a_14374_26054# 0.33426f
C318 a_11844_25782# a_14374_25782# 0.02713f
C319 s2d_block_0.s2d_loads_f_0.lp s2d_block_0.s2d_casc_n_f_0.xc 0.26366f
C320 s2d_block_0.s2d_tails_hi_f_0.vbp s2d_block_0.s2d_casc_n_f_0.y 0.07156f
C321 s2d_block_0.s2d_casc_n_f_0.x s2d_block_0.sinks_6x6_s2d_c3_core_0.vbn 11.6306f
C322 Clamp_P_M1_0.gate a_8120_4634# 0.03336f
C323 outn s2d_block_0.s2d_tails_lo_f_0.sb_A2 0.04441f
C324 pad s2d_block_0.s2d_tails_lo_f_0.sb_A2 0.0387f
C325 s2d_block_0.s2d_tails_hi_f_0.sb_F2 a_11844_26326# 0.02158f
C326 a_11758_26870# s2d_block_0.s2d_tails_lo_f_0.sb_M1 0.0482f
C327 s2d_block_0.s2d_tails_hi_f_0.sa_A1 vref 0.01051f
C328 Clamp_N_M1_0.gate a_7760_4632# 0.02705f
C329 s2d_block_0.s2d_tails_lo_f_0.sa_M2 s2d_block_0.s2d_tails_lo_f_0.sb_A1 0.16443f
C330 s2d_block_0.sinks_6x6_s2d_c3_core_0.vbn s2d_block_0.s2d_casc_n_f_0.xc 5.64586f
C331 s2d_block_0.s2d_tails_hi_f_0.sa_A1 a_11844_28502# 0.01046f
C332 vcm s2d_block_0.s2d_casc_n_f_0.yc 0.10607f
C333 s2d_block_0.s2d_casc_p_f_0.vbpc s2d_block_0.s2d_tails_hi_f_0.sa_M1 0.02579f
C334 s2d_block_0.s2d_tails_lo_f_0.sa_F1 s2d_block_0.s2d_tails_lo_f_0.sb_A2 0.25628f
C335 outn pad 0.07331f
C336 vref outp 0.30567f
C337 a_11844_27958# a_11844_28094# 0.63642f
C338 s2d_block_0.s2d_tails_hi_f_0.sa_A2 vcm 0.02476f
C339 vref s2d_block_0.s2d_tails_lo_f_0.sb_M1 0.07439f
C340 s2d_block_0.s2d_tails_hi_f_0.sa_A1 s2d_block_0.s2d_tails_lo_f_0.sb_A1 0.04713f
C341 s2d_block_0.s2d_tails_lo_f_0.sa_F2 s2d_block_0.s2d_casc_p_f_0.vbpc 0.02327f
C342 s2d_block_0.s2d_casc_n_f_0.y s2d_block_0.s2d_tails_lo_f_0.sb_A2 0.34721f
C343 a_14374_25510# s2d_block_0.sinks_6x6_s2d_c3_core_0.vbn 0.03952f
C344 vcm s2d_block_0.s2d_tails_hi_f_0.sb_M2 2.97323f
C345 a_11758_26734# a_11844_27414# 0.01944f
C346 s2d_block_0.s2d_casc_n_f_0.x s2d_block_0.s2d_casc_n_f_0.vbnc 2.98545f
C347 s2d_block_0.s2d_casc_n_f_0.yc s2d_block_0.s2d_casc_p_f_0.vbpc 0.05993f
C348 outn s2d_block_0.s2d_tails_lo_f_0.sa_F1 0.02799f
C349 pad s2d_block_0.s2d_tails_lo_f_0.sa_F1 0.06589f
C350 iovdd s2d_block_0.s2d_loads_f_0.vcmfb 46.5827f
C351 outp s2d_block_0.s2d_tails_lo_f_0.sb_A1 0.98527f
C352 a_11844_26190# a_11844_26326# 0.63642f
C353 outn s2d_block_0.s2d_casc_n_f_0.y 0.87704f
C354 a_11844_26054# s2d_block_0.s2d_tails_hi_f_0.sa_M1 0.09778f
C355 s2d_block_0.s2d_tails_hi_f_0.sa_A2 s2d_block_0.s2d_casc_p_f_0.vbpc 0.02597f
C356 pad s2d_block_0.s2d_casc_n_f_0.y 1.37827f
C357 a_14374_25782# a_14374_25646# 1.00966f
C358 s2d_block_0.s2d_tails_lo_f_0.sb_M1 s2d_block_0.s2d_tails_lo_f_0.sb_A1 0.45675f
C359 s2d_block_0.s2d_casc_n_f_0.vbnc s2d_block_0.s2d_casc_n_f_0.xc 5.59245f
C360 a_11844_28094# s2d_block_0.s2d_tails_lo_f_0.sb_M1 0.02626f
C361 vdd a_11844_27686# 0.0197f
C362 s2d_block_0.s2d_tails_hi_f_0.sb_F2 a_11844_27686# 0.02672f
C363 en_3v3_b s2d_block_0.bias_tree_noab_n_c3_0.ni 0.29376f
C364 s2d_block_0.s2d_casc_p_f_0.vbpc s2d_block_0.s2d_tails_hi_f_0.sb_M2 0.02427f
C365 iovdd s2d_block_0.s2d_tails_hi_f_0.sb_F1 3.45493f
C366 s2d_block_0.s2d_loads_f_0.dd s2d_block_0.s2d_casc_n_f_0.yc 1.54595f
C367 s2d_block_0.s2d_tails_hi_f_0.sa_A1 a_11844_28774# 0.01266f
C368 vdd iovdd 5.96585f
C369 s2d_block_0.s2d_tails_hi_f_0.sb_F2 iovdd 7.02578f
C370 s2d_block_0.s2d_casc_n_f_0.y s2d_block_0.s2d_tails_lo_f_0.sa_F1 1.19633f
C371 s2d_block_0.s2d_tails_hi_f_0.vbp s2d_block_0.bias_tree_noab_n_c3_0.ni 0.46959f
C372 vdd s2d_block_0.s2d_tails_hi_f_0.sb_F1 0.10873f
C373 s2d_block_0.s2d_tails_hi_f_0.sb_F2 s2d_block_0.s2d_tails_hi_f_0.sb_F1 6.07872f
C374 en_3v3_b vcm 0.50727f
C375 s2d_block_0.s2d_tails_hi_f_0.sb_F2 vdd 0.10947f
C376 s2d_block_0.s2d_tails_lo_f_0.sa_F2 s2d_block_0.s2d_casc_n_f_0.x 0.15244f
C377 a_14374_27278# s2d_block_0.sinks_6x6_s2d_c3_core_0.vbn 0.01757f
C378 iref en_3v3 0.26074f
C379 s2d_block_0.s2d_casc_n_f_0.xc s2d_block_0.s2d_tails_hi_f_0.sa_M1 0.21204f
C380 vcm s2d_block_0.s2d_tails_hi_f_0.vbp 0.77904f
C381 a_14374_27414# a_14374_27278# 1.00966f
C382 a_11844_28366# s2d_block_0.s2d_tails_hi_f_0.sb_F1 0.12708f
C383 s2d_block_0.s2d_casc_n_f_0.yc s2d_block_0.s2d_casc_n_f_0.x 5.29006f
C384 s2d_block_0.s2d_tails_hi_f_0.sb_F2 a_11844_28366# 0.01762f
C385 a_11758_26326# a_11844_27822# 0.01932f
C386 s2d_block_0.s2d_tails_lo_f_0.sa_F2 s2d_block_0.s2d_casc_n_f_0.xc 0.01761f
C387 iovdd s2d_block_0.s2d_tails_lo_f_0.sa_M2 1.97454f
C388 s2d_block_0.s2d_tails_hi_f_0.sa_A2 s2d_block_0.s2d_casc_n_f_0.x 0.19349f
C389 s2d_block_0.s2d_tails_lo_f_0.sa_M2 s2d_block_0.s2d_tails_hi_f_0.sb_F1 0.06369f
C390 a_11844_26462# s2d_block_0.s2d_tails_hi_f_0.sa_M1 0.01273f
C391 s2d_block_0.s2d_casc_n_f_0.yc s2d_block_0.s2d_casc_n_f_0.xc 12.1225f
C392 a_11844_26598# a_11844_26734# 0.63642f
C393 a_11844_27142# a_11844_27278# 0.63642f
C394 s2d_block_0.s2d_tails_hi_f_0.sb_F2 s2d_block_0.s2d_tails_lo_f_0.sa_M2 0.36456f
C395 a_11844_25510# s2d_block_0.s2d_tails_hi_f_0.sb_F1 0.01318f
C396 s2d_block_0.s2d_tails_hi_f_0.vbp s2d_block_0.s2d_casc_p_f_0.vbpc 3.8698f
C397 s2d_block_0.s2d_tails_hi_f_0.sb_F2 a_11844_27958# 0.04246f
C398 s2d_block_0.s2d_tails_hi_f_0.sb_F2 a_11844_25510# 0.02158f
C399 outp s2d_block_0.s2d_loads_f_0.vcmfb 10.7502f
C400 s2d_block_0.s2d_tails_hi_f_0.sa_A1 iovdd 1.51645f
C401 a_11844_28638# a_14374_27142# 0.02707f
C402 s2d_block_0.s2d_tails_hi_f_0.sa_A1 s2d_block_0.s2d_tails_hi_f_0.sb_F1 0.1176f
C403 vcm s2d_block_0.s2d_tails_lo_f_0.sb_A2 0.25963f
C404 a_11844_25918# a_11844_25782# 0.63642f
C405 a_11844_26054# a_14374_26054# 0.02728f
C406 Clamp_P_M1_0.gate iovdd 44.7526f
C407 outn s2d_block_0.bias_tree_noab_n_c3_0.ni 0.0188f
C408 s2d_block_0.s2d_tails_hi_f_0.sb_F2 s2d_block_0.s2d_tails_hi_f_0.sa_A1 0.41711f
C409 s2d_block_0.s2d_tails_hi_f_0.sa_A1 vdd 0.10518f
C410 s2d_block_0.s2d_casc_n_f_0.xc s2d_block_0.s2d_tails_hi_f_0.sb_M2 1.1962f
C411 s2d_block_0.s2d_tails_hi_f_0.sb_F2 a_11844_26190# 0.02158f
C412 a_11758_27006# s2d_block_0.s2d_tails_lo_f_0.sb_M1 0.04688f
C413 outp iovdd 12.3124f
C414 pad Clamp_N_M1_0.gate 7.47057f
C415 outp s2d_block_0.s2d_tails_hi_f_0.sb_F1 2.88116f
C416 outn vcm 6.98968f
C417 vdd outp 4.61201f
C418 pad vcm 0.3255f
C419 iovdd s2d_block_0.s2d_tails_lo_f_0.sb_M1 1.22564f
C420 a_11758_26326# s2d_block_0.s2d_tails_lo_f_0.sb_A1 0.05685f
C421 s2d_block_0.s2d_tails_hi_f_0.sb_F2 outp 0.05962f
C422 s2d_block_0.s2d_tails_lo_f_0.sb_M1 s2d_block_0.s2d_tails_hi_f_0.sb_F1 0.07854f
C423 s2d_block_0.s2d_casc_p_f_0.vbpc s2d_block_0.s2d_tails_lo_f_0.sb_A2 0.04675f
C424 a_11844_28230# a_14374_27550# 0.02719f
C425 s2d_block_0.s2d_tails_hi_f_0.sb_F2 s2d_block_0.s2d_tails_lo_f_0.sb_M1 0.80863f
C426 s2d_block_0.s2d_tails_hi_f_0.sa_A1 s2d_block_0.s2d_tails_lo_f_0.sa_M2 0.05843f
C427 a_11844_26190# s2d_block_0.s2d_tails_lo_f_0.sa_M2 0.0194f
C428 a_14374_25646# s2d_block_0.sinks_6x6_s2d_c3_core_0.vbn 0.01791f
C429 s2d_block_0.s2d_tails_hi_f_0.sa_A1 a_11844_25510# 0.0665f
C430 vcm s2d_block_0.s2d_tails_lo_f_0.sa_F1 2.76655f
C431 a_11844_26326# a_11758_26326# 0.01932f
C432 a_11844_26598# a_11758_26598# 0.01938f
C433 a_11844_26734# a_11758_26734# 0.01944f
C434 a_11844_27006# a_11758_27006# 0.01971f
C435 a_11844_26462# a_11758_26462# 0.01935f
C436 a_11844_26870# a_11758_26870# 0.01953f
C437 s2d_block_0.s2d_casc_n_f_0.x s2d_block_0.s2d_tails_hi_f_0.vbp 0.07574f
C438 a_11844_27550# a_11844_27686# 0.63642f
C439 outn s2d_block_0.s2d_casc_p_f_0.vbpc 7.61108f
C440 vcm s2d_block_0.s2d_casc_n_f_0.y 0.63563f
C441 s2d_block_0.s2d_loads_f_0.ln s2d_block_0.s2d_loads_f_0.vcmfb 1.8425f
C442 outp s2d_block_0.s2d_tails_lo_f_0.sa_M2 0.5411f
C443 a_11844_25782# s2d_block_0.s2d_tails_hi_f_0.sa_M1 0.01333f
C444 a_11844_26462# a_14374_26054# 0.02728f
C445 s2d_block_0.s2d_tails_hi_f_0.vbp s2d_block_0.s2d_casc_n_f_0.xc 0.09249f
C446 s2d_block_0.s2d_tails_lo_f_0.sb_M1 s2d_block_0.s2d_tails_lo_f_0.sa_M2 0.59445f
C447 vdd a_11844_27006# 0.01077f
C448 s2d_block_0.s2d_tails_hi_f_0.sb_F2 a_11844_27006# 0.02253f
C449 s2d_block_0.s2d_tails_hi_f_0.sb_F2 a_11844_27550# 0.0248f
C450 vdd a_11844_27550# 0.01806f
C451 s2d_block_0.s2d_casc_p_f_0.vbpc s2d_block_0.s2d_tails_lo_f_0.sa_F1 0.01535f
C452 en_3v3 iovdd 0.36737f
C453 s2d_block_0.s2d_tails_hi_f_0.sa_A1 outp 0.02033f
C454 a_8120_4634# a_7760_4632# 0.05849f
C455 iovdd s2d_block_0.s2d_loads_f_0.ln 9.1759f
C456 s2d_block_0.s2d_loads_f_0.lp s2d_block_0.s2d_loads_f_0.vcmfb 2.06469f
C457 vref s2d_block_0.s2d_tails_lo_f_0.sa_F2 0.07479f
C458 s2d_block_0.s2d_tails_hi_f_0.sa_A1 s2d_block_0.s2d_tails_lo_f_0.sb_M1 1.47019f
C459 outn s2d_block_0.s2d_loads_f_0.dd 0.03137f
C460 vdd en_3v3 1.37224f
C461 s2d_block_0.s2d_casc_n_f_0.x s2d_block_0.s2d_tails_lo_f_0.sb_A2 1.26802f
C462 a_11844_28502# s2d_block_0.s2d_tails_hi_f_0.sa_M1 0.02158f
C463 vref s2d_block_0.s2d_casc_n_f_0.yc 0.03751f
C464 s2d_block_0.s2d_loads_f_0.vcmfb s2d_block_0.sinks_6x6_s2d_c3_core_0.vbn 0.04166f
C465 s2d_block_0.s2d_tails_hi_f_0.sa_A2 a_11844_25782# 0.03941f
C466 iovdd s2d_block_0.s2d_loads_f_0.lp 9.55312f
C467 s2d_block_0.s2d_tails_lo_f_0.sb_A1 s2d_block_0.s2d_tails_hi_f_0.sa_M1 0.02784f
C468 outp s2d_block_0.s2d_tails_lo_f_0.sb_M1 0.86893f
C469 outn s2d_block_0.s2d_casc_n_f_0.x 0.03219f
C470 a_11758_26734# a_11758_26598# 0.78325f
C471 pad s2d_block_0.s2d_casc_n_f_0.x 0.07862f
C472 s2d_block_0.s2d_tails_lo_f_0.sa_F2 s2d_block_0.s2d_tails_lo_f_0.sb_A1 0.21993f
C473 a_14374_27822# a_14374_27686# 0.33426f
C474 iovdd s2d_block_0.sinks_6x6_s2d_c3_core_0.vbn 14.9428f
C475 s2d_block_0.sinks_6x6_s2d_c3_core_0.vbn s2d_block_0.s2d_tails_hi_f_0.sb_F1 0.50564f
C476 a_11844_26326# s2d_block_0.s2d_tails_hi_f_0.sa_M1 0.01916f
C477 s2d_block_0.s2d_casc_n_f_0.yc s2d_block_0.s2d_tails_lo_f_0.sb_A1 0.03102f
C478 outn s2d_block_0.s2d_casc_n_f_0.xc 0.33309f
C479 a_11844_26870# a_14374_25646# 0.0271f
C480 s2d_block_0.s2d_tails_hi_f_0.sb_F2 s2d_block_0.sinks_6x6_s2d_c3_core_0.vbn 0.5387f
C481 pad s2d_block_0.s2d_casc_n_f_0.xc 0.0794f
C482 vdd s2d_block_0.sinks_6x6_s2d_c3_core_0.vbn 1.34414f
C483 s2d_block_0.s2d_casc_n_f_0.x s2d_block_0.s2d_tails_lo_f_0.sa_F1 0.17877f
C484 vdd a_11758_26326# 0.01425f
C485 s2d_block_0.s2d_tails_hi_f_0.sa_A2 s2d_block_0.s2d_tails_lo_f_0.sb_A1 0.03116f
C486 a_11844_25646# a_11844_25782# 0.63642f
C487 s2d_block_0.s2d_casc_n_f_0.x s2d_block_0.s2d_casc_n_f_0.y 22.009f
C488 s2d_block_0.s2d_casc_n_f_0.vbnc s2d_block_0.s2d_loads_f_0.vcmfb 4.60294f
C489 a_11844_25918# s2d_block_0.s2d_tails_hi_f_0.sb_F1 0.0102f
C490 s2d_block_0.s2d_tails_hi_f_0.sb_F2 a_11844_25918# 0.02158f
C491 s2d_block_0.s2d_tails_lo_f_0.sb_A1 s2d_block_0.s2d_tails_hi_f_0.sb_M2 0.08784f
C492 s2d_block_0.s2d_casc_n_f_0.xc s2d_block_0.s2d_tails_lo_f_0.sa_F1 0.04682f
C493 a_11844_28774# s2d_block_0.s2d_tails_hi_f_0.sa_M1 0.0238f
C494 a_14374_27414# a_11844_28366# 0.02713f
C495 outp en_3v3 0.10044f
C496 outp s2d_block_0.s2d_loads_f_0.ln 0.02987f
C497 s2d_block_0.s2d_casc_n_f_0.y s2d_block_0.s2d_casc_n_f_0.xc 7.99643f
C498 iovdd s2d_block_0.s2d_casc_n_f_0.vbnc 22.6805f
C499 a_11758_26462# s2d_block_0.s2d_tails_lo_f_0.sb_A1 0.02995f
C500 a_11758_26326# s2d_block_0.s2d_tails_lo_f_0.sa_M2 0.26248f
C501 s2d_block_0.s2d_casc_p_f_0.vbpc s2d_block_0.bias_tree_noab_n_c3_0.ni 0.54432f
C502 vdd s2d_block_0.s2d_casc_n_f_0.vbnc 1.187f
C503 en_3v3_b iref 1.56328f
C504 vref s2d_block_0.s2d_tails_hi_f_0.vbp 0.10217f
C505 outp s2d_block_0.s2d_loads_f_0.lp 0.34422f
C506 a_11844_27142# a_14374_27142# 0.02707f
C507 a_11844_27278# a_14374_27278# 0.0271f
C508 a_14374_25782# s2d_block_0.sinks_6x6_s2d_c3_core_0.vbn 0.01214f
C509 a_11844_28638# a_11844_28502# 0.63642f
C510 iref s2d_block_0.s2d_tails_hi_f_0.vbp 0.12001f
C511 a_11758_26870# a_11844_27278# 0.01953f
C512 outp s2d_block_0.sinks_6x6_s2d_c3_core_0.vbn 0.0236f
C513 a_11844_28638# s2d_block_0.s2d_tails_lo_f_0.sb_A1 0.02111f
C514 s2d_block_0.s2d_casc_n_f_0.yc s2d_block_0.s2d_loads_f_0.vcmfb 0.20847f
C515 iovdd s2d_block_0.s2d_tails_hi_f_0.sa_M1 0.6851f
C516 a_11844_25646# a_14374_25646# 0.0271f
C517 a_14374_25918# a_14374_25782# 0.78325f
C518 s2d_block_0.s2d_tails_lo_f_0.sb_M1 s2d_block_0.sinks_6x6_s2d_c3_core_0.vbn 0.15983f
C519 s2d_block_0.s2d_tails_hi_f_0.vbp s2d_block_0.s2d_tails_lo_f_0.sb_A1 0.9893f
C520 s2d_block_0.s2d_tails_hi_f_0.sb_F1 s2d_block_0.s2d_tails_hi_f_0.sa_M1 1.21732f
C521 vdd s2d_block_0.s2d_tails_hi_f_0.sa_M1 0.10508f
C522 s2d_block_0.s2d_tails_hi_f_0.sb_F2 a_11844_26870# 0.02235f
C523 s2d_block_0.s2d_tails_hi_f_0.sb_F2 s2d_block_0.s2d_tails_hi_f_0.sa_M1 0.02465f
C524 iovdd s2d_block_0.s2d_tails_lo_f_0.sa_F2 5.27432f
C525 vdd a_11844_27414# 0.01616f
C526 s2d_block_0.s2d_tails_hi_f_0.sb_F2 a_11844_27414# 0.02378f
C527 a_11758_26326# s2d_block_0.s2d_tails_lo_f_0.sb_M1 0.04825f
C528 vref s2d_block_0.s2d_tails_lo_f_0.sb_A2 2.89541f
C529 s2d_block_0.s2d_tails_lo_f_0.sa_F2 s2d_block_0.s2d_tails_hi_f_0.sb_F1 3.20673f
C530 iovdd a_7760_4632# 0.04371f
C531 s2d_block_0.s2d_tails_hi_f_0.sb_F2 s2d_block_0.s2d_tails_lo_f_0.sa_F2 1.64077f
C532 iovdd s2d_block_0.s2d_casc_n_f_0.yc 10.8052f
C533 a_11844_28502# s2d_block_0.s2d_tails_lo_f_0.sb_A2 0.02094f
C534 iref iovss 2.67053f
C535 vdd iovss 0.20836p
C536 s2d_block_0.s2d_loads_f_0.dd iovss 3.19021f
C537 s2d_block_0.s2d_loads_f_0.ln iovss 9.89804f
C538 s2d_block_0.s2d_loads_f_0.lp iovss 6.22746f
C539 a_14374_26190# iovss 1.16641f
C540 a_14374_26054# iovss 1.29287f
C541 a_14374_25918# iovss 1.39935f
C542 a_14374_25782# iovss 1.46247f
C543 a_14374_25646# iovss 1.47687f
C544 a_14374_25510# iovss 2.66141f
C545 a_11758_27006# iovss 1.03056f
C546 a_11758_26870# iovss 1.10629f
C547 a_11758_26734# iovss 1.21292f
C548 a_11758_26598# iovss 1.3156f
C549 a_11758_26462# iovss 1.38801f
C550 a_11758_26326# iovss 2.409f
C551 a_14374_27822# iovss 1.06639f
C552 a_14374_27686# iovss 1.18649f
C553 a_14374_27550# iovss 1.26601f
C554 a_14374_27414# iovss 1.34504f
C555 a_14374_27278# iovss 1.42889f
C556 a_14374_27142# iovss 2.67699f
C557 s2d_block_0.s2d_casc_n_f_0.xc iovss 83.8826f
C558 s2d_block_0.s2d_casc_n_f_0.yc iovss 47.58514f
C559 s2d_block_0.s2d_casc_n_f_0.x iovss 32.80537f
C560 s2d_block_0.s2d_casc_n_f_0.y iovss 39.42073f
C561 s2d_block_0.s2d_tails_lo_f_0.sa_M2 iovss 2.67627f
C562 s2d_block_0.s2d_tails_lo_f_0.sb_M1 iovss 3.81297f
C563 s2d_block_0.s2d_tails_lo_f_0.sb_A1 iovss 3.85353f
C564 s2d_block_0.s2d_tails_lo_f_0.sa_F2 iovss 19.3854f
C565 s2d_block_0.s2d_tails_lo_f_0.sa_F1 iovss 6.60592f
C566 s2d_block_0.s2d_tails_lo_f_0.sb_A2 iovss 9.08991f
C567 s2d_block_0.s2d_tails_hi_f_0.sb_M2 iovss 4.72933f
C568 s2d_block_0.s2d_tails_hi_f_0.sa_M1 iovss 7.29322f
C569 s2d_block_0.s2d_tails_hi_f_0.sa_A2 iovss 4.56941f
C570 s2d_block_0.s2d_tails_hi_f_0.sb_F1 iovss 24.26897f
C571 s2d_block_0.s2d_tails_hi_f_0.sb_F2 iovss 8.68036f
C572 s2d_block_0.s2d_tails_hi_f_0.sa_A1 iovss 5.54355f
Rtie0 a_11844_25374# iovss 1e12
Rtie1 a_11844_25510# iovss 1e12
Rtie2 a_11844_25646# iovss 1e12
Rtie3 a_11844_25782# iovss 1e12
Rtie4 a_11844_25918# iovss 1e12
Rtie5 a_11844_26054# iovss 1e12
Rtie6 a_11844_26190# iovss 1e12
Rtie7 a_11844_26326# iovss 1e12
Rtie8 a_11844_26462# iovss 1e12
Rtie9 a_11844_26598# iovss 1e12
Rtie10 a_11844_26734# iovss 1e12
Rtie11 a_11844_26870# iovss 1e12
Rtie12 a_11844_27006# iovss 1e12
Rtie13 a_11844_27142# iovss 1e12
Rtie14 a_11844_27278# iovss 1e12
Rtie15 a_11844_27414# iovss 1e12
Rtie16 a_11844_27550# iovss 1e12
Rtie17 a_11844_27686# iovss 1e12
Rtie18 a_11844_27822# iovss 1e12
Rtie19 a_11844_27958# iovss 1e12
Rtie20 a_11844_28094# iovss 1e12
Rtie21 a_11844_28230# iovss 1e12
Rtie22 a_11844_28366# iovss 1e12
Rtie23 a_11844_28502# iovss 1e12
Rtie24 a_11844_28638# iovss 1e12
Rtie25 a_11844_28774# iovss 1e12
Rtie26 a_7760_4632# iovss 1e12
Rtie27 a_8120_4634# iovss 1e12
.ends
