* generated by scripts/cace/pex_for_sim.py from /tmp/claude-0/-home-user-sg13cmos5l-cm-ip--single2diff2single/9625f5bb-27cd-530e-a9cf-d1aa15a8223d/scratchpad/agents/F/work/B/runs/final/pex/sg13cmos5l_IOPadSingle2Diff.pex.spice: 28 capacitor-only nodes tied to iovss through 1e12 Ohm
* PEX produced on Wed Nov  4 13:05:34 UTC 2026 using /usr/local/bin/sak-pex.sh with m=2 and s=1
* NGSPICE file created from sg13cmos5l_IOPadSingle2Diff.ext - technology: ihp-sg13cmos5l

.subckt sg13cmos5l_IOPadSingle2Diff vdd iovss pad iovdd vref outp outn vcm en_3v3
+ en_3v3_b iref
X0 iovdd s2d_block_0.s2d_tails_hi_f_0.vbp iovdd iovdd sg13_hv_pmos ad=1.7p pd=10.68u as=0.65668n ps=2.66101m w=5u l=6u
X1 iovss iovss iovss rhigh l=12.65u w=0.5u
X2 s2d_block_0.s2d_loads_f_0.ln s2d_block_0.s2d_loads_f_0.vcmfb iovdd iovdd sg13_hv_pmos ad=2.04p pd=12.68u as=2.04p ps=12.68u w=6u l=4u
X3 s2d_block_0.s2d_loads_f_0.ln s2d_block_0.s2d_casc_p_f_0.vbpc outn iovdd sg13_hv_pmos ad=5.1p pd=30.68u as=5.1p ps=30.68u w=15u l=3u
X4 s2d_block_0.s2d_tails_hi_f_0.sa_A2 a_14374_25646# iovss rhigh l=12.65u w=0.5u
X5 s2d_block_0.s2d_casc_n_f_0.xc s2d_block_0.sinks_6x6_s2d_c3_core_0.vbn iovss iovss sg13_hv_nmos ad=2.04p pd=12.68u as=2.04p ps=12.68u w=6u l=6u
X6 iovdd s2d_block_0.s2d_casc_n_f_0.vbnc s2d_block_0.s2d_casc_n_f_0.yc iovss sg13_hv_nmos ad=5.1p pd=30.68u as=5.1p ps=30.68u w=15u l=3u
X7 Clamp_P_M1_0.gate iovdd iovss rppd l=12.9u w=0.5u
X8 s2d_block_0.s2d_loads_f_0.ln s2d_block_0.s2d_loads_f_0.vcmfb iovdd iovdd sg13_hv_pmos ad=2.04p pd=12.68u as=2.04p ps=12.68u w=6u l=4u
X9 s2d_block_0.s2d_casc_p_f_0.vbpc s2d_block_0.bias_tree_noab_n_c3_0.ni iovss iovss sg13_hv_nmos ad=0.816p pd=5.48u as=0.816p ps=5.48u w=2.4u l=6u
X10 a_11758_27006# a_14374_25510# iovss rhigh l=12.65u w=0.5u
X11 s2d_block_0.s2d_tails_lo_f_0.sa_F1 vcm s2d_block_0.s2d_casc_n_f_0.y s2d_block_0.s2d_tails_lo_f_0.sa_F1 sg13_hv_pmos ad=3.4p pd=20.68u as=1.9p ps=10.38u w=10u l=1u
X12 iovss s2d_block_0.sinks_6x6_s2d_c3_core_0.vbn iovss iovss sg13_hv_nmos ad=0.68p pd=4.68u as=0.74628n ps=2.70983m w=2u l=6u
X13 iovdd Clamp_P_M1_0.gate pad iovdd sg13_hv_pmos ad=2.1312p pd=7.3u as=3.9294p ps=7.84u w=6.66u l=0.6u
X14 iovss s2d_block_0.sinks_6x6_s2d_c3_core_0.vbn s2d_block_0.s2d_casc_n_f_0.xc iovss sg13_hv_nmos ad=2.04p pd=12.68u as=2.04p ps=12.68u w=6u l=6u
X15 s2d_block_0.bias_tree_noab_n_c3_0.ni en_3v3_b iovss iovss sg13_hv_nmos ad=0.34p pd=2.68u as=0.34p ps=2.68u w=1u l=0.45u
X16 iovdd Clamp_P_M1_0.gate pad iovdd sg13_hv_pmos ad=2.1312p pd=7.3u as=3.9294p ps=7.84u w=6.66u l=0.6u
X17 iovss s2d_block_0.sinks_6x6_s2d_c3_core_0.vbn iovss iovss sg13_hv_nmos ad=2.04p pd=12.68u as=0 ps=0 w=6u l=6u
X18 s2d_block_0.s2d_casc_n_f_0.x s2d_block_0.s2d_casc_n_f_0.vbnc outp iovss sg13_hv_nmos ad=5.1p pd=30.68u as=5.1p ps=30.68u w=15u l=3u
X19 s2d_block_0.s2d_casc_n_f_0.x vref s2d_block_0.s2d_tails_lo_f_0.sb_A2 s2d_block_0.s2d_tails_lo_f_0.sb_A2 sg13_hv_pmos ad=1.9p pd=10.38u as=3.4p ps=20.68u w=10u l=1u
X20 iovdd Clamp_P_M1_0.gate pad iovdd sg13_hv_pmos ad=2.1312p pd=7.3u as=3.9294p ps=7.84u w=6.66u l=0.6u
X21 s2d_block_0.s2d_tails_hi_f_0.sb_F1 outp s2d_block_0.s2d_casc_n_f_0.x s2d_block_0.s2d_tails_hi_f_0.sb_F1 sg13_hv_pmos ad=3.4p pd=20.68u as=1.9p ps=10.38u w=10u l=1u
X22 iovdd iovdd iovdd iovdd sg13_hv_pmos ad=1.9p pd=10.38u as=0 ps=0 w=10u l=1u
X23 iovdd s2d_block_0.s2d_tails_hi_f_0.vbp iovdd iovdd sg13_hv_pmos ad=1.7p pd=10.68u as=0 ps=0 w=5u l=6u
X24 s2d_block_0.s2d_casc_n_f_0.y s2d_block_0.sinks_6x6_s2d_c3_core_0.vbn iovss iovss sg13_hv_nmos ad=2.04p pd=12.68u as=2.04p ps=12.68u w=6u l=6u
X25 s2d_block_0.s2d_tails_lo_f_0.sb_A2 a_14374_27278# iovss rhigh l=12.65u w=0.5u
X26 iovdd s2d_block_0.s2d_loads_f_0.vcmfb s2d_block_0.s2d_loads_f_0.dd iovdd sg13_hv_pmos ad=2.04p pd=12.68u as=2.04p ps=12.68u w=6u l=4u
X27 pad Clamp_N_M1_0.gate iovss iovss sg13_hv_nmos ad=2.596p pd=5.58u as=1.408p ps=5.04u w=4.4u l=0.6u
X28 pad Clamp_N_M1_0.gate iovss iovss sg13_hv_nmos ad=2.596p pd=5.58u as=2.068p ps=9.74u w=4.4u l=0.6u
X29 iovdd s2d_block_0.s2d_loads_f_0.vcmfb s2d_block_0.s2d_loads_f_0.lp iovdd sg13_hv_pmos ad=2.04p pd=12.68u as=2.04p ps=12.68u w=6u l=4u
X30 pad Clamp_N_M1_0.gate iovss iovss sg13_hv_nmos ad=2.596p pd=5.58u as=1.408p ps=5.04u w=4.4u l=0.6u
X31 vcm en_3v3_b outp iovss sg13_hv_nmos ad=0.19p pd=1.38u as=0.34p ps=2.68u w=1u l=0.45u
X32 s2d_block_0.s2d_tails_lo_f_0.sa_F1 a_14374_25782# iovss rhigh l=12.65u w=0.5u
X33 a_11758_27006# a_14374_27142# iovss rhigh l=12.65u w=0.5u
X34 iovdd iovdd iovdd iovdd sg13_hv_pmos ad=3.4p pd=20.68u as=0 ps=0 w=10u l=1u
X35 pad Clamp_P_M1_0.gate iovdd iovdd sg13_hv_pmos ad=3.9294p pd=7.84u as=2.1312p ps=7.3u w=6.66u l=0.6u
X36 s2d_block_0.s2d_loads_f_0.lp s2d_block_0.s2d_casc_p_f_0.vbpc outp iovdd sg13_hv_pmos ad=5.1p pd=30.68u as=5.1p ps=30.68u w=15u l=3u
X37 iovdd s2d_block_0.s2d_tails_hi_f_0.vbp s2d_block_0.s2d_tails_hi_f_0.sa_M1 iovdd sg13_hv_pmos ad=1.7p pd=10.68u as=1.7p ps=10.68u w=5u l=6u
X38 s2d_block_0.s2d_casc_n_f_0.y s2d_block_0.sinks_6x6_s2d_c3_core_0.vbn iovss iovss sg13_hv_nmos ad=2.04p pd=12.68u as=2.04p ps=12.68u w=6u l=6u
X39 iovdd Clamp_P_M1_0.gate pad iovdd sg13_hv_pmos ad=2.1312p pd=7.3u as=3.9294p ps=7.84u w=6.66u l=0.6u
X40 iovdd Clamp_P_M1_0.gate pad iovdd sg13_hv_pmos ad=2.1312p pd=7.3u as=3.9294p ps=7.84u w=6.66u l=0.6u
X41 iref en_3v3 s2d_block_0.bias_tree_noab_n_c3_0.ni iovss sg13_hv_nmos ad=0.34p pd=2.68u as=0.34p ps=2.68u w=1u l=0.45u
X42 iovdd Clamp_P_M1_0.gate pad iovdd sg13_hv_pmos ad=2.1312p pd=7.3u as=3.9294p ps=7.84u w=6.66u l=0.6u
X43 pad iovdd dpantenna l=1.26u w=27.78u
X44 pad Clamp_P_M1_0.gate iovdd iovdd sg13_hv_pmos ad=3.9294p pd=7.84u as=2.1312p ps=7.3u w=6.66u l=0.6u
X45 s2d_block_0.s2d_casc_n_f_0.x vcm s2d_block_0.s2d_tails_hi_f_0.sb_F2 s2d_block_0.s2d_tails_hi_f_0.sb_F2 sg13_hv_pmos ad=1.9p pd=10.38u as=3.4p ps=20.68u w=10u l=1u
X46 s2d_block_0.s2d_tails_hi_f_0.sa_A1 a_14374_25510# iovss rhigh l=12.65u w=0.5u
X47 iovss s2d_block_0.sinks_6x6_s2d_c3_core_0.vbn s2d_block_0.s2d_casc_n_f_0.y iovss sg13_hv_nmos ad=2.04p pd=12.68u as=2.04p ps=12.68u w=6u l=6u
X48 s2d_block_0.s2d_tails_hi_f_0.sb_F1 a_14374_27414# iovss rhigh l=12.65u w=0.5u
X49 s2d_block_0.s2d_tails_lo_f_0.sa_F2 outn s2d_block_0.s2d_casc_n_f_0.y s2d_block_0.s2d_tails_lo_f_0.sa_F2 sg13_hv_pmos ad=3.4p pd=20.68u as=1.9p ps=10.38u w=10u l=1u
X50 iovss s2d_block_0.bias_tree_noab_n_c3_0.ni iovss iovss sg13_hv_nmos ad=0.816p pd=5.48u as=0 ps=0 w=2.4u l=6u
X51 s2d_block_0.s2d_casc_n_f_0.y s2d_block_0.s2d_casc_n_f_0.vbnc outn iovss sg13_hv_nmos ad=5.1p pd=30.68u as=5.1p ps=30.68u w=15u l=3u
X52 pad Clamp_N_M1_0.gate iovss iovss sg13_hv_nmos ad=2.596p pd=5.58u as=1.408p ps=5.04u w=4.4u l=0.6u
X53 iovss s2d_block_0.s2d_casc_n_f_0.vbnc iovss iovss sg13_hv_nmos ad=0.68p pd=4.68u as=0 ps=0 w=2u l=3u
X54 iovss pad dantenna l=1.26u w=27.78u
X55 pad Clamp_N_M1_0.gate iovss iovss sg13_hv_nmos ad=2.596p pd=5.58u as=1.408p ps=5.04u w=4.4u l=0.6u
X56 vcm en_3v3 outp iovdd sg13_hv_pmos ad=0.19p pd=1.38u as=0.34p ps=2.68u w=1u l=0.45u
X57 outn en_3v3 vcm iovdd sg13_hv_pmos ad=0.34p pd=2.68u as=0.19p ps=1.38u w=1u l=0.45u
X58 iovdd s2d_block_0.s2d_tails_hi_f_0.vbp s2d_block_0.s2d_tails_hi_f_0.sb_M2 iovdd sg13_hv_pmos ad=1.7p pd=10.68u as=1.7p ps=10.68u w=5u l=6u
X59 iovss s2d_block_0.sinks_6x6_s2d_c3_core_0.vbn s2d_block_0.s2d_casc_n_f_0.y iovss sg13_hv_nmos ad=2.04p pd=12.68u as=2.04p ps=12.68u w=6u l=6u
X60 pad Clamp_P_M1_0.gate iovdd iovdd sg13_hv_pmos ad=3.9294p pd=7.84u as=2.1312p ps=7.3u w=6.66u l=0.6u
X61 iovdd s2d_block_0.s2d_tails_hi_f_0.vbp s2d_block_0.s2d_tails_hi_f_0.sb_F1 iovdd sg13_hv_pmos ad=1.7p pd=10.68u as=1.7p ps=10.68u w=5u l=6u
X62 iovdd s2d_block_0.s2d_loads_f_0.vcmfb s2d_block_0.s2d_loads_f_0.lp iovdd sg13_hv_pmos ad=2.04p pd=12.68u as=2.04p ps=12.68u w=6u l=4u
X63 iovdd Clamp_P_M1_0.gate pad iovdd sg13_hv_pmos ad=2.1312p pd=7.3u as=3.9294p ps=7.84u w=6.66u l=0.6u
X64 a_11758_26734# a_14374_25782# iovss rhigh l=12.65u w=0.5u
X65 pad Clamp_P_M1_0.gate iovdd iovdd sg13_hv_pmos ad=3.9294p pd=7.84u as=2.1312p ps=7.3u w=6.66u l=0.6u
X66 pad Clamp_P_M1_0.gate iovdd iovdd sg13_hv_pmos ad=3.9294p pd=7.84u as=2.1312p ps=7.3u w=6.66u l=0.6u
X67 pad Clamp_P_M1_0.gate iovdd iovdd sg13_hv_pmos ad=3.9294p pd=7.84u as=2.1312p ps=7.3u w=6.66u l=0.6u
X68 s2d_block_0.s2d_tails_hi_f_0.sb_M2 vcm s2d_block_0.s2d_casc_n_f_0.xc s2d_block_0.s2d_tails_hi_f_0.sb_M2 sg13_hv_pmos ad=3.4p pd=20.68u as=1.9p ps=10.38u w=10u l=1u
X69 pad Clamp_P_M1_0.gate iovdd iovdd sg13_hv_pmos ad=3.9294p pd=7.84u as=2.1312p ps=7.3u w=6.66u l=0.6u
X70 iovss Clamp_N_M1_0.gate pad iovss sg13_hv_nmos ad=1.408p pd=5.04u as=2.596p ps=5.58u w=4.4u l=0.6u
X71 iovss Clamp_N_M1_0.gate pad iovss sg13_hv_nmos ad=1.408p pd=5.04u as=2.596p ps=5.58u w=4.4u l=0.6u
X72 iovss iovss iovss rhigh l=12.65u w=0.5u
X73 s2d_block_0.s2d_casc_n_f_0.yc s2d_block_0.s2d_casc_n_f_0.vbnc iovdd iovss sg13_hv_nmos ad=5.1p pd=30.68u as=5.1p ps=30.68u w=15u l=3u
X74 iovdd s2d_block_0.s2d_casc_p_f_0.vbpc iovdd iovdd sg13_hv_pmos ad=0.34p pd=2.68u as=0 ps=0 w=1u l=4u
X75 s2d_block_0.s2d_casc_n_f_0.yc outp s2d_block_0.s2d_tails_hi_f_0.sa_M1 s2d_block_0.s2d_tails_hi_f_0.sa_M1 sg13_hv_pmos ad=1.9p pd=10.38u as=3.4p ps=20.68u w=10u l=1u
X76 s2d_block_0.s2d_casc_n_f_0.y vcm s2d_block_0.s2d_tails_lo_f_0.sa_F1 s2d_block_0.s2d_tails_lo_f_0.sa_F1 sg13_hv_pmos ad=1.9p pd=10.38u as=3.4p ps=20.68u w=10u l=1u
X77 iovdd s2d_block_0.s2d_tails_hi_f_0.vbp s2d_block_0.s2d_tails_hi_f_0.sa_A2 iovdd sg13_hv_pmos ad=1.7p pd=10.68u as=1.7p ps=10.68u w=5u l=6u
X78 s2d_block_0.s2d_tails_hi_f_0.sa_A2 pad s2d_block_0.s2d_casc_n_f_0.y s2d_block_0.s2d_tails_hi_f_0.sa_A2 sg13_hv_pmos ad=3.4p pd=20.68u as=1.9p ps=10.38u w=10u l=1u
X79 iovss s2d_block_0.sinks_6x6_s2d_c3_core_0.vbn s2d_block_0.s2d_casc_n_f_0.yc iovss sg13_hv_nmos ad=2.04p pd=12.68u as=2.04p ps=12.68u w=6u l=6u
X80 iovss s2d_block_0.sinks_6x6_s2d_c3_core_0.vbn iovss iovss sg13_hv_nmos ad=0.68p pd=4.68u as=0 ps=0 w=2u l=6u
X81 s2d_block_0.s2d_tails_hi_f_0.sb_M2 a_14374_27822# iovss rhigh l=12.65u w=0.5u
X82 s2d_block_0.s2d_casc_n_f_0.yc s2d_block_0.sinks_6x6_s2d_c3_core_0.vbn iovss iovss sg13_hv_nmos ad=2.04p pd=12.68u as=2.04p ps=12.68u w=6u l=6u
X83 iovss s2d_block_0.sinks_6x6_s2d_c3_core_0.vbn s2d_block_0.s2d_casc_n_f_0.y iovss sg13_hv_nmos ad=2.04p pd=12.68u as=2.04p ps=12.68u w=6u l=6u
X84 iovdd s2d_block_0.s2d_tails_hi_f_0.vbp s2d_block_0.s2d_tails_hi_f_0.sa_A1 iovdd sg13_hv_pmos ad=1.7p pd=10.68u as=1.7p ps=10.68u w=5u l=6u
X85 a_11758_26870# a_14374_25646# iovss rhigh l=12.65u w=0.5u
X86 s2d_block_0.s2d_casc_n_f_0.vbnc s2d_block_0.s2d_tails_hi_f_0.vbp iovdd iovdd sg13_hv_pmos ad=0.68p pd=4.68u as=0.68p ps=4.68u w=2u l=6u
X87 s2d_block_0.s2d_tails_hi_f_0.sb_F2 a_14374_27550# iovss rhigh l=12.65u w=0.5u
X88 iovdd s2d_block_0.s2d_tails_hi_f_0.vbp iovdd iovdd sg13_hv_pmos ad=1.7p pd=10.68u as=0 ps=0 w=5u l=6u
X89 pad Clamp_P_M1_0.gate iovdd iovdd sg13_hv_pmos ad=3.9294p pd=7.84u as=2.1312p ps=7.3u w=6.66u l=0.6u
X90 pad Clamp_P_M1_0.gate iovdd iovdd sg13_hv_pmos ad=3.9294p pd=7.84u as=2.1312p ps=7.3u w=6.66u l=0.6u
X91 a_11758_26598# a_14374_25918# iovss rhigh l=12.65u w=0.5u
X92 iovss s2d_block_0.sinks_6x6_s2d_c3_core_0.vbn s2d_block_0.s2d_casc_n_f_0.x iovss sg13_hv_nmos ad=2.04p pd=12.68u as=2.04p ps=12.68u w=6u l=6u
X93 s2d_block_0.s2d_loads_f_0.dd s2d_block_0.s2d_loads_f_0.vcmfb iovdd iovdd sg13_hv_pmos ad=2.04p pd=12.68u as=2.04p ps=12.68u w=6u l=4u
X94 pad Clamp_P_M1_0.gate iovdd iovdd sg13_hv_pmos ad=3.9294p pd=7.84u as=2.1312p ps=7.3u w=6.66u l=0.6u
X95 iovss Clamp_N_M1_0.gate pad iovss sg13_hv_nmos ad=1.408p pd=5.04u as=2.596p ps=5.58u w=4.4u l=0.6u
X96 iovdd s2d_block_0.s2d_loads_f_0.vcmfb iovdd iovdd sg13_hv_pmos ad=0.34p pd=2.68u as=0 ps=0 w=1u l=4u
X97 pad iovdd dpantenna l=1.26u w=27.78u
X98 pad Clamp_P_M1_0.gate iovdd iovdd sg13_hv_pmos ad=3.9294p pd=7.84u as=2.1312p ps=7.3u w=6.66u l=0.6u
X99 iovdd s2d_block_0.s2d_loads_f_0.vcmfb s2d_block_0.s2d_loads_f_0.ln iovdd sg13_hv_pmos ad=2.04p pd=12.68u as=2.04p ps=12.68u w=6u l=4u
X100 iovss Clamp_N_M1_0.gate pad iovss sg13_hv_nmos ad=2.068p pd=9.74u as=2.596p ps=5.58u w=4.4u l=0.6u
X101 s2d_block_0.s2d_loads_f_0.lp s2d_block_0.s2d_loads_f_0.vcmfb iovdd iovdd sg13_hv_pmos ad=2.04p pd=12.68u as=2.04p ps=12.68u w=6u l=4u
X102 iovdd s2d_block_0.s2d_loads_f_0.vcmfb s2d_block_0.s2d_loads_f_0.ln iovdd sg13_hv_pmos ad=2.04p pd=12.68u as=2.04p ps=12.68u w=6u l=4u
X103 iovdd s2d_block_0.s2d_casc_p_f_0.vbpc iovdd iovdd sg13_hv_pmos ad=0.34p pd=2.68u as=0 ps=0 w=1u l=4u
X104 pad Clamp_N_M1_0.gate iovss iovss sg13_hv_nmos ad=2.596p pd=5.58u as=1.408p ps=5.04u w=4.4u l=0.6u
X105 s2d_block_0.s2d_tails_lo_f_0.sa_M2 outn s2d_block_0.s2d_casc_n_f_0.yc s2d_block_0.s2d_tails_lo_f_0.sa_M2 sg13_hv_pmos ad=3.4p pd=20.68u as=1.9p ps=10.38u w=10u l=1u
X106 iovdd s2d_block_0.s2d_casc_p_f_0.vbpc s2d_block_0.s2d_casc_p_f_0.vbpc iovdd sg13_hv_pmos ad=0.34p pd=2.68u as=0.34p ps=2.68u w=1u l=4u
X107 iovdd s2d_block_0.s2d_loads_f_0.vcmfb iovdd iovdd sg13_hv_pmos ad=0.34p pd=2.68u as=0 ps=0 w=1u l=4u
X108 s2d_block_0.s2d_casc_n_f_0.y s2d_block_0.sinks_6x6_s2d_c3_core_0.vbn iovss iovss sg13_hv_nmos ad=2.04p pd=12.68u as=2.04p ps=12.68u w=6u l=6u
X109 iovss outp iovss iovss sg13_hv_nmos ad=4.08p pd=24.68u as=0 ps=0 w=12u l=12u
X110 iovss outn iovss iovss sg13_hv_nmos ad=4.08p pd=24.68u as=0 ps=0 w=12u l=12u
X111 iovdd s2d_block_0.s2d_tails_hi_f_0.vbp s2d_block_0.s2d_tails_hi_f_0.sb_F2 iovdd sg13_hv_pmos ad=1.7p pd=10.68u as=1.7p ps=10.68u w=5u l=6u
X112 s2d_block_0.s2d_casc_n_f_0.x outp s2d_block_0.s2d_tails_hi_f_0.sb_F1 s2d_block_0.s2d_tails_hi_f_0.sb_F1 sg13_hv_pmos ad=1.9p pd=10.38u as=3.4p ps=20.68u w=10u l=1u
X113 s2d_block_0.s2d_casc_n_f_0.xc vcm s2d_block_0.s2d_tails_lo_f_0.sb_M1 s2d_block_0.s2d_tails_lo_f_0.sb_M1 sg13_hv_pmos ad=1.9p pd=10.38u as=3.4p ps=20.68u w=10u l=1u
X114 iovss s2d_block_0.sinks_6x6_s2d_c3_core_0.vbn iovss iovss sg13_hv_nmos ad=0.68p pd=4.68u as=0 ps=0 w=2u l=6u
X115 iovdd s2d_block_0.s2d_casc_p_f_0.vbpc iovdd iovdd sg13_hv_pmos ad=0.34p pd=2.68u as=0 ps=0 w=1u l=4u
X116 a_11758_26326# a_14374_26190# iovss rhigh l=12.65u w=0.5u
X117 s2d_block_0.s2d_tails_lo_f_0.sb_A1 vref s2d_block_0.s2d_casc_n_f_0.x s2d_block_0.s2d_tails_lo_f_0.sb_A1 sg13_hv_pmos ad=3.4p pd=20.68u as=1.9p ps=10.38u w=10u l=1u
X118 s2d_block_0.s2d_casc_n_f_0.x s2d_block_0.sinks_6x6_s2d_c3_core_0.vbn iovss iovss sg13_hv_nmos ad=2.04p pd=12.68u as=2.04p ps=12.68u w=6u l=6u
X119 iovdd Clamp_P_M1_0.gate pad iovdd sg13_hv_pmos ad=2.1312p pd=7.3u as=3.9294p ps=7.84u w=6.66u l=0.6u
X120 s2d_block_0.s2d_tails_lo_f_0.sb_M1 a_14374_27686# iovss rhigh l=12.65u w=0.5u
X121 iovss s2d_block_0.sinks_6x6_s2d_c3_core_0.vbn iovss iovss sg13_hv_nmos ad=0.68p pd=4.68u as=0 ps=0 w=2u l=6u
X122 iovdd Clamp_P_M1_0.gate pad iovdd sg13_hv_pmos ad=2.1312p pd=7.3u as=3.9294p ps=7.84u w=6.66u l=0.6u
X123 s2d_block_0.s2d_tails_hi_f_0.sa_A1 pad s2d_block_0.s2d_casc_n_f_0.y s2d_block_0.s2d_tails_hi_f_0.sa_A1 sg13_hv_pmos ad=3.4p pd=20.68u as=1.9p ps=10.38u w=10u l=1u
X124 s2d_block_0.s2d_tails_lo_f_0.sb_M1 s2d_block_0.s2d_tails_hi_f_0.vbp iovdd iovdd sg13_hv_pmos ad=1.7p pd=10.68u as=1.7p ps=10.68u w=5u l=6u
X125 pad Clamp_P_M1_0.gate iovdd iovdd sg13_hv_pmos ad=3.9294p pd=7.84u as=2.1312p ps=7.3u w=6.66u l=0.6u
X126 iovdd iovdd iovdd iovdd sg13_hv_pmos ad=3.4p pd=20.68u as=0 ps=0 w=10u l=1u
X127 a_11758_26326# a_14374_27822# iovss rhigh l=12.65u w=0.5u
X128 s2d_block_0.s2d_casc_n_f_0.xc s2d_block_0.sinks_6x6_s2d_c3_core_0.vbn iovss iovss sg13_hv_nmos ad=2.04p pd=12.68u as=2.04p ps=12.68u w=6u l=6u
X129 pad Clamp_N_M1_0.gate iovss iovss sg13_hv_nmos ad=2.596p pd=5.58u as=1.408p ps=5.04u w=4.4u l=0.6u
X130 pad Clamp_N_M1_0.gate iovss iovss sg13_hv_nmos ad=2.596p pd=5.58u as=1.408p ps=5.04u w=4.4u l=0.6u
X131 iovdd Clamp_P_M1_0.gate pad iovdd sg13_hv_pmos ad=2.1312p pd=7.3u as=3.9294p ps=7.84u w=6.66u l=0.6u
X132 s2d_block_0.bias_tree_noab_n_c3_0.ni en_3v3_b iref iovdd sg13_hv_pmos ad=0.34p pd=2.68u as=0.34p ps=2.68u w=1u l=0.45u
X133 pad Clamp_P_M1_0.gate iovdd iovdd sg13_hv_pmos ad=3.9294p pd=7.84u as=3.1302p ps=14.26u w=6.66u l=0.6u
X134 pad Clamp_N_M1_0.gate iovss iovss sg13_hv_nmos ad=2.596p pd=5.58u as=1.408p ps=5.04u w=4.4u l=0.6u
X135 a_11758_26462# a_14374_26054# iovss rhigh l=12.65u w=0.5u
X136 s2d_block_0.s2d_loads_f_0.dd s2d_block_0.s2d_loads_f_0.vcmfb iovdd iovdd sg13_hv_pmos ad=2.04p pd=12.68u as=2.04p ps=12.68u w=6u l=4u
X137 iovss s2d_block_0.sinks_6x6_s2d_c3_core_0.vbn iovss iovss sg13_hv_nmos ad=0.68p pd=4.68u as=0 ps=0 w=2u l=6u
X138 iovdd iovdd iovdd iovdd sg13_hv_pmos ad=1.9p pd=10.38u as=0 ps=0 w=10u l=1u
X139 s2d_block_0.s2d_loads_f_0.vcmfb s2d_block_0.s2d_casc_p_f_0.vbpc s2d_block_0.s2d_loads_f_0.dd iovdd sg13_hv_pmos ad=5.1p pd=30.68u as=5.1p ps=30.68u w=15u l=3u
X140 iovdd s2d_block_0.s2d_tails_hi_f_0.vbp s2d_block_0.s2d_tails_hi_f_0.vbp iovdd sg13_hv_pmos ad=1.7p pd=10.68u as=1.7p ps=10.68u w=5u l=6u
X141 s2d_block_0.bias_tree_noab_n_c3_0.ni s2d_block_0.bias_tree_noab_n_c3_0.ni iovss iovss sg13_hv_nmos ad=2.04p pd=12.68u as=2.04p ps=12.68u w=6u l=6u
X142 iovdd Clamp_P_M1_0.gate pad iovdd sg13_hv_pmos ad=2.1312p pd=7.3u as=3.9294p ps=7.84u w=6.66u l=0.6u
X143 s2d_block_0.s2d_tails_lo_f_0.sa_M2 s2d_block_0.s2d_tails_hi_f_0.vbp iovdd iovdd sg13_hv_pmos ad=1.7p pd=10.68u as=1.7p ps=10.68u w=5u l=6u
X144 outn s2d_block_0.s2d_casc_n_f_0.vbnc s2d_block_0.s2d_casc_n_f_0.y iovss sg13_hv_nmos ad=5.1p pd=30.68u as=5.1p ps=30.68u w=15u l=3u
X145 iovdd Clamp_P_M1_0.gate pad iovdd sg13_hv_pmos ad=2.1312p pd=7.3u as=3.9294p ps=7.84u w=6.66u l=0.6u
X146 iovdd Clamp_P_M1_0.gate pad iovdd sg13_hv_pmos ad=2.1312p pd=7.3u as=3.9294p ps=7.84u w=6.66u l=0.6u
X147 s2d_block_0.s2d_casc_n_f_0.yc s2d_block_0.sinks_6x6_s2d_c3_core_0.vbn iovss iovss sg13_hv_nmos ad=2.04p pd=12.68u as=2.04p ps=12.68u w=6u l=6u
X148 s2d_block_0.s2d_casc_n_f_0.xc vcm s2d_block_0.s2d_tails_hi_f_0.sb_M2 s2d_block_0.s2d_tails_hi_f_0.sb_M2 sg13_hv_pmos ad=1.9p pd=10.38u as=3.4p ps=20.68u w=10u l=1u
X149 s2d_block_0.s2d_casc_n_f_0.y outn s2d_block_0.s2d_tails_lo_f_0.sa_F2 s2d_block_0.s2d_tails_lo_f_0.sa_F2 sg13_hv_pmos ad=1.9p pd=10.38u as=3.4p ps=20.68u w=10u l=1u
X150 s2d_block_0.s2d_tails_hi_f_0.sa_M1 outp s2d_block_0.s2d_casc_n_f_0.yc s2d_block_0.s2d_tails_hi_f_0.sa_M1 sg13_hv_pmos ad=3.4p pd=20.68u as=1.9p ps=10.38u w=10u l=1u
X151 pad Clamp_P_M1_0.gate iovdd iovdd sg13_hv_pmos ad=3.9294p pd=7.84u as=2.1312p ps=7.3u w=6.66u l=0.6u
X152 s2d_block_0.s2d_tails_lo_f_0.sa_F2 a_14374_25918# iovss rhigh l=12.65u w=0.5u
X153 s2d_block_0.sinks_6x6_s2d_c3_core_0.vbn s2d_block_0.sinks_6x6_s2d_c3_core_0.vbn iovss iovss sg13_hv_nmos ad=2.04p pd=12.68u as=2.04p ps=12.68u w=6u l=6u
X154 iovdd Clamp_P_M1_0.gate pad iovdd sg13_hv_pmos ad=2.1312p pd=7.3u as=3.9294p ps=7.84u w=6.66u l=0.6u
X155 iovss s2d_block_0.s2d_casc_n_f_0.vbnc iovss iovss sg13_hv_nmos ad=0.68p pd=4.68u as=0 ps=0 w=2u l=3u
X156 s2d_block_0.s2d_tails_lo_f_0.sa_F2 s2d_block_0.s2d_tails_hi_f_0.vbp iovdd iovdd sg13_hv_pmos ad=1.7p pd=10.68u as=1.7p ps=10.68u w=5u l=6u
X157 iovss Clamp_N_M1_0.gate pad iovss sg13_hv_nmos ad=1.408p pd=5.04u as=2.596p ps=5.58u w=4.4u l=0.6u
X158 s2d_block_0.s2d_tails_lo_f_0.sb_A2 vref s2d_block_0.s2d_casc_n_f_0.x s2d_block_0.s2d_tails_lo_f_0.sb_A2 sg13_hv_pmos ad=3.4p pd=20.68u as=1.9p ps=10.38u w=10u l=1u
X159 pad Clamp_N_M1_0.gate iovss iovss sg13_hv_nmos ad=2.596p pd=5.58u as=1.408p ps=5.04u w=4.4u l=0.6u
X160 a_11758_26462# a_14374_27686# iovss rhigh l=12.65u w=0.5u
X161 s2d_block_0.s2d_casc_n_f_0.x s2d_block_0.sinks_6x6_s2d_c3_core_0.vbn iovss iovss sg13_hv_nmos ad=2.04p pd=12.68u as=2.04p ps=12.68u w=6u l=6u
X162 iovdd Clamp_P_M1_0.gate pad iovdd sg13_hv_pmos ad=2.1312p pd=7.3u as=3.9294p ps=7.84u w=6.66u l=0.6u
X163 s2d_block_0.s2d_tails_hi_f_0.vbp s2d_block_0.bias_tree_noab_n_c3_0.ni iovss iovss sg13_hv_nmos ad=2.04p pd=12.68u as=2.04p ps=12.68u w=6u l=6u
X164 pad Clamp_P_M1_0.gate iovdd iovdd sg13_hv_pmos ad=3.9294p pd=7.84u as=3.1302p ps=14.26u w=6.66u l=0.6u
X165 iovdd iovdd iovdd iovdd sg13_hv_pmos ad=3.4p pd=20.68u as=0 ps=0 w=10u l=1u
X166 iovss s2d_block_0.sinks_6x6_s2d_c3_core_0.vbn s2d_block_0.s2d_casc_n_f_0.xc iovss sg13_hv_nmos ad=2.04p pd=12.68u as=2.04p ps=12.68u w=6u l=6u
X167 Clamp_N_M1_0.gate iovss iovss rppd l=3.54u w=0.5u
X168 iovdd Clamp_P_M1_0.gate pad iovdd sg13_hv_pmos ad=2.1312p pd=7.3u as=3.9294p ps=7.84u w=6.66u l=0.6u
X169 iovss s2d_block_0.s2d_casc_n_f_0.vbnc iovss iovss sg13_hv_nmos ad=0.68p pd=4.68u as=0 ps=0 w=2u l=3u
X170 iovdd iovdd iovdd iovdd sg13_hv_pmos ad=1.9p pd=10.38u as=0 ps=0 w=10u l=1u
X171 s2d_block_0.s2d_tails_lo_f_0.sb_A1 s2d_block_0.s2d_tails_hi_f_0.vbp iovdd iovdd sg13_hv_pmos ad=1.7p pd=10.68u as=1.7p ps=10.68u w=5u l=6u
X172 pad Clamp_P_M1_0.gate iovdd iovdd sg13_hv_pmos ad=3.9294p pd=7.84u as=2.1312p ps=7.3u w=6.66u l=0.6u
X173 a_11758_26734# a_14374_27414# iovss rhigh l=12.65u w=0.5u
X174 pad Clamp_P_M1_0.gate iovdd iovdd sg13_hv_pmos ad=3.9294p pd=7.84u as=2.1312p ps=7.3u w=6.66u l=0.6u
X175 iovdd Clamp_P_M1_0.gate pad iovdd sg13_hv_pmos ad=2.1312p pd=7.3u as=3.9294p ps=7.84u w=6.66u l=0.6u
X176 iovdd Clamp_P_M1_0.gate pad iovdd sg13_hv_pmos ad=3.1302p pd=14.26u as=3.9294p ps=7.84u w=6.66u l=0.6u
X177 outn s2d_block_0.s2d_casc_p_f_0.vbpc s2d_block_0.s2d_loads_f_0.ln iovdd sg13_hv_pmos ad=5.1p pd=30.68u as=5.1p ps=30.68u w=15u l=3u
X178 s2d_block_0.s2d_casc_n_f_0.y pad s2d_block_0.s2d_tails_hi_f_0.sa_A2 s2d_block_0.s2d_tails_hi_f_0.sa_A2 sg13_hv_pmos ad=1.9p pd=10.38u as=3.4p ps=20.68u w=10u l=1u
X179 pad Clamp_P_M1_0.gate iovdd iovdd sg13_hv_pmos ad=3.9294p pd=7.84u as=2.1312p ps=7.3u w=6.66u l=0.6u
X180 iovss Clamp_N_M1_0.gate pad iovss sg13_hv_nmos ad=1.408p pd=5.04u as=2.596p ps=5.58u w=4.4u l=0.6u
X181 s2d_block_0.s2d_casc_n_f_0.yc outn s2d_block_0.s2d_tails_lo_f_0.sa_M2 s2d_block_0.s2d_tails_lo_f_0.sa_M2 sg13_hv_pmos ad=1.9p pd=10.38u as=3.4p ps=20.68u w=10u l=1u
X182 s2d_block_0.s2d_tails_lo_f_0.sb_A2 s2d_block_0.s2d_tails_hi_f_0.vbp iovdd iovdd sg13_hv_pmos ad=1.7p pd=10.68u as=1.7p ps=10.68u w=5u l=6u
X183 iovss s2d_block_0.sinks_6x6_s2d_c3_core_0.vbn s2d_block_0.s2d_casc_n_f_0.x iovss sg13_hv_nmos ad=2.04p pd=12.68u as=2.04p ps=12.68u w=6u l=6u
X184 iovss Clamp_N_M1_0.gate pad iovss sg13_hv_nmos ad=1.408p pd=5.04u as=2.596p ps=5.58u w=4.4u l=0.6u
X185 s2d_block_0.s2d_loads_f_0.lp s2d_block_0.s2d_loads_f_0.vcmfb iovdd iovdd sg13_hv_pmos ad=2.04p pd=12.68u as=2.04p ps=12.68u w=6u l=4u
X186 s2d_block_0.sinks_6x6_s2d_c3_core_0.vbn s2d_block_0.s2d_tails_hi_f_0.vbp iovdd iovdd sg13_hv_pmos ad=1.7p pd=10.68u as=1.7p ps=10.68u w=5u l=6u
X187 s2d_block_0.s2d_tails_lo_f_0.sb_M1 vcm s2d_block_0.s2d_casc_n_f_0.xc s2d_block_0.s2d_tails_lo_f_0.sb_M1 sg13_hv_pmos ad=3.4p pd=20.68u as=1.9p ps=10.38u w=10u l=1u
X188 outp s2d_block_0.s2d_casc_n_f_0.vbnc s2d_block_0.s2d_casc_n_f_0.x iovss sg13_hv_nmos ad=5.1p pd=30.68u as=5.1p ps=30.68u w=15u l=3u
X189 s2d_block_0.s2d_tails_hi_f_0.sa_M1 a_14374_26054# iovss rhigh l=12.65u w=0.5u
X190 iovss Clamp_N_M1_0.gate pad iovss sg13_hv_nmos ad=1.408p pd=5.04u as=2.596p ps=5.58u w=4.4u l=0.6u
X191 iovss s2d_block_0.s2d_casc_n_f_0.vbnc iovss iovss sg13_hv_nmos ad=0.68p pd=4.68u as=0 ps=0 w=2u l=3u
X192 iovss s2d_block_0.sinks_6x6_s2d_c3_core_0.vbn s2d_block_0.s2d_casc_n_f_0.x iovss sg13_hv_nmos ad=2.04p pd=12.68u as=2.04p ps=12.68u w=6u l=6u
X193 iovss s2d_block_0.sinks_6x6_s2d_c3_core_0.vbn iovss iovss sg13_hv_nmos ad=0.68p pd=4.68u as=0 ps=0 w=2u l=6u
X194 iovdd s2d_block_0.s2d_loads_f_0.vcmfb iovdd iovdd sg13_hv_pmos ad=0.34p pd=2.68u as=0 ps=0 w=1u l=4u
X195 outn en_3v3_b vcm iovss sg13_hv_nmos ad=0.34p pd=2.68u as=0.19p ps=1.38u w=1u l=0.45u
X196 s2d_block_0.s2d_tails_hi_f_0.sb_F2 vcm s2d_block_0.s2d_casc_n_f_0.x s2d_block_0.s2d_tails_hi_f_0.sb_F2 sg13_hv_pmos ad=3.4p pd=20.68u as=1.9p ps=10.38u w=10u l=1u
X197 iovss s2d_block_0.sinks_6x6_s2d_c3_core_0.vbn iovss iovss sg13_hv_nmos ad=0.68p pd=4.68u as=0 ps=0 w=2u l=6u
X198 s2d_block_0.s2d_casc_n_f_0.x s2d_block_0.sinks_6x6_s2d_c3_core_0.vbn iovss iovss sg13_hv_nmos ad=2.04p pd=12.68u as=2.04p ps=12.68u w=6u l=6u
X199 s2d_block_0.s2d_casc_n_f_0.y pad s2d_block_0.s2d_tails_hi_f_0.sa_A1 s2d_block_0.s2d_tails_hi_f_0.sa_A1 sg13_hv_pmos ad=1.9p pd=10.38u as=3.4p ps=20.68u w=10u l=1u
X200 s2d_block_0.s2d_tails_lo_f_0.sb_A1 a_14374_27142# iovss rhigh l=12.65u w=0.5u
X201 iovdd s2d_block_0.s2d_loads_f_0.vcmfb s2d_block_0.s2d_loads_f_0.dd iovdd sg13_hv_pmos ad=2.04p pd=12.68u as=2.04p ps=12.68u w=6u l=4u
X202 iovdd iovdd iovdd iovdd sg13_hv_pmos ad=1.9p pd=10.38u as=0 ps=0 w=10u l=1u
X203 iovdd Clamp_P_M1_0.gate pad iovdd sg13_hv_pmos ad=2.1312p pd=7.3u as=3.9294p ps=7.84u w=6.66u l=0.6u
X204 iovdd s2d_block_0.s2d_loads_f_0.vcmfb iovdd iovdd sg13_hv_pmos ad=0.34p pd=2.68u as=0 ps=0 w=1u l=4u
X205 a_11758_26598# a_14374_27550# iovss rhigh l=12.65u w=0.5u
X206 s2d_block_0.s2d_casc_n_f_0.xc s2d_block_0.s2d_casc_n_f_0.vbnc s2d_block_0.s2d_loads_f_0.vcmfb iovss sg13_hv_nmos ad=5.1p pd=30.68u as=5.1p ps=30.68u w=15u l=3u
X207 pad Clamp_P_M1_0.gate iovdd iovdd sg13_hv_pmos ad=3.9294p pd=7.84u as=2.1312p ps=7.3u w=6.66u l=0.6u
X208 s2d_block_0.s2d_tails_lo_f_0.sa_F1 s2d_block_0.s2d_tails_hi_f_0.vbp iovdd iovdd sg13_hv_pmos ad=1.7p pd=10.68u as=1.7p ps=10.68u w=5u l=6u
X209 iovdd Clamp_P_M1_0.gate pad iovdd sg13_hv_pmos ad=3.1302p pd=14.26u as=3.9294p ps=7.84u w=6.66u l=0.6u
X210 outp s2d_block_0.s2d_casc_p_f_0.vbpc s2d_block_0.s2d_loads_f_0.lp iovdd sg13_hv_pmos ad=5.1p pd=30.68u as=5.1p ps=30.68u w=15u l=3u
X211 iovdd s2d_block_0.s2d_tails_hi_f_0.vbp iovdd iovdd sg13_hv_pmos ad=0.68p pd=4.68u as=0 ps=0 w=2u l=6u
X212 a_11758_26870# a_14374_27278# iovss rhigh l=12.65u w=0.5u
X213 s2d_block_0.s2d_casc_n_f_0.vbnc s2d_block_0.s2d_casc_n_f_0.vbnc iovss iovss sg13_hv_nmos ad=0.34p pd=2.68u as=0.34p ps=2.68u w=1u l=8u
X214 pad Clamp_P_M1_0.gate iovdd iovdd sg13_hv_pmos ad=3.9294p pd=7.84u as=2.1312p ps=7.3u w=6.66u l=0.6u
X215 iovss s2d_block_0.sinks_6x6_s2d_c3_core_0.vbn s2d_block_0.s2d_casc_n_f_0.yc iovss sg13_hv_nmos ad=2.04p pd=12.68u as=2.04p ps=12.68u w=6u l=6u
X216 iovss Clamp_N_M1_0.gate pad iovss sg13_hv_nmos ad=1.408p pd=5.04u as=2.596p ps=5.58u w=4.4u l=0.6u
X217 s2d_block_0.s2d_tails_lo_f_0.sa_M2 a_14374_26190# iovss rhigh l=12.65u w=0.5u
X218 s2d_block_0.s2d_loads_f_0.vcmfb s2d_block_0.s2d_casc_n_f_0.vbnc s2d_block_0.s2d_casc_n_f_0.xc iovss sg13_hv_nmos ad=5.1p pd=30.68u as=5.1p ps=30.68u w=15u l=3u
X219 iovss pad dantenna l=1.26u w=27.78u
X220 s2d_block_0.s2d_loads_f_0.dd s2d_block_0.s2d_casc_p_f_0.vbpc s2d_block_0.s2d_loads_f_0.vcmfb iovdd sg13_hv_pmos ad=5.1p pd=30.68u as=5.1p ps=30.68u w=15u l=3u
X221 iovdd iovdd iovdd iovdd sg13_hv_pmos ad=3.4p pd=20.68u as=0 ps=0 w=10u l=1u
X222 s2d_block_0.s2d_casc_n_f_0.x vref s2d_block_0.s2d_tails_lo_f_0.sb_A1 s2d_block_0.s2d_tails_lo_f_0.sb_A1 sg13_hv_pmos ad=1.9p pd=10.38u as=3.4p ps=20.68u w=10u l=1u
X223 iovss Clamp_N_M1_0.gate pad iovss sg13_hv_nmos ad=1.408p pd=5.04u as=2.596p ps=5.58u w=4.4u l=0.6u
X224 iovss s2d_block_0.sinks_6x6_s2d_c3_core_0.vbn iovss iovss sg13_hv_nmos ad=0.68p pd=4.68u as=0 ps=0 w=2u l=6u
C0 a_11844_27414# a_11758_26734# 0.01944f
C1 a_11844_26054# a_11844_25918# 0.63642f
C2 a_11758_26598# a_11758_26462# 1.00966f
C3 s2d_block_0.s2d_casc_n_f_0.yc s2d_block_0.s2d_tails_lo_f_0.sa_F2 0.01488f
C4 a_11844_26054# a_14374_26054# 0.02728f
C5 vref en_3v3 0.29868f
C6 s2d_block_0.s2d_tails_lo_f_0.sa_M2 s2d_block_0.s2d_tails_lo_f_0.sa_F2 0.03184f
C7 s2d_block_0.s2d_casc_n_f_0.x s2d_block_0.s2d_tails_hi_f_0.vbp 0.88785f
C8 s2d_block_0.s2d_tails_lo_f_0.sb_A1 s2d_block_0.s2d_tails_lo_f_0.sb_M1 0.42502f
C9 vdd a_11844_27414# 0.01616f
C10 s2d_block_0.s2d_tails_hi_f_0.sb_F2 s2d_block_0.s2d_tails_hi_f_0.sa_A2 0.06194f
C11 vdd a_11758_26326# 0.01425f
C12 vref outn 5.90972f
C13 en_3v3 s2d_block_0.s2d_casc_n_f_0.vbnc 0.02771f
C14 s2d_block_0.s2d_tails_hi_f_0.sa_A1 s2d_block_0.s2d_tails_lo_f_0.sa_F2 0.03918f
C15 outp s2d_block_0.s2d_loads_f_0.ln 0.02981f
C16 outp s2d_block_0.s2d_casc_p_f_0.vbpc 1.4341f
C17 outn s2d_block_0.s2d_casc_n_f_0.vbnc 9.71317f
C18 s2d_block_0.s2d_loads_f_0.lp s2d_block_0.s2d_casc_n_f_0.yc 0.89259f
C19 a_8120_4634# Clamp_P_M1_0.gate 0.03336f
C20 a_14374_25510# a_14374_27142# 0.27561f
C21 en_3v3 en_3v3_b 0.17956f
C22 s2d_block_0.s2d_tails_hi_f_0.sb_F2 vdd 0.10958f
C23 vref s2d_block_0.s2d_tails_lo_f_0.sb_A2 2.83717f
C24 s2d_block_0.s2d_tails_hi_f_0.sb_F2 vcm 3.14225f
C25 s2d_block_0.s2d_tails_hi_f_0.sb_F1 outp 4.17044f
C26 iovdd s2d_block_0.s2d_casc_n_f_0.yc 12.9248f
C27 outn en_3v3_b 0.35641f
C28 s2d_block_0.s2d_tails_lo_f_0.sa_F2 s2d_block_0.s2d_tails_hi_f_0.sa_A2 0.64797f
C29 iovdd s2d_block_0.s2d_tails_lo_f_0.sa_M2 1.56854f
C30 a_11758_26870# s2d_block_0.s2d_tails_lo_f_0.sb_A2 0.04798f
C31 s2d_block_0.s2d_casc_n_f_0.yc s2d_block_0.s2d_tails_lo_f_0.sa_F1 0.03413f
C32 s2d_block_0.s2d_loads_f_0.dd s2d_block_0.sinks_6x6_s2d_c3_core_0.vbn 0.01271f
C33 a_11844_27550# a_11844_27686# 0.63642f
C34 a_11844_25918# s2d_block_0.s2d_tails_hi_f_0.sa_A2 0.01081f
C35 a_11844_27822# a_11758_26326# 0.01932f
C36 s2d_block_0.s2d_tails_lo_f_0.sa_M2 s2d_block_0.s2d_tails_lo_f_0.sa_F1 1.57654f
C37 s2d_block_0.s2d_tails_hi_f_0.sb_M2 s2d_block_0.s2d_tails_lo_f_0.sb_M1 0.32756f
C38 a_11844_27958# a_11844_28094# 0.63642f
C39 s2d_block_0.s2d_tails_hi_f_0.sa_A1 iovdd 1.02088f
C40 s2d_block_0.s2d_tails_hi_f_0.sb_F2 s2d_block_0.s2d_tails_hi_f_0.sa_M1 0.02897f
C41 pad s2d_block_0.s2d_tails_hi_f_0.sb_M2 0.06574f
C42 s2d_block_0.s2d_tails_hi_f_0.sa_A1 s2d_block_0.s2d_tails_lo_f_0.sa_F1 0.24121f
C43 s2d_block_0.s2d_casc_p_f_0.vbpc s2d_block_0.s2d_tails_lo_f_0.sb_M1 0.02091f
C44 vdd s2d_block_0.s2d_tails_lo_f_0.sa_F2 0.02196f
C45 s2d_block_0.s2d_tails_hi_f_0.sb_F2 s2d_block_0.s2d_tails_hi_f_0.vbp 0.45545f
C46 vcm s2d_block_0.s2d_tails_lo_f_0.sa_F2 0.22099f
C47 outn s2d_block_0.sinks_6x6_s2d_c3_core_0.vbn 0.02952f
C48 s2d_block_0.s2d_tails_hi_f_0.sb_F2 a_11844_27822# 0.02771f
C49 s2d_block_0.s2d_tails_hi_f_0.sb_F2 a_11844_28230# 0.1402f
C50 vref s2d_block_0.s2d_casc_n_f_0.x 1.29464f
C51 s2d_block_0.s2d_loads_f_0.dd s2d_block_0.s2d_loads_f_0.vcmfb 1.69244f
C52 outn s2d_block_0.s2d_casc_n_f_0.xc 0.5833f
C53 iovdd s2d_block_0.s2d_tails_hi_f_0.sa_A2 0.79139f
C54 iovdd a_14374_25510# 0.02823f
C55 s2d_block_0.s2d_tails_hi_f_0.sb_F1 pad 0.07445f
C56 a_11844_26190# a_11844_26326# 0.63642f
C57 s2d_block_0.s2d_tails_lo_f_0.sa_F2 s2d_block_0.s2d_tails_hi_f_0.sa_M1 5.13302f
C58 s2d_block_0.s2d_casc_n_f_0.x s2d_block_0.s2d_casc_n_f_0.vbnc 3.02607f
C59 s2d_block_0.s2d_tails_lo_f_0.sb_A2 s2d_block_0.sinks_6x6_s2d_c3_core_0.vbn 0.1341f
C60 s2d_block_0.s2d_tails_lo_f_0.sa_F1 s2d_block_0.s2d_tails_hi_f_0.sa_A2 0.31556f
C61 s2d_block_0.s2d_tails_hi_f_0.sb_F2 a_11844_26462# 0.02158f
C62 a_11758_26598# s2d_block_0.s2d_tails_lo_f_0.sb_A1 0.01794f
C63 iovdd Clamp_P_M1_0.gate 44.7526f
C64 s2d_block_0.s2d_tails_hi_f_0.sb_M2 s2d_block_0.s2d_tails_lo_f_0.sb_A1 0.08819f
C65 s2d_block_0.s2d_tails_hi_f_0.vbp s2d_block_0.s2d_tails_lo_f_0.sa_F2 0.24847f
C66 s2d_block_0.s2d_casc_n_f_0.xc s2d_block_0.s2d_tails_lo_f_0.sb_A2 0.11316f
C67 outp s2d_block_0.s2d_casc_n_f_0.yc 0.95108f
C68 outn s2d_block_0.s2d_loads_f_0.vcmfb 4.70815f
C69 vdd iovdd 5.0684f
C70 outp s2d_block_0.s2d_tails_lo_f_0.sa_M2 0.10643f
C71 vcm iovdd 7.80763f
C72 a_11844_25782# a_11844_25646# 0.63642f
C73 s2d_block_0.s2d_casc_p_f_0.vbpc s2d_block_0.s2d_tails_lo_f_0.sb_A1 1.20865f
C74 a_14374_27822# a_14374_27686# 0.33426f
C75 vcm s2d_block_0.s2d_tails_lo_f_0.sa_F1 2.76774f
C76 a_14374_27550# a_11844_28230# 0.02719f
C77 s2d_block_0.s2d_tails_hi_f_0.sa_A1 outp 0.14921f
C78 a_11844_28366# a_11844_28502# 0.63642f
C79 en_3v3 s2d_block_0.bias_tree_noab_n_c3_0.ni 0.06108f
C80 a_14374_25646# a_11844_25646# 0.0271f
C81 iref s2d_block_0.s2d_casc_p_f_0.vbpc 0.22924f
C82 s2d_block_0.s2d_tails_hi_f_0.sb_F1 s2d_block_0.s2d_tails_lo_f_0.sb_A1 0.07599f
C83 iovdd s2d_block_0.s2d_tails_hi_f_0.sa_M1 0.70405f
C84 s2d_block_0.s2d_casc_n_f_0.x s2d_block_0.sinks_6x6_s2d_c3_core_0.vbn 11.6323f
C85 s2d_block_0.s2d_tails_hi_f_0.sb_F2 a_11844_25782# 0.02723f
C86 iovdd s2d_block_0.s2d_tails_hi_f_0.vbp 75.9722f
C87 s2d_block_0.s2d_tails_hi_f_0.sa_A1 a_11844_25510# 0.01933f
C88 s2d_block_0.s2d_tails_hi_f_0.sb_F2 vref 0.09756f
C89 s2d_block_0.s2d_casc_n_f_0.yc s2d_block_0.s2d_tails_lo_f_0.sb_M1 0.25635f
C90 outn s2d_block_0.s2d_casc_n_f_0.y 0.87677f
C91 a_14374_26054# a_11844_26462# 0.02728f
C92 a_11844_26598# a_11844_26734# 0.63642f
C93 s2d_block_0.s2d_casc_n_f_0.x s2d_block_0.s2d_casc_n_f_0.xc 0.34889f
C94 s2d_block_0.s2d_tails_lo_f_0.sa_F1 s2d_block_0.s2d_tails_hi_f_0.vbp 0.24852f
C95 s2d_block_0.s2d_tails_lo_f_0.sa_M2 s2d_block_0.s2d_tails_lo_f_0.sb_M1 0.28167f
C96 pad s2d_block_0.s2d_casc_n_f_0.yc 0.03716f
C97 vdd a_11844_27278# 0.01422f
C98 vdd a_11758_26462# 0.0103f
C99 Clamp_N_M1_0.gate s2d_block_0.s2d_casc_n_f_0.vbnc 0.01062f
C100 s2d_block_0.s2d_casc_p_f_0.vbpc s2d_block_0.s2d_tails_hi_f_0.sb_M2 0.03287f
C101 s2d_block_0.s2d_tails_hi_f_0.sa_A1 pad 2.83737f
C102 s2d_block_0.s2d_tails_lo_f_0.sb_A2 s2d_block_0.s2d_casc_n_f_0.y 0.32677f
C103 vdd outp 4.08914f
C104 vcm outp 0.54809f
C105 s2d_block_0.s2d_loads_f_0.ln s2d_block_0.s2d_casc_p_f_0.vbpc 1.72179f
C106 s2d_block_0.s2d_loads_f_0.vcmfb s2d_block_0.s2d_casc_n_f_0.x 0.26198f
C107 a_11844_25510# s2d_block_0.s2d_tails_hi_f_0.sa_A2 0.02242f
C108 a_14374_25510# a_11844_25510# 0.02707f
C109 a_11844_25782# s2d_block_0.s2d_tails_lo_f_0.sa_F2 0.03632f
C110 s2d_block_0.s2d_tails_hi_f_0.sb_F1 s2d_block_0.s2d_tails_hi_f_0.sb_M2 1.52485f
C111 vref s2d_block_0.s2d_tails_lo_f_0.sa_F2 0.19414f
C112 a_14374_27414# a_14374_27278# 1.00966f
C113 a_11844_25782# a_11844_25918# 0.63642f
C114 s2d_block_0.s2d_tails_hi_f_0.sb_F1 s2d_block_0.s2d_casc_p_f_0.vbpc 0.1427f
C115 s2d_block_0.s2d_tails_lo_f_0.sb_M1 s2d_block_0.s2d_tails_hi_f_0.sa_A2 1.27636f
C116 a_11758_27006# s2d_block_0.s2d_tails_lo_f_0.sb_A2 0.0467f
C117 s2d_block_0.s2d_casc_n_f_0.yc s2d_block_0.s2d_tails_lo_f_0.sb_A1 0.3272f
C118 outp s2d_block_0.s2d_tails_hi_f_0.sa_M1 2.77025f
C119 pad s2d_block_0.s2d_tails_hi_f_0.sa_A2 2.82194f
C120 a_11844_28502# s2d_block_0.s2d_tails_hi_f_0.sa_A2 0.01142f
C121 s2d_block_0.s2d_tails_lo_f_0.sa_M2 s2d_block_0.s2d_tails_lo_f_0.sb_A1 0.21024f
C122 Clamp_N_M1_0.gate s2d_block_0.sinks_6x6_s2d_c3_core_0.vbn 0.02015f
C123 s2d_block_0.s2d_tails_hi_f_0.sb_F2 s2d_block_0.sinks_6x6_s2d_c3_core_0.vbn 2.97635f
C124 outp s2d_block_0.s2d_tails_hi_f_0.vbp 0.13321f
C125 s2d_block_0.s2d_tails_hi_f_0.sa_A1 s2d_block_0.s2d_tails_lo_f_0.sb_A1 0.27455f
C126 a_14374_25918# a_14374_25782# 0.78325f
C127 pad Clamp_P_M1_0.gate 19.5174f
C128 a_14374_25646# a_11844_26870# 0.0271f
C129 vcm s2d_block_0.s2d_tails_lo_f_0.sb_M1 2.76676f
C130 s2d_block_0.s2d_tails_hi_f_0.sb_F2 s2d_block_0.s2d_casc_n_f_0.xc 0.9746f
C131 a_11844_26734# a_11758_26734# 0.01944f
C132 a_11844_26462# a_11758_26462# 0.01935f
C133 a_11844_26870# a_11758_26870# 0.01953f
C134 a_11844_27006# a_11758_27006# 0.01971f
C135 s2d_block_0.s2d_casc_n_f_0.x s2d_block_0.s2d_casc_n_f_0.y 23.2365f
C136 a_11844_26326# a_11758_26326# 0.01932f
C137 a_11844_26598# a_11758_26598# 0.01938f
C138 vdd pad 0.09566f
C139 vref iovdd 0.94237f
C140 pad vcm 0.33417f
C141 s2d_block_0.s2d_tails_hi_f_0.sb_F2 a_11844_27686# 0.02495f
C142 a_11844_25782# s2d_block_0.s2d_tails_lo_f_0.sa_F1 0.01924f
C143 s2d_block_0.s2d_tails_hi_f_0.sb_F2 a_11844_28094# 0.06483f
C144 vref s2d_block_0.s2d_tails_lo_f_0.sa_F1 0.06427f
C145 iovdd a_14374_25646# 0.01766f
C146 iovdd s2d_block_0.s2d_casc_n_f_0.vbnc 14.3126f
C147 a_11844_28774# a_11844_28638# 0.63642f
C148 s2d_block_0.s2d_tails_hi_f_0.sb_F1 a_11844_28366# 0.01924f
C149 s2d_block_0.s2d_tails_lo_f_0.sb_M1 s2d_block_0.s2d_tails_hi_f_0.sa_M1 0.02734f
C150 s2d_block_0.s2d_tails_lo_f_0.sb_A1 s2d_block_0.s2d_tails_hi_f_0.sa_A2 0.03629f
C151 s2d_block_0.s2d_tails_hi_f_0.sb_F2 a_11844_26326# 0.02158f
C152 a_11758_26734# s2d_block_0.s2d_tails_lo_f_0.sb_A1 0.01181f
C153 s2d_block_0.s2d_casc_n_f_0.yc s2d_block_0.s2d_tails_hi_f_0.sb_M2 0.2619f
C154 pad s2d_block_0.s2d_tails_hi_f_0.sa_M1 0.07254f
C155 iovdd en_3v3_b 1.22713f
C156 s2d_block_0.s2d_tails_hi_f_0.vbp s2d_block_0.s2d_tails_lo_f_0.sb_M1 0.24775f
C157 s2d_block_0.s2d_loads_f_0.ln s2d_block_0.s2d_casc_n_f_0.yc 0.04676f
C158 outn s2d_block_0.s2d_loads_f_0.dd 0.03812f
C159 pad s2d_block_0.s2d_tails_hi_f_0.vbp 1.16149f
C160 a_11844_27822# s2d_block_0.s2d_tails_lo_f_0.sb_M1 0.01326f
C161 s2d_block_0.s2d_casc_p_f_0.vbpc s2d_block_0.s2d_casc_n_f_0.yc 0.05155f
C162 s2d_block_0.s2d_tails_hi_f_0.sa_A1 s2d_block_0.s2d_tails_hi_f_0.sb_M2 0.38962f
C163 s2d_block_0.s2d_casc_p_f_0.vbpc s2d_block_0.s2d_tails_lo_f_0.sa_M2 0.04225f
C164 en_3v3 outn 0.88692f
C165 s2d_block_0.s2d_loads_f_0.lp s2d_block_0.sinks_6x6_s2d_c3_core_0.vbn 0.01951f
C166 s2d_block_0.s2d_tails_hi_f_0.sb_F1 s2d_block_0.s2d_casc_n_f_0.yc 0.01163f
C167 s2d_block_0.s2d_tails_hi_f_0.sa_A1 s2d_block_0.s2d_casc_p_f_0.vbpc 1.34004f
C168 iref vdd 1.6991f
C169 iovdd s2d_block_0.sinks_6x6_s2d_c3_core_0.vbn 18.5068f
C170 a_11844_27278# a_11758_26870# 0.01953f
C171 s2d_block_0.s2d_tails_hi_f_0.sb_F2 s2d_block_0.s2d_casc_n_f_0.y 0.26538f
C172 a_11758_26734# a_11758_26598# 0.78325f
C173 vref outp 0.12646f
C174 s2d_block_0.s2d_tails_hi_f_0.sa_A1 s2d_block_0.s2d_tails_hi_f_0.sb_F1 0.68676f
C175 s2d_block_0.s2d_tails_lo_f_0.sb_A1 s2d_block_0.s2d_tails_hi_f_0.sa_M1 0.02734f
C176 s2d_block_0.s2d_tails_hi_f_0.sb_M2 s2d_block_0.s2d_tails_hi_f_0.sa_A2 0.10456f
C177 s2d_block_0.s2d_tails_lo_f_0.sa_F1 s2d_block_0.sinks_6x6_s2d_c3_core_0.vbn 0.04563f
C178 iovdd s2d_block_0.s2d_casc_n_f_0.xc 7.38042f
C179 outp s2d_block_0.s2d_casc_n_f_0.vbnc 10.0705f
C180 outn s2d_block_0.s2d_tails_lo_f_0.sb_A2 0.02396f
C181 s2d_block_0.s2d_tails_lo_f_0.sa_F1 s2d_block_0.s2d_casc_n_f_0.xc 0.06696f
C182 s2d_block_0.s2d_tails_lo_f_0.sb_A1 s2d_block_0.s2d_tails_hi_f_0.vbp 0.24275f
C183 s2d_block_0.s2d_loads_f_0.lp s2d_block_0.s2d_loads_f_0.vcmfb 2.06525f
C184 s2d_block_0.s2d_casc_p_f_0.vbpc s2d_block_0.s2d_tails_hi_f_0.sa_A2 0.03582f
C185 vdd a_11844_27142# 0.01241f
C186 a_14374_27278# a_14374_27142# 1.23642f
C187 iref s2d_block_0.s2d_tails_hi_f_0.vbp 0.07364f
C188 vdd s2d_block_0.s2d_tails_hi_f_0.sb_M2 0.093f
C189 outp en_3v3_b 0.21472f
C190 vcm s2d_block_0.s2d_tails_hi_f_0.sb_M2 3.34892f
C191 iovdd s2d_block_0.s2d_loads_f_0.vcmfb 46.3232f
C192 s2d_block_0.s2d_tails_hi_f_0.sb_F1 s2d_block_0.s2d_tails_hi_f_0.sa_A2 0.28062f
C193 s2d_block_0.s2d_tails_lo_f_0.sa_F2 s2d_block_0.s2d_casc_n_f_0.y 1.24912f
C194 vdd s2d_block_0.s2d_casc_p_f_0.vbpc 0.37748f
C195 vref s2d_block_0.s2d_tails_lo_f_0.sb_M1 0.07443f
C196 vref pad 0.10654f
C197 s2d_block_0.s2d_tails_hi_f_0.sb_M2 s2d_block_0.s2d_tails_hi_f_0.sa_M1 0.27974f
C198 s2d_block_0.s2d_tails_hi_f_0.sb_F1 vdd 0.98133f
C199 iovdd s2d_block_0.bias_tree_noab_n_c3_0.ni 0.16822f
C200 s2d_block_0.s2d_tails_hi_f_0.sb_F1 vcm 0.02843f
C201 outp s2d_block_0.sinks_6x6_s2d_c3_core_0.vbn 0.03137f
C202 s2d_block_0.s2d_casc_n_f_0.yc s2d_block_0.s2d_tails_lo_f_0.sa_M2 1.79719f
C203 outn s2d_block_0.s2d_casc_n_f_0.x 0.03241f
C204 a_11844_25374# s2d_block_0.sinks_6x6_s2d_c3_core_0.vbn 0.03332f
C205 pad s2d_block_0.s2d_casc_n_f_0.vbnc 12.4429f
C206 a_11844_27414# a_11844_27550# 0.63642f
C207 a_11844_28366# s2d_block_0.s2d_tails_hi_f_0.sa_A2 0.0102f
C208 s2d_block_0.s2d_tails_hi_f_0.sb_M2 s2d_block_0.s2d_tails_hi_f_0.vbp 0.25269f
C209 a_11844_27686# a_11758_26462# 0.01935f
C210 s2d_block_0.s2d_casc_p_f_0.vbpc s2d_block_0.s2d_tails_hi_f_0.sa_M1 0.03197f
C211 s2d_block_0.s2d_tails_hi_f_0.sa_A1 s2d_block_0.s2d_casc_n_f_0.yc 0.04876f
C212 outp s2d_block_0.s2d_casc_n_f_0.xc 0.41632f
C213 iovdd s2d_block_0.s2d_casc_n_f_0.y 11.5898f
C214 a_11844_25374# s2d_block_0.s2d_casc_n_f_0.xc 0.01124f
C215 s2d_block_0.s2d_tails_hi_f_0.sa_A1 s2d_block_0.s2d_tails_lo_f_0.sa_M2 0.05749f
C216 s2d_block_0.s2d_casc_p_f_0.vbpc s2d_block_0.s2d_tails_hi_f_0.vbp 0.03549f
C217 iovdd a_14374_27278# 0.01766f
C218 s2d_block_0.s2d_tails_hi_f_0.sb_F1 s2d_block_0.s2d_tails_hi_f_0.sa_M1 0.01643f
C219 s2d_block_0.s2d_casc_n_f_0.x s2d_block_0.s2d_tails_lo_f_0.sb_A2 1.22267f
C220 s2d_block_0.s2d_tails_lo_f_0.sa_F1 s2d_block_0.s2d_casc_n_f_0.y 1.18782f
C221 s2d_block_0.s2d_tails_hi_f_0.sb_F2 a_11844_27550# 0.0237f
C222 s2d_block_0.s2d_tails_hi_f_0.sb_F2 a_11844_27958# 0.03529f
C223 s2d_block_0.s2d_tails_hi_f_0.sb_F1 s2d_block_0.s2d_tails_hi_f_0.vbp 0.74577f
C224 vref s2d_block_0.s2d_tails_lo_f_0.sb_A1 2.83327f
C225 outp s2d_block_0.s2d_loads_f_0.vcmfb 12.9821f
C226 iovdd a_14374_25782# 0.012f
C227 a_14374_27142# a_11844_28638# 0.02707f
C228 s2d_block_0.s2d_tails_lo_f_0.sa_M2 s2d_block_0.s2d_tails_hi_f_0.sa_A2 0.02981f
C229 s2d_block_0.s2d_tails_lo_f_0.sb_M1 s2d_block_0.sinks_6x6_s2d_c3_core_0.vbn 0.17579f
C230 iref vref 0.02575f
C231 s2d_block_0.s2d_tails_hi_f_0.sb_F2 a_11844_26190# 0.02158f
C232 iref s2d_block_0.s2d_casc_n_f_0.vbnc 0.12949f
C233 s2d_block_0.s2d_tails_hi_f_0.sa_A1 s2d_block_0.s2d_tails_hi_f_0.sa_A2 2.49686f
C234 s2d_block_0.s2d_casc_n_f_0.xc s2d_block_0.s2d_tails_lo_f_0.sb_M1 1.91231f
C235 a_11844_28638# s2d_block_0.s2d_tails_lo_f_0.sa_F2 0.02158f
C236 pad s2d_block_0.s2d_casc_n_f_0.xc 0.03568f
C237 vdd s2d_block_0.s2d_casc_n_f_0.yc 0.02686f
C238 a_11844_28094# s2d_block_0.s2d_tails_lo_f_0.sb_M1 0.06056f
C239 vcm s2d_block_0.s2d_casc_n_f_0.yc 0.28624f
C240 a_11758_26326# s2d_block_0.s2d_tails_lo_f_0.sb_A2 0.04715f
C241 a_11844_26054# s2d_block_0.s2d_tails_hi_f_0.sa_M1 0.09629f
C242 s2d_block_0.s2d_tails_hi_f_0.sb_F2 outn 0.05986f
C243 a_11844_26598# s2d_block_0.s2d_tails_hi_f_0.sa_M1 0.01028f
C244 vcm s2d_block_0.s2d_tails_lo_f_0.sa_M2 0.01518f
C245 a_11844_27686# a_14374_27686# 0.02728f
C246 a_11844_27414# a_14374_27414# 0.02713f
C247 a_11844_27550# a_14374_27550# 0.02719f
C248 a_11844_27278# a_14374_27278# 0.0271f
C249 a_11844_27822# a_14374_27822# 0.02746f
C250 a_14374_27686# a_11844_28094# 0.02728f
C251 a_11844_28230# a_11844_28366# 0.63642f
C252 iref en_3v3_b 1.53723f
C253 s2d_block_0.s2d_tails_hi_f_0.sa_A1 vdd 0.10518f
C254 outp s2d_block_0.s2d_casc_n_f_0.y 0.19269f
C255 a_11844_26190# s2d_block_0.s2d_tails_lo_f_0.sa_F2 0.0105f
C256 s2d_block_0.s2d_tails_hi_f_0.sa_A1 vcm 0.04051f
C257 vref s2d_block_0.s2d_tails_hi_f_0.sb_M2 0.14065f
C258 s2d_block_0.s2d_casc_n_f_0.yc s2d_block_0.s2d_tails_hi_f_0.sa_M1 1.03531f
C259 s2d_block_0.s2d_tails_hi_f_0.sb_F2 s2d_block_0.s2d_tails_lo_f_0.sb_A2 0.66896f
C260 s2d_block_0.s2d_tails_lo_f_0.sa_M2 s2d_block_0.s2d_tails_hi_f_0.sa_M1 0.32682f
C261 s2d_block_0.s2d_tails_lo_f_0.sb_A1 s2d_block_0.sinks_6x6_s2d_c3_core_0.vbn 0.047f
C262 vref s2d_block_0.s2d_casc_p_f_0.vbpc 0.09301f
C263 s2d_block_0.s2d_casc_n_f_0.yc s2d_block_0.s2d_tails_hi_f_0.vbp 0.36143f
C264 outn s2d_block_0.s2d_tails_lo_f_0.sa_F2 2.96064f
C265 a_14374_26190# a_11844_26326# 0.02746f
C266 a_11844_26462# a_11844_26598# 0.63642f
C267 s2d_block_0.s2d_tails_hi_f_0.sa_A1 s2d_block_0.s2d_tails_hi_f_0.sa_M1 0.11601f
C268 s2d_block_0.s2d_tails_lo_f_0.sb_A1 s2d_block_0.s2d_casc_n_f_0.xc 0.15156f
C269 a_11844_28774# s2d_block_0.s2d_tails_lo_f_0.sa_F2 0.02392f
C270 s2d_block_0.s2d_tails_lo_f_0.sa_M2 s2d_block_0.s2d_tails_hi_f_0.vbp 0.25171f
C271 s2d_block_0.s2d_loads_f_0.lp s2d_block_0.s2d_loads_f_0.dd 3.6366f
C272 s2d_block_0.s2d_casc_p_f_0.vbpc s2d_block_0.s2d_casc_n_f_0.vbnc 0.3137f
C273 vdd s2d_block_0.s2d_tails_hi_f_0.sa_A2 0.10246f
C274 vcm s2d_block_0.s2d_tails_hi_f_0.sa_A2 0.02927f
C275 s2d_block_0.s2d_tails_hi_f_0.sb_F1 vref 0.27891f
C276 s2d_block_0.s2d_tails_hi_f_0.sb_F2 a_11844_27006# 0.02221f
C277 s2d_block_0.s2d_tails_hi_f_0.sa_A1 s2d_block_0.s2d_tails_hi_f_0.vbp 0.27068f
C278 iovdd s2d_block_0.s2d_loads_f_0.dd 11.3424f
C279 s2d_block_0.s2d_tails_hi_f_0.sb_F1 s2d_block_0.s2d_casc_n_f_0.vbnc 1.91291f
C280 s2d_block_0.s2d_tails_lo_f_0.sa_F2 s2d_block_0.s2d_tails_lo_f_0.sb_A2 0.14118f
C281 pad s2d_block_0.s2d_casc_n_f_0.y 3.1649f
C282 outn s2d_block_0.s2d_loads_f_0.lp 0.10812f
C283 vdd vcm 1.87232f
C284 en_3v3 iovdd 0.38341f
C285 s2d_block_0.s2d_tails_hi_f_0.sa_M1 s2d_block_0.s2d_tails_hi_f_0.sa_A2 4.59267f
C286 a_14374_27550# a_14374_27414# 0.78325f
C287 s2d_block_0.s2d_tails_hi_f_0.sb_F2 s2d_block_0.s2d_casc_n_f_0.x 1.75142f
C288 a_14374_27278# a_11844_28502# 0.0271f
C289 iovdd outn 16.7646f
C290 s2d_block_0.s2d_tails_hi_f_0.vbp s2d_block_0.s2d_tails_hi_f_0.sa_A2 0.24322f
C291 outn s2d_block_0.s2d_tails_lo_f_0.sa_F1 0.02403f
C292 s2d_block_0.s2d_tails_hi_f_0.sb_M2 s2d_block_0.s2d_casc_n_f_0.xc 1.21481f
C293 a_14374_25918# a_11844_25918# 0.02719f
C294 s2d_block_0.s2d_casc_p_f_0.vbpc s2d_block_0.sinks_6x6_s2d_c3_core_0.vbn 0.90554f
C295 vdd s2d_block_0.s2d_tails_hi_f_0.sa_M1 0.10508f
C296 vcm s2d_block_0.s2d_tails_hi_f_0.sa_M1 0.03993f
C297 iovdd s2d_block_0.s2d_tails_lo_f_0.sb_A2 1.6506f
C298 iref s2d_block_0.bias_tree_noab_n_c3_0.ni 0.20231f
C299 a_14374_26054# a_14374_25918# 0.55763f
C300 vdd s2d_block_0.s2d_tails_hi_f_0.vbp 4.07095f
C301 s2d_block_0.s2d_casc_p_f_0.vbpc s2d_block_0.s2d_casc_n_f_0.xc 0.05739f
C302 iovdd a_14374_27414# 0.012f
C303 vcm s2d_block_0.s2d_tails_hi_f_0.vbp 0.35492f
C304 a_14374_25782# a_11844_26734# 0.02713f
C305 a_11844_26870# a_11844_27006# 0.63642f
C306 s2d_block_0.s2d_tails_hi_f_0.sb_F2 a_11844_25646# 0.0281f
C307 s2d_block_0.s2d_tails_lo_f_0.sa_F1 s2d_block_0.s2d_tails_lo_f_0.sb_A2 0.75594f
C308 s2d_block_0.s2d_tails_lo_f_0.sb_A1 s2d_block_0.s2d_casc_n_f_0.y 0.19341f
C309 s2d_block_0.s2d_casc_n_f_0.x s2d_block_0.s2d_tails_lo_f_0.sa_F2 0.14813f
C310 vdd a_11844_27822# 0.02082f
C311 s2d_block_0.s2d_tails_hi_f_0.sb_F2 a_11844_27414# 0.02303f
C312 vref s2d_block_0.s2d_casc_n_f_0.yc 0.12653f
C313 vref s2d_block_0.s2d_tails_lo_f_0.sa_M2 0.07292f
C314 outp s2d_block_0.s2d_loads_f_0.dd 0.02837f
C315 s2d_block_0.s2d_loads_f_0.vcmfb s2d_block_0.s2d_loads_f_0.ln 1.84165f
C316 s2d_block_0.s2d_casc_n_f_0.yc s2d_block_0.s2d_casc_n_f_0.vbnc 1.57285f
C317 s2d_block_0.s2d_loads_f_0.vcmfb s2d_block_0.s2d_casc_p_f_0.vbpc 2.28139f
C318 a_7760_4632# Clamp_N_M1_0.gate 0.02705f
C319 a_8120_4634# a_7760_4632# 0.05849f
C320 s2d_block_0.s2d_tails_hi_f_0.vbp s2d_block_0.s2d_tails_hi_f_0.sa_M1 0.24813f
C321 s2d_block_0.s2d_tails_hi_f_0.sa_A1 vref 0.56814f
C322 en_3v3 outp 0.08032f
C323 outn outp 7.48996f
C324 iovdd s2d_block_0.s2d_casc_n_f_0.x 8.76917f
C325 a_11758_26462# s2d_block_0.s2d_tails_lo_f_0.sb_A2 0.04736f
C326 a_11844_28502# a_11844_28638# 0.63642f
C327 a_11844_27958# s2d_block_0.s2d_tails_lo_f_0.sb_M1 0.02375f
C328 s2d_block_0.s2d_casc_p_f_0.vbpc s2d_block_0.bias_tree_noab_n_c3_0.ni 0.57492f
C329 a_11844_25782# s2d_block_0.s2d_tails_hi_f_0.sa_A2 0.04197f
C330 a_11844_26462# s2d_block_0.s2d_tails_hi_f_0.sa_M1 0.01272f
C331 s2d_block_0.s2d_tails_lo_f_0.sa_F1 s2d_block_0.s2d_casc_n_f_0.x 0.16251f
C332 vref s2d_block_0.s2d_tails_hi_f_0.sa_A2 0.02925f
C333 outp s2d_block_0.s2d_tails_lo_f_0.sb_A2 0.0209f
C334 a_14374_25646# a_14374_25510# 1.23642f
C335 a_11844_27142# a_11758_27006# 0.01971f
C336 a_11758_26870# a_11758_26734# 0.55763f
C337 s2d_block_0.s2d_tails_hi_f_0.sb_F2 s2d_block_0.s2d_tails_lo_f_0.sa_F2 1.21274f
C338 s2d_block_0.s2d_casc_n_f_0.yc s2d_block_0.sinks_6x6_s2d_c3_core_0.vbn 6.17244f
C339 s2d_block_0.s2d_tails_lo_f_0.sa_M2 s2d_block_0.sinks_6x6_s2d_c3_core_0.vbn 0.05689f
C340 s2d_block_0.s2d_tails_hi_f_0.sb_F2 a_11844_25918# 0.02395f
C341 vref vdd 1.09206f
C342 vref vcm 1.2656f
C343 s2d_block_0.s2d_tails_hi_f_0.sb_F1 s2d_block_0.s2d_casc_n_f_0.y 0.14483f
C344 s2d_block_0.s2d_casc_n_f_0.yc s2d_block_0.s2d_casc_n_f_0.xc 10.4448f
C345 outn s2d_block_0.s2d_tails_lo_f_0.sb_M1 0.03002f
C346 a_14374_26190# a_11844_26190# 0.02746f
C347 s2d_block_0.s2d_tails_hi_f_0.sa_A1 s2d_block_0.sinks_6x6_s2d_c3_core_0.vbn 0.12097f
C348 s2d_block_0.s2d_tails_lo_f_0.sb_A1 a_11844_28638# 0.02257f
C349 s2d_block_0.s2d_tails_lo_f_0.sa_M2 s2d_block_0.s2d_casc_n_f_0.xc 0.81808f
C350 vdd s2d_block_0.s2d_casc_n_f_0.vbnc 2.31537f
C351 pad outn 0.04621f
C352 vcm s2d_block_0.s2d_casc_n_f_0.vbnc 0.01971f
C353 s2d_block_0.s2d_tails_hi_f_0.sb_F2 a_11844_26870# 0.02208f
C354 s2d_block_0.s2d_tails_hi_f_0.sa_A1 s2d_block_0.s2d_casc_n_f_0.xc 0.0776f
C355 iovdd a_7760_4632# 0.04371f
C356 vref s2d_block_0.s2d_tails_hi_f_0.sa_M1 0.02889f
C357 s2d_block_0.s2d_loads_f_0.vcmfb s2d_block_0.s2d_casc_n_f_0.yc 0.23125f
C358 s2d_block_0.s2d_tails_lo_f_0.sb_M1 s2d_block_0.s2d_tails_lo_f_0.sb_A2 3.42454f
C359 vdd en_3v3_b 2.20327f
C360 outp s2d_block_0.s2d_casc_n_f_0.x 0.94634f
C361 vcm en_3v3_b 1.42417f
C362 a_8120_4634# iovdd 0.08872f
C363 iovdd Clamp_N_M1_0.gate 0.31292f
C364 s2d_block_0.s2d_tails_hi_f_0.sb_F2 iovdd 6.03352f
C365 a_11844_28502# s2d_block_0.s2d_tails_lo_f_0.sb_A2 0.02849f
C366 a_11844_25918# s2d_block_0.s2d_tails_lo_f_0.sa_F2 0.11478f
C367 vref s2d_block_0.s2d_tails_hi_f_0.vbp 0.32711f
C368 a_14374_25510# s2d_block_0.sinks_6x6_s2d_c3_core_0.vbn 0.0115f
C369 s2d_block_0.s2d_tails_hi_f_0.sb_F2 s2d_block_0.s2d_tails_lo_f_0.sa_F1 0.56114f
C370 s2d_block_0.s2d_tails_hi_f_0.vbp s2d_block_0.s2d_casc_n_f_0.vbnc 4.06264f
C371 iovdd a_14374_27142# 0.02823f
C372 outn s2d_block_0.s2d_tails_lo_f_0.sb_A1 0.30789f
C373 iref en_3v3 0.23216f
C374 a_11844_27278# a_11844_27414# 0.63642f
C375 a_11844_27550# a_11758_26598# 0.01938f
C376 a_11758_26462# a_11758_26326# 1.23642f
C377 vdd s2d_block_0.sinks_6x6_s2d_c3_core_0.vbn 1.9456f
C378 a_11844_27958# s2d_block_0.s2d_tails_hi_f_0.sb_M2 0.01935f
C379 en_3v3_b s2d_block_0.s2d_tails_hi_f_0.vbp 1.1167f
C380 iovdd s2d_block_0.s2d_tails_lo_f_0.sa_F2 3.0746f
C381 s2d_block_0.s2d_casc_n_f_0.yc s2d_block_0.s2d_casc_n_f_0.y 0.33719f
C382 vdd s2d_block_0.s2d_casc_n_f_0.xc 0.0268f
C383 vcm s2d_block_0.s2d_casc_n_f_0.xc 1.30615f
C384 s2d_block_0.s2d_tails_lo_f_0.sb_A1 s2d_block_0.s2d_tails_lo_f_0.sb_A2 2.4348f
C385 s2d_block_0.s2d_tails_lo_f_0.sa_F1 s2d_block_0.s2d_tails_lo_f_0.sa_F2 0.55194f
C386 vdd a_11844_27686# 0.0197f
C387 s2d_block_0.s2d_tails_hi_f_0.sb_F2 a_11844_27278# 0.02263f
C388 pad s2d_block_0.s2d_casc_n_f_0.x 0.10623f
C389 s2d_block_0.s2d_tails_hi_f_0.sa_A1 s2d_block_0.s2d_casc_n_f_0.y 1.23587f
C390 s2d_block_0.s2d_loads_f_0.dd s2d_block_0.s2d_loads_f_0.ln 12.8616f
C391 a_11844_25510# a_11844_25646# 0.63642f
C392 s2d_block_0.s2d_loads_f_0.dd s2d_block_0.s2d_casc_p_f_0.vbpc 1.63073f
C393 iovdd s2d_block_0.s2d_loads_f_0.lp 9.48528f
C394 s2d_block_0.s2d_tails_hi_f_0.vbp s2d_block_0.sinks_6x6_s2d_c3_core_0.vbn 1.69032f
C395 s2d_block_0.s2d_casc_n_f_0.xc s2d_block_0.s2d_tails_hi_f_0.sa_M1 0.19353f
C396 s2d_block_0.s2d_tails_hi_f_0.sb_F2 outp 0.07024f
C397 s2d_block_0.s2d_tails_hi_f_0.sb_F2 a_11844_25374# 0.03166f
C398 outn s2d_block_0.s2d_tails_hi_f_0.sb_M2 0.62434f
C399 en_3v3 s2d_block_0.s2d_casc_p_f_0.vbpc 0.11347f
C400 s2d_block_0.s2d_casc_n_f_0.xc s2d_block_0.s2d_tails_hi_f_0.vbp 0.03022f
C401 outn s2d_block_0.s2d_loads_f_0.ln 0.36494f
C402 s2d_block_0.s2d_casc_n_f_0.y s2d_block_0.s2d_tails_hi_f_0.sa_A2 1.08118f
C403 iovdd s2d_block_0.s2d_tails_lo_f_0.sa_F1 3.78604f
C404 outn s2d_block_0.s2d_casc_p_f_0.vbpc 2.00001f
C405 a_11758_26598# s2d_block_0.s2d_tails_lo_f_0.sb_A2 0.04764f
C406 vdd s2d_block_0.bias_tree_noab_n_c3_0.ni 1.76501f
C407 a_11844_26326# s2d_block_0.s2d_tails_hi_f_0.sa_M1 0.01913f
C408 s2d_block_0.s2d_tails_hi_f_0.sb_F1 en_3v3 0.20957f
C409 a_11844_27686# a_11844_27822# 0.63642f
C410 a_14374_27822# a_11844_27958# 0.02746f
C411 s2d_block_0.s2d_tails_hi_f_0.sb_F2 a_11844_25510# 0.02922f
C412 s2d_block_0.s2d_tails_hi_f_0.sb_M2 s2d_block_0.s2d_tails_lo_f_0.sb_A2 0.05301f
C413 s2d_block_0.s2d_tails_lo_f_0.sb_A1 s2d_block_0.s2d_casc_n_f_0.x 1.08004f
C414 vref s2d_block_0.s2d_casc_n_f_0.vbnc 0.03195f
C415 a_11844_28094# a_11844_28230# 0.63642f
C416 s2d_block_0.s2d_tails_hi_f_0.sb_F1 outn 1.22022f
C417 outp s2d_block_0.s2d_tails_lo_f_0.sa_F2 0.20113f
C418 s2d_block_0.s2d_casc_p_f_0.vbpc s2d_block_0.s2d_tails_lo_f_0.sb_A2 0.02874f
C419 vdd s2d_block_0.s2d_casc_n_f_0.y 0.04859f
C420 a_11844_27142# a_11844_27006# 0.63642f
C421 vcm s2d_block_0.s2d_casc_n_f_0.y 0.63544f
C422 s2d_block_0.s2d_tails_hi_f_0.sb_F2 s2d_block_0.s2d_tails_lo_f_0.sb_M1 1.45977f
C423 vref en_3v3_b 3.42268f
C424 pad Clamp_N_M1_0.gate 7.47115f
C425 s2d_block_0.s2d_tails_hi_f_0.sb_F2 pad 0.16346f
C426 s2d_block_0.s2d_tails_hi_f_0.sb_F2 a_11844_28502# 0.01671f
C427 s2d_block_0.s2d_tails_hi_f_0.sb_F1 s2d_block_0.s2d_tails_lo_f_0.sb_A2 0.34054f
C428 a_11844_26054# a_11844_26190# 0.63642f
C429 en_3v3_b s2d_block_0.s2d_casc_n_f_0.vbnc 0.02878f
C430 a_11844_26326# a_11844_26462# 0.63642f
C431 s2d_block_0.bias_tree_noab_n_c3_0.ni s2d_block_0.s2d_tails_hi_f_0.vbp 0.46375f
C432 s2d_block_0.s2d_loads_f_0.lp outp 0.34238f
C433 s2d_block_0.s2d_tails_hi_f_0.sb_F2 a_11844_26734# 0.02199f
C434 a_11758_26326# s2d_block_0.s2d_tails_lo_f_0.sb_A1 0.05685f
C435 iovdd outp 14.7872f
C436 s2d_block_0.s2d_loads_f_0.dd s2d_block_0.s2d_casc_n_f_0.yc 0.20626f
C437 s2d_block_0.s2d_tails_lo_f_0.sb_M1 s2d_block_0.s2d_tails_lo_f_0.sa_F2 0.02026f
C438 s2d_block_0.s2d_tails_hi_f_0.vbp s2d_block_0.s2d_casc_n_f_0.y 0.16277f
C439 outp s2d_block_0.s2d_tails_lo_f_0.sa_F1 0.02376f
C440 pad s2d_block_0.s2d_tails_lo_f_0.sa_F2 0.27985f
C441 a_11844_26190# s2d_block_0.s2d_tails_lo_f_0.sa_M2 0.01935f
C442 a_11844_28502# s2d_block_0.s2d_tails_lo_f_0.sa_F2 0.02158f
C443 a_11844_28366# s2d_block_0.s2d_tails_lo_f_0.sb_A2 0.01228f
C444 s2d_block_0.sinks_6x6_s2d_c3_core_0.vbn s2d_block_0.s2d_casc_n_f_0.vbnc 0.04762f
C445 vref s2d_block_0.s2d_casc_n_f_0.xc 0.2609f
C446 a_14374_27686# a_14374_27550# 0.55763f
C447 s2d_block_0.s2d_tails_hi_f_0.sb_F2 s2d_block_0.s2d_tails_lo_f_0.sb_A1 0.07061f
C448 a_14374_27414# a_11844_28366# 0.02713f
C449 a_11844_28638# s2d_block_0.s2d_tails_hi_f_0.sa_A2 0.01297f
C450 s2d_block_0.s2d_casc_n_f_0.xc s2d_block_0.s2d_casc_n_f_0.vbnc 2.58001f
C451 outn s2d_block_0.s2d_casc_n_f_0.yc 1.60368f
C452 s2d_block_0.s2d_tails_hi_f_0.sb_F1 s2d_block_0.s2d_casc_n_f_0.x 1.19998f
C453 outn s2d_block_0.s2d_tails_lo_f_0.sa_M2 3.25078f
C454 s2d_block_0.s2d_tails_hi_f_0.sa_A1 outn 0.03031f
C455 a_11758_26326# s2d_block_0.s2d_tails_hi_f_0.sb_M2 0.26248f
C456 iovdd s2d_block_0.s2d_tails_lo_f_0.sb_M1 1.20235f
C457 s2d_block_0.s2d_casc_n_f_0.yc s2d_block_0.s2d_tails_lo_f_0.sb_A2 0.04795f
C458 a_14374_26190# a_14374_26054# 0.33426f
C459 s2d_block_0.s2d_loads_f_0.vcmfb s2d_block_0.s2d_casc_n_f_0.vbnc 2.71351f
C460 pad iovdd 39.7827f
C461 a_14374_25918# a_11844_26598# 0.02719f
C462 a_11844_26734# a_11844_26870# 0.63642f
C463 s2d_block_0.s2d_tails_lo_f_0.sa_M2 s2d_block_0.s2d_tails_lo_f_0.sb_A2 0.18932f
C464 s2d_block_0.s2d_tails_lo_f_0.sa_F1 s2d_block_0.s2d_tails_lo_f_0.sb_M1 1.00895f
C465 s2d_block_0.s2d_tails_lo_f_0.sb_A1 s2d_block_0.s2d_tails_lo_f_0.sa_F2 0.25648f
C466 vdd a_11844_27550# 0.01806f
C467 s2d_block_0.s2d_tails_hi_f_0.sb_F2 a_11844_27142# 0.02238f
C468 s2d_block_0.s2d_tails_hi_f_0.sa_A1 s2d_block_0.s2d_tails_lo_f_0.sb_A2 0.02919f
C469 s2d_block_0.s2d_tails_hi_f_0.sb_F2 s2d_block_0.s2d_tails_hi_f_0.sb_M2 0.03186f
C470 outn s2d_block_0.s2d_tails_hi_f_0.sa_A2 0.01529f
C471 a_11844_28774# s2d_block_0.s2d_tails_hi_f_0.sa_A2 0.0152f
C472 s2d_block_0.s2d_casc_n_f_0.xc s2d_block_0.sinks_6x6_s2d_c3_core_0.vbn 7.63066f
C473 s2d_block_0.bias_tree_noab_n_c3_0.ni s2d_block_0.s2d_casc_n_f_0.vbnc 0.01097f
C474 a_11844_27142# a_14374_27142# 0.02707f
C475 s2d_block_0.s2d_tails_hi_f_0.sb_F2 s2d_block_0.s2d_casc_p_f_0.vbpc 0.02121f
C476 vref s2d_block_0.s2d_casc_n_f_0.y 0.05183f
C477 en_3v3 vdd 1.61139f
C478 en_3v3 vcm 0.12306f
C479 s2d_block_0.s2d_tails_lo_f_0.sb_A2 s2d_block_0.s2d_tails_hi_f_0.sa_A2 0.1185f
C480 a_11844_25374# a_11844_25510# 0.63642f
C481 en_3v3_b s2d_block_0.bias_tree_noab_n_c3_0.ni 0.29362f
C482 s2d_block_0.s2d_casc_n_f_0.y s2d_block_0.s2d_casc_n_f_0.vbnc 1.97858f
C483 iovdd s2d_block_0.s2d_tails_lo_f_0.sb_A1 1.16397f
C484 a_11758_26734# s2d_block_0.s2d_tails_lo_f_0.sb_A2 0.04787f
C485 s2d_block_0.s2d_tails_hi_f_0.sb_F2 s2d_block_0.s2d_tails_hi_f_0.sb_F1 0.56257f
C486 vdd outn 4.432f
C487 vcm outn 9.45068f
C488 s2d_block_0.s2d_loads_f_0.vcmfb s2d_block_0.sinks_6x6_s2d_c3_core_0.vbn 0.04213f
C489 s2d_block_0.s2d_casc_n_f_0.yc s2d_block_0.s2d_casc_n_f_0.x 5.29006f
C490 a_11844_26190# s2d_block_0.s2d_tails_hi_f_0.sa_M1 0.03964f
C491 a_14374_25782# a_11844_25782# 0.02713f
C492 a_11844_27822# a_11844_27958# 0.63642f
C493 s2d_block_0.s2d_tails_lo_f_0.sb_A1 s2d_block_0.s2d_tails_lo_f_0.sa_F1 0.25712f
C494 s2d_block_0.s2d_tails_hi_f_0.sb_M2 s2d_block_0.s2d_tails_lo_f_0.sa_F2 0.2626f
C495 iref iovdd 0.38696f
C496 outp s2d_block_0.s2d_tails_lo_f_0.sb_M1 0.02431f
C497 s2d_block_0.s2d_loads_f_0.vcmfb s2d_block_0.s2d_casc_n_f_0.xc 0.32881f
C498 a_11844_25374# s2d_block_0.s2d_tails_lo_f_0.sb_M1 0.01618f
C499 s2d_block_0.s2d_tails_hi_f_0.sa_A1 s2d_block_0.s2d_casc_n_f_0.x 0.33233f
C500 s2d_block_0.s2d_casc_p_f_0.vbpc s2d_block_0.s2d_tails_lo_f_0.sa_F2 0.03272f
C501 pad outp 5.74492f
C502 a_14374_25782# a_14374_25646# 1.00966f
C503 a_14374_25510# a_11844_27006# 0.02707f
C504 a_11758_27006# a_11758_26870# 0.33426f
C505 outn s2d_block_0.s2d_tails_hi_f_0.sa_M1 0.01551f
C506 en_3v3 s2d_block_0.s2d_tails_hi_f_0.vbp 0.03309f
C507 s2d_block_0.s2d_tails_hi_f_0.sb_F2 a_11844_28366# 0.04247f
C508 s2d_block_0.s2d_tails_hi_f_0.sb_F1 s2d_block_0.s2d_tails_lo_f_0.sa_F2 0.06213f
C509 outn s2d_block_0.s2d_tails_hi_f_0.vbp 0.1235f
C510 a_11844_25510# s2d_block_0.s2d_tails_lo_f_0.sb_M1 0.01476f
C511 s2d_block_0.s2d_loads_f_0.lp s2d_block_0.s2d_loads_f_0.ln 6.36668f
C512 s2d_block_0.s2d_tails_hi_f_0.sb_F2 a_11844_26054# 0.02158f
C513 vdd a_11844_27006# 0.01077f
C514 s2d_block_0.s2d_casc_n_f_0.y s2d_block_0.sinks_6x6_s2d_c3_core_0.vbn 10.5813f
C515 s2d_block_0.s2d_tails_lo_f_0.sb_A2 s2d_block_0.s2d_tails_hi_f_0.sa_M1 0.04471f
C516 s2d_block_0.s2d_casc_n_f_0.x s2d_block_0.s2d_tails_hi_f_0.sa_A2 0.19257f
C517 s2d_block_0.s2d_tails_hi_f_0.sb_F2 a_11844_26598# 0.02183f
C518 iovdd s2d_block_0.s2d_tails_hi_f_0.sb_M2 1.00738f
C519 s2d_block_0.s2d_loads_f_0.lp s2d_block_0.s2d_casc_p_f_0.vbpc 1.82865f
C520 a_11758_26326# s2d_block_0.s2d_tails_lo_f_0.sa_M2 0.26248f
C521 a_11758_26462# s2d_block_0.s2d_tails_lo_f_0.sb_A1 0.02995f
C522 iovdd s2d_block_0.s2d_loads_f_0.ln 9.07021f
C523 s2d_block_0.s2d_tails_hi_f_0.vbp s2d_block_0.s2d_tails_lo_f_0.sb_A2 0.25264f
C524 s2d_block_0.s2d_casc_n_f_0.xc s2d_block_0.s2d_casc_n_f_0.y 5.73376f
C525 iovdd s2d_block_0.s2d_casc_p_f_0.vbpc 35.3307f
C526 outp s2d_block_0.s2d_tails_lo_f_0.sb_A1 0.03836f
C527 a_11844_28366# s2d_block_0.s2d_tails_lo_f_0.sa_F2 0.02158f
C528 s2d_block_0.s2d_tails_hi_f_0.sb_F2 s2d_block_0.s2d_casc_n_f_0.yc 0.03658f
C529 s2d_block_0.s2d_casc_p_f_0.vbpc s2d_block_0.s2d_tails_lo_f_0.sa_F1 0.0612f
C530 vdd s2d_block_0.s2d_casc_n_f_0.x 0.04841f
C531 vcm s2d_block_0.s2d_casc_n_f_0.x 0.63396f
C532 s2d_block_0.s2d_tails_hi_f_0.sb_F2 s2d_block_0.s2d_tails_lo_f_0.sa_M2 0.03901f
C533 s2d_block_0.s2d_tails_hi_f_0.sb_F1 iovdd 4.46003f
C534 s2d_block_0.s2d_loads_f_0.vcmfb s2d_block_0.s2d_casc_n_f_0.y 0.15223f
C535 a_11844_25646# s2d_block_0.s2d_tails_hi_f_0.sa_A2 0.08226f
C536 a_11844_26054# s2d_block_0.s2d_tails_lo_f_0.sa_F2 0.02708f
C537 s2d_block_0.s2d_tails_hi_f_0.sb_F2 s2d_block_0.s2d_tails_hi_f_0.sa_A1 0.38523f
C538 a_11844_27142# a_11844_27278# 0.63642f
C539 iref iovss 2.84041f
C540 vdd iovss 0.20787p
C541 s2d_block_0.s2d_loads_f_0.dd iovss 3.53484f
C542 s2d_block_0.s2d_loads_f_0.ln iovss 9.8759f
C543 s2d_block_0.s2d_loads_f_0.lp iovss 6.0795f
C544 a_14374_26190# iovss 1.16634f
C545 a_14374_26054# iovss 1.29284f
C546 a_14374_25918# iovss 1.3963f
C547 a_14374_25782# iovss 1.46396f
C548 a_14374_25646# iovss 1.47901f
C549 a_14374_25510# iovss 2.6658f
C550 a_11758_27006# iovss 1.03059f
C551 a_11758_26870# iovss 1.10629f
C552 a_11758_26734# iovss 1.2129f
C553 a_11758_26598# iovss 1.31805f
C554 a_11758_26462# iovss 1.38557f
C555 a_11758_26326# iovss 2.40813f
C556 a_14374_27822# iovss 1.06642f
C557 a_14374_27686# iovss 1.18602f
C558 a_14374_27550# iovss 1.26657f
C559 a_14374_27414# iovss 1.34955f
C560 a_14374_27278# iovss 1.42769f
C561 a_14374_27142# iovss 2.67705f
C562 s2d_block_0.s2d_casc_n_f_0.xc iovss 81.2536f
C563 s2d_block_0.s2d_casc_n_f_0.yc iovss 49.17923f
C564 s2d_block_0.s2d_casc_n_f_0.x iovss 31.30896f
C565 s2d_block_0.s2d_casc_n_f_0.y iovss 32.69825f
C566 s2d_block_0.s2d_tails_lo_f_0.sa_M2 iovss 2.80762f
C567 s2d_block_0.s2d_tails_lo_f_0.sb_M1 iovss 2.97971f
C568 s2d_block_0.s2d_tails_lo_f_0.sb_A1 iovss 4.09079f
C569 s2d_block_0.s2d_tails_lo_f_0.sa_F2 iovss 21.07319f
C570 s2d_block_0.s2d_tails_lo_f_0.sa_F1 iovss 5.91279f
C571 s2d_block_0.s2d_tails_lo_f_0.sb_A2 iovss 9.01883f
C572 s2d_block_0.s2d_tails_hi_f_0.sb_M2 iovss 4.64485f
C573 s2d_block_0.s2d_tails_hi_f_0.sa_M1 iovss 6.04415f
C574 s2d_block_0.s2d_tails_hi_f_0.sa_A2 iovss 4.73024f
C575 s2d_block_0.s2d_tails_hi_f_0.sb_F1 iovss 19.61646f
C576 s2d_block_0.s2d_tails_hi_f_0.sb_F2 iovss 8.49076f
C577 s2d_block_0.s2d_tails_hi_f_0.sa_A1 iovss 7.11202f
Rtie0 a_11844_25374# iovss 1e12
Rtie1 a_11844_25510# iovss 1e12
Rtie2 a_11844_25646# iovss 1e12
Rtie3 a_11844_25782# iovss 1e12
Rtie4 a_11844_25918# iovss 1e12
Rtie5 a_11844_26054# iovss 1e12
Rtie6 a_11844_26190# iovss 1e12
Rtie7 a_11844_26326# iovss 1e12
Rtie8 a_11844_26462# iovss 1e12
Rtie9 a_11844_26598# iovss 1e12
Rtie10 a_11844_26734# iovss 1e12
Rtie11 a_11844_26870# iovss 1e12
Rtie12 a_11844_27006# iovss 1e12
Rtie13 a_11844_27142# iovss 1e12
Rtie14 a_11844_27278# iovss 1e12
Rtie15 a_11844_27414# iovss 1e12
Rtie16 a_11844_27550# iovss 1e12
Rtie17 a_11844_27686# iovss 1e12
Rtie18 a_11844_27822# iovss 1e12
Rtie19 a_11844_27958# iovss 1e12
Rtie20 a_11844_28094# iovss 1e12
Rtie21 a_11844_28230# iovss 1e12
Rtie22 a_11844_28366# iovss 1e12
Rtie23 a_11844_28502# iovss 1e12
Rtie24 a_11844_28638# iovss 1e12
Rtie25 a_11844_28774# iovss 1e12
Rtie26 a_7760_4632# iovss 1e12
Rtie27 a_8120_4634# iovss 1e12
.ends
