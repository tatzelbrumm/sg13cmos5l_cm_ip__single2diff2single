* SPDX-FileCopyrightText: 2026 Christoph Maier
* SPDX-License-Identifier: Apache-2.0
* pad_candidate.cdl: reference netlist of pad_candidate.gds (F, C3 stage B, compose_cdl.py)

.SUBCKT sinks_6x6_s2d_c3_core vbn vss x y
Mdummy_0 vss vbn vss vss sg13_hv_nmos w=2u l=6u ng=1 m=1
MSX_1 x vbn vss vss sg13_hv_nmos w=6u l=6u ng=1 m=1
MSY_2 y vbn vss vss sg13_hv_nmos w=6u l=6u ng=1 m=1
MSY_3 y vbn vss vss sg13_hv_nmos w=6u l=6u ng=1 m=1
MBN_4 vbn vbn vss vss sg13_hv_nmos w=6u l=6u ng=1 m=1
MSX_5 x vbn vss vss sg13_hv_nmos w=6u l=6u ng=1 m=1
MSX_6 x vbn vss vss sg13_hv_nmos w=6u l=6u ng=1 m=1
MSY_7 y vbn vss vss sg13_hv_nmos w=6u l=6u ng=1 m=1
Mdummy_8 vss vbn vss vss sg13_hv_nmos w=2u l=6u ng=1 m=1
Mdummy_9 vss vbn vss vss sg13_hv_nmos w=2u l=6u ng=1 m=1
MSY_10 y vbn vss vss sg13_hv_nmos w=6u l=6u ng=1 m=1
MSX_11 x vbn vss vss sg13_hv_nmos w=6u l=6u ng=1 m=1
MSX_12 x vbn vss vss sg13_hv_nmos w=6u l=6u ng=1 m=1
MBNtwin_13 vss vbn vss vss sg13_hv_nmos w=6u l=6u ng=1 m=1
MSY_14 y vbn vss vss sg13_hv_nmos w=6u l=6u ng=1 m=1
MSY_15 y vbn vss vss sg13_hv_nmos w=6u l=6u ng=1 m=1
MSX_16 x vbn vss vss sg13_hv_nmos w=6u l=6u ng=1 m=1
Mdummy_17 vss vbn vss vss sg13_hv_nmos w=2u l=6u ng=1 m=1
.ENDS sinks_6x6_s2d_c3_core

.SUBCKT s2d_casc_n_f vbnc vcmfb vdd voutn voutp vss x xc y yc
Mdummy_0 vss vbnc vss vss sg13_hv_nmos w=2u l=3u ng=1 m=1
MCXC_1 vcmfb vbnc xc vss sg13_hv_nmos w=15u l=3u ng=1 m=1
MCX_2 voutp vbnc x vss sg13_hv_nmos w=15u l=3u ng=1 m=1
MCY_3 voutn vbnc y vss sg13_hv_nmos w=15u l=3u ng=1 m=1
MCYC_4 vdd vbnc yc vss sg13_hv_nmos w=15u l=3u ng=1 m=1
Mdummy_5 vss vbnc vss vss sg13_hv_nmos w=2u l=3u ng=1 m=1
Mdummy_6 vss vbnc vss vss sg13_hv_nmos w=2u l=3u ng=1 m=1
MCYC_7 vdd vbnc yc vss sg13_hv_nmos w=15u l=3u ng=1 m=1
MCY_8 voutn vbnc y vss sg13_hv_nmos w=15u l=3u ng=1 m=1
MCX_9 voutp vbnc x vss sg13_hv_nmos w=15u l=3u ng=1 m=1
MCXC_10 vcmfb vbnc xc vss sg13_hv_nmos w=15u l=3u ng=1 m=1
Mdummy_11 vss vbnc vss vss sg13_hv_nmos w=2u l=3u ng=1 m=1
MBNC_12 vbnc vbnc vss vss sg13_hv_nmos w=1u l=8u ng=1 m=1
.ENDS s2d_casc_n_f

.SUBCKT s2d_casc_p_f dd ln lp vbpc vcmfb vdd voutn voutp
MXl0 vdd vbpc vdd vdd sg13_hv_pmos w=1u l=4u ng=1 m=1
MLPCl voutp vbpc lp vdd sg13_hv_pmos w=15u l=3u ng=1 m=1
MLNCl voutn vbpc ln vdd sg13_hv_pmos w=15u l=3u ng=1 m=1
MDCl vcmfb vbpc dd vdd sg13_hv_pmos w=15u l=3u ng=1 m=1
MXl4 vdd vbpc vdd vdd sg13_hv_pmos w=1u l=4u ng=1 m=1
MBPC vbpc vbpc vdd vdd sg13_hv_pmos w=1u l=4u ng=1 m=1
MLPCu voutp vbpc lp vdd sg13_hv_pmos w=15u l=3u ng=1 m=1
MLNCu voutn vbpc ln vdd sg13_hv_pmos w=15u l=3u ng=1 m=1
MDCu vcmfb vbpc dd vdd sg13_hv_pmos w=15u l=3u ng=1 m=1
MXu4 vdd vbpc vdd vdd sg13_hv_pmos w=1u l=4u ng=1 m=1
.ENDS s2d_casc_p_f

.SUBCKT s2d_loads_f dd ln lp vcmfb vdd
MXl0 vdd vcmfb vdd vdd sg13_hv_pmos w=1u l=4u ng=1 m=1
MLP1l lp vcmfb vdd vdd sg13_hv_pmos w=6u l=4u ng=1 m=1
MLN2l ln vcmfb vdd vdd sg13_hv_pmos w=6u l=4u ng=1 m=1
MDD3l dd vcmfb vdd vdd sg13_hv_pmos w=6u l=4u ng=1 m=1
MDD4l dd vcmfb vdd vdd sg13_hv_pmos w=6u l=4u ng=1 m=1
MLN5l ln vcmfb vdd vdd sg13_hv_pmos w=6u l=4u ng=1 m=1
MLP6l lp vcmfb vdd vdd sg13_hv_pmos w=6u l=4u ng=1 m=1
MXl7 vdd vcmfb vdd vdd sg13_hv_pmos w=1u l=4u ng=1 m=1
MXu0 vdd vcmfb vdd vdd sg13_hv_pmos w=1u l=4u ng=1 m=1
MLP1u lp vcmfb vdd vdd sg13_hv_pmos w=6u l=4u ng=1 m=1
MLN2u ln vcmfb vdd vdd sg13_hv_pmos w=6u l=4u ng=1 m=1
MDD3u dd vcmfb vdd vdd sg13_hv_pmos w=6u l=4u ng=1 m=1
MDD4u dd vcmfb vdd vdd sg13_hv_pmos w=6u l=4u ng=1 m=1
MLN5u ln vcmfb vdd vdd sg13_hv_pmos w=6u l=4u ng=1 m=1
MLP6u lp vcmfb vdd vdd sg13_hv_pmos w=6u l=4u ng=1 m=1
MXu7 vdd vcmfb vdd vdd sg13_hv_pmos w=1u l=4u ng=1 m=1
.ENDS s2d_loads_f

.SUBCKT s2d_tails_lo_f sa_F1 sa_F2 sa_M2 sb_A1 sb_A2 sb_M1 vbp vdd
MD0 vdd vbp vdd vdd sg13_hv_pmos w=5u l=6u ng=1 m=1
MTA2b sb_A2 vbp vdd vdd sg13_hv_pmos w=5u l=6u ng=1 m=1
MTF1a sa_F1 vbp vdd vdd sg13_hv_pmos w=5u l=6u ng=1 m=1
MTF2a sa_F2 vbp vdd vdd sg13_hv_pmos w=5u l=6u ng=1 m=1
MTA1b sb_A1 vbp vdd vdd sg13_hv_pmos w=5u l=6u ng=1 m=1
MTM1b sb_M1 vbp vdd vdd sg13_hv_pmos w=5u l=6u ng=1 m=1
MTM2a sa_M2 vbp vdd vdd sg13_hv_pmos w=5u l=6u ng=1 m=1
MD7 vdd vbp vdd vdd sg13_hv_pmos w=5u l=6u ng=1 m=1
.ENDS s2d_tails_lo_f

.SUBCKT tub_p20x1_c3 d g s
M0 d g s s sg13_hv_pmos w=20u l=1u ng=2 m=1
.ENDS tub_p20x1_c3

.SUBCKT s2d_inputs_c3 sa_A1 sa_A2 sa_F1 sa_F2 sa_M1 sa_M2 sb_A1 sb_A2 sb_F1 sb_F2 sb_M1 sb_M2 vcm vdd vfbn vfbp vin vref x xc y yc
XDlo0 vdd vdd vdd tub_p20x1_c3
XA2b x vcm sb_A2 tub_p20x1_c3
XF1a y vcm sa_F1 tub_p20x1_c3
XF2a y vfbn sa_F2 tub_p20x1_c3
XA1b x vref sb_A1 tub_p20x1_c3
XM1b xc vcm sb_M1 tub_p20x1_c3
XM2a yc vfbn sa_M2 tub_p20x1_c3
XDlo7 vdd vdd vdd tub_p20x1_c3
XDup0 vdd vdd vdd tub_p20x1_c3
XA1a y vin sa_A1 tub_p20x1_c3
XF2b x vcm sb_F2 tub_p20x1_c3
XF1b x vfbp sb_F1 tub_p20x1_c3
XA2a y vin sa_A2 tub_p20x1_c3
XM1a yc vfbp sa_M1 tub_p20x1_c3
XM2b xc vcm sb_M2 tub_p20x1_c3
XDup7 vdd vdd vdd tub_p20x1_c3
.ENDS s2d_inputs_c3

.SUBCKT s2d_tails_hi_f sa_A1 sa_A2 sa_M1 sb_F1 sb_F2 sb_M2 vbp vdd
MBP vbp vbp vdd vdd sg13_hv_pmos w=5u l=6u ng=1 m=1
MTA1a sa_A1 vbp vdd vdd sg13_hv_pmos w=5u l=6u ng=1 m=1
MTF2b sb_F2 vbp vdd vdd sg13_hv_pmos w=5u l=6u ng=1 m=1
MTF1b sb_F1 vbp vdd vdd sg13_hv_pmos w=5u l=6u ng=1 m=1
MTA2a sa_A2 vbp vdd vdd sg13_hv_pmos w=5u l=6u ng=1 m=1
MTM1a sa_M1 vbp vdd vdd sg13_hv_pmos w=5u l=6u ng=1 m=1
MTM2b sb_M2 vbp vdd vdd sg13_hv_pmos w=5u l=6u ng=1 m=1
MD7 vdd vbp vdd vdd sg13_hv_pmos w=5u l=6u ng=1 m=1
.ENDS s2d_tails_hi_f

.SUBCKT s2d_rhigh_c3 sa_A1 sa_A2 sa_F1 sa_F2 sa_M1 sa_M2 sb_A1 sb_A2 sb_F1 sb_F2 sb_M1 sb_M2 vss
RA1_0 sa_A1 A1_1 vss rhigh w=0.5u l=12.65u m=1 b=0
RA1_1 A1_1 A1_2 vss rhigh w=0.5u l=12.65u m=1 b=0
RA1_2 A1_2 A1_3 vss rhigh w=0.5u l=12.65u m=1 b=0
RA1_3 A1_3 sb_A1 vss rhigh w=0.5u l=12.65u m=1 b=0
RA2_0 sa_A2 A2_1 vss rhigh w=0.5u l=12.65u m=1 b=0
RA2_1 A2_1 A2_2 vss rhigh w=0.5u l=12.65u m=1 b=0
RA2_2 A2_2 A2_3 vss rhigh w=0.5u l=12.65u m=1 b=0
RA2_3 A2_3 sb_A2 vss rhigh w=0.5u l=12.65u m=1 b=0
RF1_0 sa_F1 F1_1 vss rhigh w=0.5u l=12.65u m=1 b=0
RF1_1 F1_1 F1_2 vss rhigh w=0.5u l=12.65u m=1 b=0
RF1_2 F1_2 F1_3 vss rhigh w=0.5u l=12.65u m=1 b=0
RF1_3 F1_3 sb_F1 vss rhigh w=0.5u l=12.65u m=1 b=0
RF2_0 sa_F2 F2_1 vss rhigh w=0.5u l=12.65u m=1 b=0
RF2_1 F2_1 F2_2 vss rhigh w=0.5u l=12.65u m=1 b=0
RF2_2 F2_2 F2_3 vss rhigh w=0.5u l=12.65u m=1 b=0
RF2_3 F2_3 sb_F2 vss rhigh w=0.5u l=12.65u m=1 b=0
RM1_0 sa_M1 M1_1 vss rhigh w=0.5u l=12.65u m=1 b=0
RM1_1 M1_1 M1_2 vss rhigh w=0.5u l=12.65u m=1 b=0
RM1_2 M1_2 M1_3 vss rhigh w=0.5u l=12.65u m=1 b=0
RM1_3 M1_3 sb_M1 vss rhigh w=0.5u l=12.65u m=1 b=0
RM2_0 sa_M2 M2_1 vss rhigh w=0.5u l=12.65u m=1 b=0
RM2_1 M2_1 M2_2 vss rhigh w=0.5u l=12.65u m=1 b=0
RM2_2 M2_2 M2_3 vss rhigh w=0.5u l=12.65u m=1 b=0
RM2_3 M2_3 sb_M2 vss rhigh w=0.5u l=12.65u m=1 b=0
Rdummy_0 vss vss vss rhigh w=0.5u l=12.65u m=1 b=0
Rdummy_1 vss vss vss rhigh w=0.5u l=12.65u m=1 b=0
.ENDS s2d_rhigh_c3

.SUBCKT s2d_sinks_cmfb_c3_core vbn vss xc yc
Mdummy_0 vss vbn vss vss sg13_hv_nmos w=2u l=6u ng=1 m=1
MSXC_1 xc vbn vss vss sg13_hv_nmos w=6u l=6u ng=1 m=1
MSYC_2 yc vbn vss vss sg13_hv_nmos w=6u l=6u ng=1 m=1
MSYC_3 yc vbn vss vss sg13_hv_nmos w=6u l=6u ng=1 m=1
MSXC_4 xc vbn vss vss sg13_hv_nmos w=6u l=6u ng=1 m=1
Mdummy_5 vss vbn vss vss sg13_hv_nmos w=2u l=6u ng=1 m=1
Mdummy_6 vss vbn vss vss sg13_hv_nmos w=2u l=6u ng=1 m=1
MSYC_7 yc vbn vss vss sg13_hv_nmos w=6u l=6u ng=1 m=1
MSXC_8 xc vbn vss vss sg13_hv_nmos w=6u l=6u ng=1 m=1
MSXC_9 xc vbn vss vss sg13_hv_nmos w=6u l=6u ng=1 m=1
MSYC_10 yc vbn vss vss sg13_hv_nmos w=6u l=6u ng=1 m=1
Mdummy_11 vss vbn vss vss sg13_hv_nmos w=2u l=6u ng=1 m=1
.ENDS s2d_sinks_cmfb_c3_core

.SUBCKT bias_tree_noab_n_c3 en_3v3 en_3v3_b iref ni vbp vbpc vss
MNBPC_0 vbpc ni vss vss sg13_hv_nmos w=2.4u l=6u ng=1 m=1
MNBP_1 vbp ni vss vss sg13_hv_nmos w=6u l=6u ng=1 m=1
MNI_2 ni ni vss vss sg13_hv_nmos w=6u l=6u ng=1 m=1
Mdummy_3 vss ni vss vss sg13_hv_nmos w=2.4u l=6u ng=1 m=1
MTGN_4 iref en_3v3 ni vss sg13_hv_nmos w=1u l=0.45u ng=1 m=1
MTDN_5 ni en_3v3_b vss vss sg13_hv_nmos w=1u l=0.45u ng=1 m=1
.ENDS bias_tree_noab_n_c3

.SUBCKT bias_tree_noab_p_c3 en_3v3_b iref ni vbn vbnc vbp vdd
MPBNC vbnc vbp vdd vdd sg13_hv_pmos w=2u l=6u ng=1 m=1
MPBN vbn vbp vdd vdd sg13_hv_pmos w=5u l=6u ng=1 m=1
MD vdd vbp vdd vdd sg13_hv_pmos w=2u l=6u ng=1 m=1
MTGP iref en_3v3_b ni vdd sg13_hv_pmos w=1u l=0.45u ng=1 m=1
.ENDS bias_tree_noab_p_c3

.SUBCKT s2d_cload_c3 en_3v3_b vcm voutn voutp vss
MCLP_0 vss voutp vss vss sg13_hv_nmos w=12u l=12u ng=1 m=1
MCLN_1 vss voutn vss vss sg13_hv_nmos w=12u l=12u ng=1 m=1
MTPN_2 voutp en_3v3_b vcm vss sg13_hv_nmos w=1u l=0.45u ng=1 m=1
MTNN_3 voutn en_3v3_b vcm vss sg13_hv_nmos w=1u l=0.45u ng=1 m=1
.ENDS s2d_cload_c3

.SUBCKT s2d_pd_p_c3 en_3v3 vcm vdd voutn voutp
MTPP voutp en_3v3 vcm vdd sg13_hv_pmos w=1u l=0.45u ng=1 m=1
MTNP voutn en_3v3 vcm vdd sg13_hv_pmos w=1u l=0.45u ng=1 m=1
.ENDS s2d_pd_p_c3

.SUBCKT sg13cmos5l_IOPadSingle2Diff iovdd iovss vdd vss pad outp outn vcm vref iref en_3v3 en_3v3_b
* s2d_block (s2d_mpdda_pd + bias_tree_noab_pd as placed)
Xsinks vbn iovss x y sinks_6x6_s2d_c3_core
Xcascn vbnc vcmfb iovdd outn outp iovss x xc y yc s2d_casc_n_f
Xcascp dd ln lp vbpc vcmfb iovdd outn outp s2d_casc_p_f
Xloads dd ln lp vcmfb iovdd s2d_loads_f
Xtlo sa_F1 sa_F2 sa_M2 sb_A1 sb_A2 sb_M1 vbp iovdd s2d_tails_lo_f
Xinputs sa_A1 sa_A2 sa_F1 sa_F2 sa_M1 sa_M2 sb_A1 sb_A2 sb_F1 sb_F2 sb_M1 sb_M2 vcm iovdd outn outp pad vref x xc y yc s2d_inputs_c3
Xthi sa_A1 sa_A2 sa_M1 sb_F1 sb_F2 sb_M2 vbp iovdd s2d_tails_hi_f
Xrhigh sa_A1 sa_A2 sa_F1 sa_F2 sa_M1 sa_M2 sb_A1 sb_A2 sb_F1 sb_F2 sb_M1 sb_M2 iovss s2d_rhigh_c3
Xsinkc vbn iovss xc yc s2d_sinks_cmfb_c3_core
Xtreen en_3v3 en_3v3_b iref ni vbp vbpc iovss bias_tree_noab_n_c3
Xtreep en_3v3_b iref ni vbn vbnc vbp iovdd bias_tree_noab_p_c3
Xcload en_3v3_b vcm outn outp iovss s2d_cload_c3
Xpdp en_3v3 vcm iovdd outn outp s2d_pd_p_c3
* protection as drawn in the template (s2d_pad_esd.sch; template_extracted.cir)
RRP iovdd gp iovss rppd w=0.5u l=12.9u m=1 b=0
MMCP pad gp iovdd iovdd sg13_hv_pmos w=266.4u l=0.6u ng=40 m=1
RRN gn iovss iovss rppd w=0.5u l=3.54u m=1 b=0
MMCN pad gn iovss iovss sg13_hv_nmos w=88u l=0.6u ng=20 m=1
DDP1 pad iovdd dpantenna A=35.0028p P=58.08u m=1
DDP2 pad iovdd dpantenna A=35.0028p P=58.08u m=1
DDN1 iovss pad dantenna A=35.0028p P=58.08u m=1
DDN2 iovss pad dantenna A=35.0028p P=58.08u m=1
.ENDS sg13cmos5l_IOPadSingle2Diff
