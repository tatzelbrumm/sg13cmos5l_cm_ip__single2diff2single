* Extracted by KLayout with SG13CMOS5L LVS runset on : 31/10/2026 16:28

.SUBCKT d2s_casc_n_c b l1 vss x y
M$1 l1 \$14 x vss sg13_hv_nmos L=3u W=30u AS=10.2p AD=10.2p PS=61.36u PD=61.36u
+ rfmode=0
M$2 y \$14 b vss sg13_hv_nmos L=3u W=30u AS=10.2p AD=10.2p PS=61.36u PD=61.36u
+ rfmode=0
M$5 vss \$14 \$14 vss sg13_hv_nmos L=8u W=1u AS=0.34p AD=0.34p PS=2.68u
+ PD=2.68u rfmode=0
.ENDS d2s_casc_n_c
