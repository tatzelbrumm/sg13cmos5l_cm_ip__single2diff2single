* Extracted by KLayout with SG13CMOS5L LVS runset on : 31/10/2026 16:31

.SUBCKT sinks_6x6_c vbn vss x y
M$1 vss vbn vss vss sg13_hv_nmos L=6u W=6u AS=2.04p AD=2.04p PS=14.04u
+ PD=14.04u rfmode=0
M$2 vss vbn vbn vss sg13_hv_nmos L=6u W=6u AS=2.04p AD=2.04p PS=12.68u
+ PD=12.68u rfmode=0
M$3 x vbn vss vss sg13_hv_nmos L=6u W=36u AS=12.24p AD=12.24p PS=76.08u
+ PD=76.08u rfmode=0
M$4 vss vbn y vss sg13_hv_nmos L=6u W=36u AS=12.24p AD=12.24p PS=76.08u
+ PD=76.08u rfmode=0
.ENDS sinks_6x6_c
