* Extracted by KLayout with SG13CMOS5L LVS runset on : 31/10/2026 16:36

.SUBCKT d2s_pd_n_c b en_3v3_b vabn vss vsso
M$1 vsso en_3v3_b b vss sg13_hv_nmos L=0.45u W=1u AS=0.34p AD=0.34p PS=2.68u
+ PD=2.68u rfmode=0
M$2 vss en_3v3_b vabn vss sg13_hv_nmos L=0.45u W=1u AS=0.34p AD=0.34p PS=2.68u
+ PD=2.68u rfmode=0
.ENDS d2s_pd_n_c
