* PEX produced on Sat Oct 31 17:22:41 UTC 2026 using /usr/local/bin/sak-pex.sh with m=2 and s=1
* NGSPICE file created from sg13cmos5l_IOPadDiff2Single_pex.ext - technology: ihp-sg13cmos5l

.subckt sg13cmos5l_IOPadDiff2Single_pex pad
X0 d2s_block_0.d2s_inputs_c_0.sa_C2 d2s_block_0.d2s_tails_c_0.vbp DCNDiode_0.guard DCNDiode_0.guard sg13_hv_pmos ad=1.7p pd=10.68u as=1.7p ps=10.68u w=5u l=6u
X1 pad d2s_cma_0.a DCNDiode_0.guard DCNDiode_0.guard sg13_hv_pmos ad=3.9294p pd=7.84u as=2.1312p ps=7.3u w=6.66u l=0.6u
X2 pad Clamp_N_M1_wiring_0.b Clamp_N_M1_1.iovss Clamp_N_M1_1.iovss sg13_hv_nmos ad=2.596p pd=5.58u as=1.408p ps=5.04u w=4.4u l=1u
X3 pad d2s_cma_0.a pad pad sg13_hv_pmos ad=2.7064p pd=16.6u as=0.64076n ps=1.63949m w=7.96u l=32.16u
X4 Clamp_N_M1_1.iovss pad dantenna l=1.26u w=67.6u
X5 pad d2s_cma_0.a DCNDiode_0.guard DCNDiode_0.guard sg13_hv_pmos ad=3.9294p pd=7.84u as=2.1312p ps=7.3u w=6.66u l=0.6u
X6 d2s_block_0.d2s_ab_p_c_0.vabp d2s_block_0.d2s_ab_p_c_0.vabp Clamp_P_M1_wiring_0.dabp DCNDiode_0.guard sg13_hv_pmos ad=2.2644p pd=14u as=2.2644p ps=14u w=6.66u l=0.6u
X7 DCNDiode_0.guard d2s_cma_0.a pad DCNDiode_0.guard sg13_hv_pmos ad=2.1312p pd=7.3u as=3.9294p ps=7.84u w=6.66u l=0.6u
X8 Clamp_N_M1_1.iovss Clamp_N_M1_wiring_0.b pad Clamp_N_M1_1.iovss sg13_hv_nmos ad=1.408p pd=5.04u as=2.596p ps=5.58u w=4.4u l=1u
X9 d2s_block_0.d2s_loads_c_0.pl d2s_block_0.d2s_loads_c_0.l2 DCNDiode_0.guard DCNDiode_0.guard sg13_hv_pmos ad=2.04p pd=12.68u as=2.04p ps=12.68u w=6u l=4u
X10 DCNDiode_0.guard d2s_block_0.d2s_tails_c_0.vbp d2s_block_0.d2s_inputs_c_0.sa_B DCNDiode_0.guard sg13_hv_pmos ad=1.7p pd=10.68u as=1.7p ps=10.68u w=5u l=6u
X11 Clamp_N_M1_wiring_0.dabn d2s_block_0.d2s_ab_n_c_0.vabn d2s_block_0.d2s_ab_n_c_0.vabn Clamp_N_M1_1.iovss sg13_hv_nmos ad=1.496p pd=9.48u as=1.496p ps=9.48u w=4.4u l=1u
X12 d2s_cma_0.a d2s_block_0.d2s_ab_n_c_0.vabn Clamp_N_M1_wiring_0.b Clamp_N_M1_1.iovss sg13_hv_nmos ad=1.496p pd=9.48u as=1.496p ps=9.48u w=4.4u l=1u
X13 pad d2s_cma_0.a DCNDiode_0.guard DCNDiode_0.guard sg13_hv_pmos ad=3.9294p pd=7.84u as=2.1312p ps=7.3u w=6.66u l=0.6u
X14 pad Clamp_N_M1_wiring_0.b Clamp_N_M1_1.iovss Clamp_N_M1_1.iovss sg13_hv_nmos ad=2.596p pd=5.58u as=1.408p ps=5.04u w=4.4u l=1u
X15 DCNDiode_0.guard d2s_block_0.d2s_loads_c_0.l2 DCNDiode_0.guard DCNDiode_0.guard sg13_hv_pmos ad=0.68p pd=4.68u as=0.80471n ps=3.49253m w=2u l=4u
X16 pad d2s_cma_0.a DCNDiode_0.guard DCNDiode_0.guard sg13_hv_pmos ad=3.9294p pd=7.84u as=2.1312p ps=7.3u w=6.66u l=0.6u
X17 pad DCNDiode_0.guard dpantenna l=1.26u w=65.8u
X18 pad d2s_cma_0.a DCNDiode_0.guard DCNDiode_0.guard sg13_hv_pmos ad=4.9284p pd=14.8u as=2.1312p ps=7.3u w=6.66u l=0.6u
X19 d2s_block_0.d2s_inputs_c_0.sb_A a_4450_18030# Clamp_N_M1_1.iovss rhigh l=12.65u w=0.5u
X20 Clamp_N_M1_1.iovss Clamp_N_M1_wiring_0.b pad Clamp_N_M1_1.iovss sg13_hv_nmos ad=1.408p pd=5.04u as=2.596p ps=5.58u w=4.4u l=1u
X21 d2s_block_0.d2s_inputs_c_0.y d2s_block_0.sinks_6x6_c_0.vbn Clamp_N_M1_1.iovss Clamp_N_M1_1.iovss sg13_hv_nmos ad=2.04p pd=12.68u as=2.04p ps=12.68u w=6u l=6u
X22 d2s_block_0.d2s_inputs_c_0.sb_A d2s_block_0.vref d2s_block_0.d2s_inputs_c_0.x d2s_block_0.d2s_inputs_c_0.sb_A sg13_hv_pmos ad=3.4p pd=20.68u as=1.9p ps=10.38u w=10u l=1u
X23 pad d2s_cma_0.a DCNDiode_0.guard DCNDiode_0.guard sg13_hv_pmos ad=3.9294p pd=7.84u as=2.1312p ps=7.3u w=6.66u l=0.6u
X24 pad Clamp_N_M1_wiring_0.b Clamp_N_M1_1.iovss Clamp_N_M1_1.iovss sg13_hv_nmos ad=2.596p pd=5.58u as=1.408p ps=5.04u w=4.4u l=1u
X25 pad Clamp_N_M1_wiring_0.b Clamp_N_M1_1.iovss Clamp_N_M1_1.iovss sg13_hv_nmos ad=2.596p pd=5.58u as=1.408p ps=5.04u w=4.4u l=1u
X26 DCNDiode_0.guard d2s_cma_0.a pad DCNDiode_0.guard sg13_hv_pmos ad=2.1312p pd=7.3u as=3.9294p ps=7.84u w=6.66u l=0.6u
X27 DCNDiode_0.guard d2s_cma_0.a pad DCNDiode_0.guard sg13_hv_pmos ad=2.1312p pd=7.3u as=3.9294p ps=7.84u w=6.66u l=0.6u
X28 DCNDiode_0.guard d2s_cma_0.a pad DCNDiode_0.guard sg13_hv_pmos ad=2.1312p pd=7.3u as=3.9294p ps=7.84u w=6.66u l=0.6u
X29 Clamp_N_M1_1.iovss Clamp_N_M1_wiring_0.b pad Clamp_N_M1_1.iovss sg13_hv_nmos ad=1.408p pd=5.04u as=2.596p ps=5.58u w=4.4u l=1u
X30 Clamp_N_M1_1.iovss Clamp_N_M1_wiring_0.b pad Clamp_N_M1_1.iovss sg13_hv_nmos ad=1.408p pd=5.04u as=2.596p ps=5.58u w=4.4u l=1u
X31 Clamp_N_M1_1.iovss Clamp_N_M1_wiring_0.b pad Clamp_N_M1_1.iovss sg13_hv_nmos ad=1.408p pd=5.04u as=2.596p ps=5.58u w=4.4u l=1u
X32 DCNDiode_0.guard d2s_cma_0.a pad DCNDiode_0.guard sg13_hv_pmos ad=2.1312p pd=7.3u as=3.9294p ps=7.84u w=6.66u l=0.6u
X33 pad d2s_cma_0.a DCNDiode_0.guard DCNDiode_0.guard sg13_hv_pmos ad=3.9294p pd=7.84u as=2.1312p ps=7.3u w=6.66u l=0.6u
X34 d2s_block_0.d2s_inputs_c_0.x d2s_block_0.vref d2s_block_0.d2s_inputs_c_0.sb_A d2s_block_0.d2s_inputs_c_0.sb_A sg13_hv_pmos ad=1.9p pd=10.38u as=3.4p ps=20.68u w=10u l=1u
X35 pad d2s_cma_0.a DCNDiode_0.guard DCNDiode_0.guard sg13_hv_pmos ad=3.9294p pd=7.84u as=2.1312p ps=7.3u w=6.66u l=0.6u
X36 pad Clamp_N_M1_wiring_0.b Clamp_N_M1_1.iovss Clamp_N_M1_1.iovss sg13_hv_nmos ad=2.596p pd=5.58u as=1.408p ps=5.04u w=4.4u l=1u
X37 DCNDiode_0.guard d2s_block_0.d2s_tails_c_0.vbp DCNDiode_0.guard DCNDiode_0.guard sg13_hv_pmos ad=1.7p pd=10.68u as=0 ps=0 w=5u l=6u
X38 d2s_block_0.d2s_inputs_c_0.sa_B a_3498_18030# Clamp_N_M1_1.iovss rhigh l=12.65u w=0.5u
X39 Clamp_N_M1_wiring_0.b d2s_block_0.en_3v3_b Clamp_N_M1_1.iovss Clamp_N_M1_1.iovss sg13_hv_nmos ad=0.34p pd=2.68u as=0.34p ps=2.68u w=1u l=0.45u
X40 pad Clamp_N_M1_wiring_0.b Clamp_N_M1_1.iovss Clamp_N_M1_1.iovss sg13_hv_nmos ad=2.596p pd=5.58u as=1.408p ps=5.04u w=4.4u l=1u
X41 DCNDiode_0.guard d2s_cma_0.a pad DCNDiode_0.guard sg13_hv_pmos ad=2.1312p pd=7.3u as=3.9294p ps=7.84u w=6.66u l=0.6u
X42 d2s_block_0.sinks_6x6_c_0.vbn d2s_block_0.sinks_6x6_c_0.vbn Clamp_N_M1_1.iovss Clamp_N_M1_1.iovss sg13_hv_nmos ad=2.04p pd=12.68u as=2.04p ps=12.68u w=6u l=6u
X43 d2s_block_0.d2s_inputs_c_0.x d2s_block_0.sinks_6x6_c_0.vbn Clamp_N_M1_1.iovss Clamp_N_M1_1.iovss sg13_hv_nmos ad=2.04p pd=12.68u as=2.04p ps=12.68u w=6u l=6u
X44 d2s_block_0.d2s_inputs_c_0.sb_B d2s_block_0.d2s_tails_c_0.vbp DCNDiode_0.guard DCNDiode_0.guard sg13_hv_pmos ad=1.7p pd=10.68u as=1.7p ps=10.68u w=5u l=6u
X45 pad d2s_cma_0.a DCNDiode_0.guard DCNDiode_0.guard sg13_hv_pmos ad=3.9294p pd=7.84u as=2.1312p ps=7.3u w=6.66u l=0.6u
X46 Clamp_N_M1_1.iovss Clamp_N_M1_wiring_0.b pad Clamp_N_M1_1.iovss sg13_hv_nmos ad=1.408p pd=5.04u as=2.596p ps=5.58u w=4.4u l=1u
X47 d2s_block_0.iref d2s_block_0.en_3v3 d2s_block_0.bias_tree_pd_0.bias_tree_swp_0.ni Clamp_N_M1_1.iovss sg13_hv_nmos ad=0.34p pd=2.68u as=0.19p ps=1.38u w=1u l=0.45u
X48 d2s_block_0.d2s_inputs_c_0.y d2s_block_0.vref d2s_block_0.d2s_inputs_c_0.sa_C1 d2s_block_0.d2s_inputs_c_0.sa_C1 sg13_hv_pmos ad=1.9p pd=10.38u as=3.4p ps=20.68u w=10u l=1u
X49 pad Clamp_N_M1_wiring_0.b Clamp_N_M1_1.iovss Clamp_N_M1_1.iovss sg13_hv_nmos ad=2.596p pd=5.58u as=1.408p ps=5.04u w=4.4u l=1u
X50 Clamp_N_M1_wiring_0.b pad Clamp_N_M1_wiring_0.b Clamp_N_M1_wiring_0.b sg13_hv_pmos ad=2.7064p pd=16.6u as=0.34415n ps=1.16146m w=7.96u l=32.16u
X51 DCNDiode_0.guard d2s_cma_0.a pad DCNDiode_0.guard sg13_hv_pmos ad=2.1312p pd=7.3u as=3.9294p ps=7.84u w=6.66u l=0.6u
X52 pad Clamp_N_M1_wiring_0.b Clamp_N_M1_1.iovss Clamp_N_M1_1.iovss sg13_hv_nmos ad=2.596p pd=5.58u as=1.408p ps=5.04u w=4.4u l=1u
X53 d2s_block_0.d2s_ab_n_c_0.vabn d2s_block_0.en_3v3_b Clamp_N_M1_1.iovss Clamp_N_M1_1.iovss sg13_hv_nmos ad=0.34p pd=2.68u as=0.34p ps=2.68u w=1u l=0.45u
X54 pad d2s_cma_0.a DCNDiode_0.guard DCNDiode_0.guard sg13_hv_pmos ad=3.9294p pd=7.84u as=2.1312p ps=7.3u w=6.66u l=0.6u
X55 DCNDiode_0.guard d2s_cma_0.a pad DCNDiode_0.guard sg13_hv_pmos ad=2.1312p pd=7.3u as=3.9294p ps=7.84u w=6.66u l=0.6u
X56 Clamp_N_M1_1.iovss Clamp_N_M1_wiring_0.b pad Clamp_N_M1_1.iovss sg13_hv_nmos ad=1.408p pd=5.04u as=2.596p ps=5.58u w=4.4u l=1u
X57 DCNDiode_0.guard d2s_block_0.d2s_tails_c_0.vbp DCNDiode_0.guard DCNDiode_0.guard sg13_hv_pmos ad=0.102p pd=1.28u as=0 ps=0 w=0.3u l=6u
X58 d2s_block_0.d2s_inputs_c_0.sb_C1 a_4722_18030# Clamp_N_M1_1.iovss rhigh l=12.65u w=0.5u
X59 DCNDiode_0.guard d2s_cma_0.a pad DCNDiode_0.guard sg13_hv_pmos ad=2.1312p pd=7.3u as=3.9294p ps=7.84u w=6.66u l=0.6u
X60 pad d2s_cma_0.a DCNDiode_0.guard DCNDiode_0.guard sg13_hv_pmos ad=3.9294p pd=7.84u as=2.1312p ps=7.3u w=6.66u l=0.6u
X61 pad Clamp_N_M1_wiring_0.b Clamp_N_M1_1.iovss Clamp_N_M1_1.iovss sg13_hv_nmos ad=2.596p pd=5.58u as=1.408p ps=5.04u w=4.4u l=1u
X62 d2s_block_0.d2s_inputs_c_0.y d2s_block_0.vinp d2s_block_0.d2s_inputs_c_0.sa_A d2s_block_0.d2s_inputs_c_0.sa_A sg13_hv_pmos ad=1.9p pd=10.38u as=3.4p ps=20.68u w=10u l=1u
X63 d2s_block_0.d2s_inputs_c_0.sb_B d2s_block_0.vinn d2s_block_0.d2s_inputs_c_0.x d2s_block_0.d2s_inputs_c_0.sb_B sg13_hv_pmos ad=3.4p pd=20.68u as=1.9p ps=10.38u w=10u l=1u
X64 pad DCNDiode_0.guard dpantenna l=1.26u w=65.8u
X65 d2s_block_0.d2s_casc_n_c_0.vbnc d2s_block_0.d2s_casc_n_c_0.vbnc Clamp_N_M1_1.iovss Clamp_N_M1_1.iovss sg13_hv_nmos ad=0.34p pd=2.68u as=0.34p ps=2.68u w=1u l=8u
X66 d2s_block_0.d2s_loads_c_0.pl d2s_block_0.d2s_loads_c_0.l2 DCNDiode_0.guard DCNDiode_0.guard sg13_hv_pmos ad=2.04p pd=12.68u as=2.04p ps=12.68u w=6u l=4u
X67 d2s_block_0.d2s_loads_c_0.pl d2s_block_0.d2s_loads_c_0.l2 DCNDiode_0.guard DCNDiode_0.guard sg13_hv_pmos ad=2.04p pd=12.68u as=2.04p ps=12.68u w=6u l=4u
X68 DCNDiode_0.guard d2s_cma_0.a pad DCNDiode_0.guard sg13_hv_pmos ad=2.1312p pd=7.3u as=3.9294p ps=7.84u w=6.66u l=0.6u
X69 Clamp_N_M1_1.iovss Clamp_N_M1_wiring_0.b pad Clamp_N_M1_1.iovss sg13_hv_nmos ad=1.408p pd=5.04u as=2.596p ps=5.58u w=4.4u l=1u
X70 Clamp_N_M1_1.iovss Clamp_N_M1_wiring_0.b pad Clamp_N_M1_1.iovss sg13_hv_nmos ad=1.408p pd=5.04u as=2.596p ps=5.58u w=4.4u l=1u
X71 d2s_block_0.d2s_loads_c_0.pl d2s_block_0.d2s_loads_c_0.l2 DCNDiode_0.guard DCNDiode_0.guard sg13_hv_pmos ad=2.04p pd=12.68u as=2.04p ps=12.68u w=6u l=4u
X72 d2s_block_0.d2s_inputs_c_0.sb_C1 pad d2s_block_0.d2s_inputs_c_0.x d2s_block_0.d2s_inputs_c_0.sb_C1 sg13_hv_pmos ad=3.4p pd=20.68u as=1.9p ps=10.38u w=10u l=1u
X73 DCNDiode_0.guard d2s_cma_0.a pad DCNDiode_0.guard sg13_hv_pmos ad=2.1312p pd=7.3u as=3.9294p ps=7.84u w=6.66u l=0.6u
X74 Clamp_N_M1_1.iovss d2s_block_0.sinks_6x6_c_0.vbn Clamp_N_M1_1.iovss Clamp_N_M1_1.iovss sg13_hv_nmos ad=0.68p pd=4.68u as=0.87537n ps=3.23331m w=2u l=6u
X75 d2s_block_0.d2s_inputs_c_0.sb_A d2s_block_0.d2s_tails_c_0.vbp DCNDiode_0.guard DCNDiode_0.guard sg13_hv_pmos ad=1.7p pd=10.68u as=1.7p ps=10.68u w=5u l=6u
X76 DCNDiode_0.guard DCNDiode_0.guard DCNDiode_0.guard DCNDiode_0.guard sg13_hv_pmos ad=3.4p pd=20.68u as=0 ps=0 w=10u l=1u
X77 Clamp_N_M1_1.iovss Clamp_N_M1_wiring_0.b pad Clamp_N_M1_1.iovss sg13_hv_nmos ad=1.408p pd=5.04u as=2.596p ps=5.58u w=4.4u l=1u
X78 a_4042_20646# a_4722_18030# Clamp_N_M1_1.iovss rhigh l=12.65u w=0.5u
X79 pad d2s_cma_0.a DCNDiode_0.guard DCNDiode_0.guard sg13_hv_pmos ad=3.9294p pd=7.84u as=2.1312p ps=7.3u w=6.66u l=0.6u
X80 DCNDiode_0.guard d2s_cma_0.a pad DCNDiode_0.guard sg13_hv_pmos ad=2.1312p pd=7.3u as=3.9294p ps=7.84u w=6.66u l=0.6u
X81 Clamp_N_M1_1.iovss Clamp_N_M1_wiring_0.b pad Clamp_N_M1_1.iovss sg13_hv_nmos ad=1.408p pd=5.04u as=2.596p ps=5.58u w=4.4u l=1u
X82 pad Clamp_N_M1_wiring_0.b Clamp_N_M1_1.iovss Clamp_N_M1_1.iovss sg13_hv_nmos ad=2.596p pd=5.58u as=2.068p ps=9.74u w=4.4u l=1u
X83 a_4314_20646# a_3362_18030# Clamp_N_M1_1.iovss rhigh l=12.65u w=0.5u
X84 d2s_block_0.d2s_ab_p_c_0.l1 d2s_block_0.d2s_ab_p_c_0.vabp d2s_block_0.d2s_loads_c_0.l2 DCNDiode_0.guard sg13_hv_pmos ad=2.2644p pd=14u as=2.2644p ps=14u w=6.66u l=0.6u
X85 pad Clamp_N_M1_wiring_0.b Clamp_N_M1_1.iovss Clamp_N_M1_1.iovss sg13_hv_nmos ad=2.596p pd=5.58u as=1.408p ps=5.04u w=4.4u l=1u
X86 pad d2s_cma_0.a DCNDiode_0.guard DCNDiode_0.guard sg13_hv_pmos ad=3.9294p pd=7.84u as=2.1312p ps=7.3u w=6.66u l=0.6u
X87 DCNDiode_0.guard DCNDiode_0.guard DCNDiode_0.guard DCNDiode_0.guard sg13_hv_pmos ad=3.4p pd=20.68u as=0 ps=0 w=10u l=1u
X88 pad d2s_cma_0.a DCNDiode_0.guard DCNDiode_0.guard sg13_hv_pmos ad=3.9294p pd=7.84u as=2.1312p ps=7.3u w=6.66u l=0.6u
X89 d2s_block_0.d2s_casc_p_c_0.vbpc d2s_block_0.bias_tree_pd_0.bias_tree_swp_0.ni Clamp_N_M1_1.iovss Clamp_N_M1_1.iovss sg13_hv_nmos ad=0.816p pd=5.48u as=0.816p ps=5.48u w=2.4u l=6u
X90 Clamp_N_M1_1.iovss d2s_block_0.sinks_6x6_c_0.vbn d2s_block_0.d2s_inputs_c_0.y Clamp_N_M1_1.iovss sg13_hv_nmos ad=2.04p pd=12.68u as=2.04p ps=12.68u w=6u l=6u
X91 Clamp_N_M1_1.iovss Clamp_N_M1_wiring_0.b pad Clamp_N_M1_1.iovss sg13_hv_nmos ad=1.408p pd=5.04u as=2.596p ps=5.58u w=4.4u l=1u
X92 Clamp_N_M1_1.iovss Clamp_N_M1_wiring_0.b pad Clamp_N_M1_1.iovss sg13_hv_nmos ad=1.408p pd=5.04u as=2.596p ps=5.58u w=4.4u l=1u
X93 DCNDiode_0.guard d2s_cma_0.a pad DCNDiode_0.guard sg13_hv_pmos ad=2.1312p pd=7.3u as=3.9294p ps=7.84u w=6.66u l=0.6u
X94 pad Clamp_N_M1_wiring_0.b Clamp_N_M1_1.iovss Clamp_N_M1_1.iovss sg13_hv_nmos ad=3.256p pd=10.28u as=1.408p ps=5.04u w=4.4u l=1u
X95 DCNDiode_0.guard d2s_block_0.d2s_loads_c_0.l2 DCNDiode_0.guard DCNDiode_0.guard sg13_hv_pmos ad=0.68p pd=4.68u as=0 ps=0 w=2u l=4u
X96 d2s_block_0.d2s_loads_c_0.pr d2s_block_0.d2s_casc_p_c_0.vbpc d2s_cma_0.a DCNDiode_0.guard sg13_hv_pmos ad=5.1p pd=30.68u as=5.1p ps=30.68u w=15u l=3u
X97 d2s_block_0.d2s_inputs_c_0.x d2s_block_0.d2s_casc_n_c_0.vbnc d2s_block_0.d2s_ab_p_c_0.l1 Clamp_N_M1_1.iovss sg13_hv_nmos ad=5.1p pd=30.68u as=5.1p ps=30.68u w=15u l=3u
X98 pad Clamp_N_M1_wiring_0.b Clamp_N_M1_1.iovss Clamp_N_M1_1.iovss sg13_hv_nmos ad=2.596p pd=5.58u as=1.408p ps=5.04u w=4.4u l=1u
X99 d2s_block_0.d2s_ab_p_c_0.vabp d2s_block_0.bias_tree_pd_0.bias_tree_swp_0.ni Clamp_N_M1_1.iovss Clamp_N_M1_1.iovss sg13_hv_nmos ad=2.04p pd=12.68u as=2.04p ps=12.68u w=6u l=6u
X100 DCNDiode_0.guard d2s_cma_0.a pad DCNDiode_0.guard sg13_hv_pmos ad=2.1312p pd=7.3u as=3.9294p ps=7.84u w=6.66u l=0.6u
X101 DCNDiode_0.guard d2s_block_0.d2s_tails_c_0.vbp d2s_block_0.d2s_inputs_c_0.sb_C2 DCNDiode_0.guard sg13_hv_pmos ad=1.7p pd=10.68u as=1.7p ps=10.68u w=5u l=6u
X102 d2s_block_0.d2s_tails_c_0.vbp d2s_block_0.d2s_tails_c_0.vbp DCNDiode_0.guard DCNDiode_0.guard sg13_hv_pmos ad=1.7p pd=10.68u as=1.7p ps=10.68u w=5u l=6u
X103 Clamp_N_M1_1.iovss Clamp_N_M1_wiring_0.b pad Clamp_N_M1_1.iovss sg13_hv_nmos ad=1.408p pd=5.04u as=2.596p ps=5.58u w=4.4u l=1u
X104 d2s_block_0.d2s_loads_c_0.pr d2s_block_0.d2s_loads_c_0.l2 DCNDiode_0.guard DCNDiode_0.guard sg13_hv_pmos ad=2.04p pd=12.68u as=2.04p ps=12.68u w=6u l=4u
X105 Clamp_N_M1_1.iovss d2s_block_0.bias_tree_pd_0.bias_tree_swp_0.ni Clamp_N_M1_1.iovss Clamp_N_M1_1.iovss sg13_hv_nmos ad=0.816p pd=5.48u as=0 ps=0 w=2.4u l=6u
X106 DCNDiode_0.guard d2s_cma_0.a pad DCNDiode_0.guard sg13_hv_pmos ad=2.1312p pd=7.3u as=3.9294p ps=7.84u w=6.66u l=0.6u
X107 DCNDiode_0.guard Clamp_P_M1_wiring_0.dabp Clamp_P_M1_wiring_0.dabp DCNDiode_0.guard sg13_hv_pmos ad=2.1312p pd=7.3u as=3.9294p ps=7.84u w=6.66u l=0.6u
X108 DCNDiode_0.guard d2s_block_0.en_3v3 d2s_cma_0.a DCNDiode_0.guard sg13_hv_pmos ad=0.34p pd=2.68u as=0.34p ps=2.68u w=1u l=0.45u
X109 pad d2s_cma_0.a DCNDiode_0.guard DCNDiode_0.guard sg13_hv_pmos ad=3.9294p pd=7.84u as=2.1312p ps=7.3u w=6.66u l=0.6u
X110 DCNDiode_0.guard d2s_cma_0.a pad DCNDiode_0.guard sg13_hv_pmos ad=2.1312p pd=7.3u as=3.9294p ps=7.84u w=6.66u l=0.6u
X111 Clamp_N_M1_1.iovss Clamp_N_M1_1.iovss Clamp_N_M1_1.iovss rhigh l=12.65u w=0.5u
X112 a_3906_20646# a_3770_18030# Clamp_N_M1_1.iovss rhigh l=12.65u w=0.5u
X113 Clamp_N_M1_1.iovss Clamp_N_M1_wiring_0.b pad Clamp_N_M1_1.iovss sg13_hv_nmos ad=1.408p pd=5.04u as=2.596p ps=5.58u w=4.4u l=1u
X114 pad d2s_cma_0.a DCNDiode_0.guard DCNDiode_0.guard sg13_hv_pmos ad=3.9294p pd=7.84u as=2.1312p ps=7.3u w=6.66u l=0.6u
X115 pad Clamp_N_M1_wiring_0.b Clamp_N_M1_1.iovss Clamp_N_M1_1.iovss sg13_hv_nmos ad=2.596p pd=5.58u as=1.408p ps=5.04u w=4.4u l=1u
X116 pad Clamp_N_M1_wiring_0.b Clamp_N_M1_1.iovss Clamp_N_M1_1.iovss sg13_hv_nmos ad=2.596p pd=5.58u as=1.408p ps=5.04u w=4.4u l=1u
X117 DCNDiode_0.guard d2s_cma_0.a pad DCNDiode_0.guard sg13_hv_pmos ad=2.1312p pd=7.3u as=3.9294p ps=7.84u w=6.66u l=0.6u
X118 d2s_block_0.d2s_inputs_c_0.y d2s_block_0.vref d2s_block_0.d2s_inputs_c_0.sa_C2 d2s_block_0.d2s_inputs_c_0.sa_C2 sg13_hv_pmos ad=1.9p pd=10.38u as=3.4p ps=20.68u w=10u l=1u
X119 a_4314_20646# a_4450_18030# Clamp_N_M1_1.iovss rhigh l=12.65u w=0.5u
X120 pad d2s_cma_0.a DCNDiode_0.guard DCNDiode_0.guard sg13_hv_pmos ad=3.9294p pd=7.84u as=2.1312p ps=7.3u w=6.66u l=0.6u
X121 pad Clamp_N_M1_wiring_0.b Clamp_N_M1_1.iovss Clamp_N_M1_1.iovss sg13_hv_nmos ad=2.596p pd=5.58u as=1.408p ps=5.04u w=4.4u l=1u
X122 d2s_block_0.iref d2s_block_0.en_3v3_b d2s_block_0.bias_tree_pd_0.bias_tree_swp_0.ni DCNDiode_0.guard sg13_hv_pmos ad=0.34p pd=2.68u as=0.34p ps=2.68u w=1u l=0.45u
X123 d2s_block_0.d2s_inputs_c_0.sa_B d2s_block_0.vref d2s_block_0.d2s_inputs_c_0.y d2s_block_0.d2s_inputs_c_0.sa_B sg13_hv_pmos ad=3.4p pd=20.68u as=1.9p ps=10.38u w=10u l=1u
X124 a_4042_20646# a_3634_18030# Clamp_N_M1_1.iovss rhigh l=12.65u w=0.5u
X125 DCNDiode_0.guard d2s_cma_0.a pad DCNDiode_0.guard sg13_hv_pmos ad=2.1312p pd=7.3u as=3.9294p ps=7.84u w=6.66u l=0.6u
X126 pad d2s_cma_0.a DCNDiode_0.guard DCNDiode_0.guard sg13_hv_pmos ad=3.9294p pd=7.84u as=3.1302p ps=14.26u w=6.66u l=0.6u
X127 DCNDiode_0.guard d2s_block_0.d2s_tails_c_0.vbp DCNDiode_0.guard DCNDiode_0.guard sg13_hv_pmos ad=0.102p pd=1.28u as=0 ps=0 w=0.3u l=6u
X128 d2s_block_0.d2s_ab_p_c_0.vabp d2s_block_0.en_3v3 DCNDiode_0.guard DCNDiode_0.guard sg13_hv_pmos ad=0.34p pd=2.68u as=0.34p ps=2.68u w=1u l=0.45u
X129 d2s_block_0.d2s_inputs_c_0.x d2s_block_0.d2s_casc_n_c_0.vbnc d2s_block_0.d2s_ab_p_c_0.l1 Clamp_N_M1_1.iovss sg13_hv_nmos ad=5.1p pd=30.68u as=5.1p ps=30.68u w=15u l=3u
X130 Clamp_N_M1_1.iovss Clamp_N_M1_wiring_0.b pad Clamp_N_M1_1.iovss sg13_hv_nmos ad=1.408p pd=5.04u as=2.596p ps=5.58u w=4.4u l=1u
X131 Clamp_N_M1_1.iovss Clamp_N_M1_wiring_0.b pad Clamp_N_M1_1.iovss sg13_hv_nmos ad=1.408p pd=5.04u as=2.596p ps=5.58u w=4.4u l=1u
X132 Clamp_N_M1_1.iovss Clamp_N_M1_wiring_0.b pad Clamp_N_M1_1.iovss sg13_hv_nmos ad=1.408p pd=5.04u as=2.596p ps=5.58u w=4.4u l=1u
X133 pad d2s_cma_0.a DCNDiode_0.guard DCNDiode_0.guard sg13_hv_pmos ad=3.9294p pd=7.84u as=2.1312p ps=7.3u w=6.66u l=0.6u
X134 Clamp_N_M1_1.iovss d2s_block_0.sinks_6x6_c_0.vbn Clamp_N_M1_1.iovss Clamp_N_M1_1.iovss sg13_hv_nmos ad=0.68p pd=4.68u as=0 ps=0 w=2u l=6u
X135 Clamp_N_M1_1.iovss d2s_block_0.sinks_6x6_c_0.vbn Clamp_N_M1_1.iovss Clamp_N_M1_1.iovss sg13_hv_nmos ad=0.68p pd=4.68u as=0 ps=0 w=2u l=6u
X136 pad Clamp_N_M1_wiring_0.b Clamp_N_M1_1.iovss Clamp_N_M1_1.iovss sg13_hv_nmos ad=2.596p pd=5.58u as=1.408p ps=5.04u w=4.4u l=1u
X137 DCNDiode_0.guard d2s_block_0.d2s_tails_c_0.vbp DCNDiode_0.guard DCNDiode_0.guard sg13_hv_pmos ad=0.68p pd=4.68u as=0 ps=0 w=2u l=6u
X138 d2s_block_0.d2s_inputs_c_0.y d2s_block_0.vref d2s_block_0.d2s_inputs_c_0.sa_B d2s_block_0.d2s_inputs_c_0.sa_B sg13_hv_pmos ad=1.9p pd=10.38u as=3.4p ps=20.68u w=10u l=1u
X139 pad Clamp_N_M1_wiring_0.b Clamp_N_M1_1.iovss Clamp_N_M1_1.iovss sg13_hv_nmos ad=2.596p pd=5.58u as=1.408p ps=5.04u w=4.4u l=1u
X140 DCNDiode_0.guard d2s_cma_0.a pad DCNDiode_0.guard sg13_hv_pmos ad=2.1312p pd=7.3u as=3.9294p ps=7.84u w=6.66u l=0.6u
X141 DCNDiode_0.guard d2s_cma_0.a pad DCNDiode_0.guard sg13_hv_pmos ad=2.1312p pd=7.3u as=3.9294p ps=7.84u w=6.66u l=0.6u
X142 DCNDiode_0.guard Clamp_P_M1_wiring_0.dabp Clamp_P_M1_wiring_0.dabp DCNDiode_0.guard sg13_hv_pmos ad=2.1312p pd=7.3u as=3.9294p ps=7.84u w=6.66u l=0.6u
X143 Clamp_N_M1_1.iovss Clamp_N_M1_wiring_0.b pad Clamp_N_M1_1.iovss sg13_hv_nmos ad=1.408p pd=5.04u as=2.596p ps=5.58u w=4.4u l=1u
X144 Clamp_N_M1_1.iovss d2s_block_0.sinks_6x6_c_0.vbn d2s_block_0.d2s_inputs_c_0.x Clamp_N_M1_1.iovss sg13_hv_nmos ad=2.04p pd=12.68u as=2.04p ps=12.68u w=6u l=6u
X145 d2s_block_0.d2s_loads_c_0.l2 d2s_block_0.d2s_casc_p_c_0.vbpc d2s_block_0.d2s_loads_c_0.pl DCNDiode_0.guard sg13_hv_pmos ad=5.1p pd=30.68u as=5.1p ps=30.68u w=15u l=3u
X146 pad d2s_cma_0.a DCNDiode_0.guard DCNDiode_0.guard sg13_hv_pmos ad=3.9294p pd=7.84u as=2.1312p ps=7.3u w=6.66u l=0.6u
X147 pad Clamp_N_M1_wiring_0.b Clamp_N_M1_1.iovss Clamp_N_M1_1.iovss sg13_hv_nmos ad=2.596p pd=5.58u as=1.408p ps=5.04u w=4.4u l=1u
X148 pad Clamp_N_M1_wiring_0.b Clamp_N_M1_1.iovss Clamp_N_M1_1.iovss sg13_hv_nmos ad=2.596p pd=5.58u as=1.408p ps=5.04u w=4.4u l=1u
X149 d2s_block_0.d2s_inputs_c_0.x pad d2s_block_0.d2s_inputs_c_0.sb_C2 d2s_block_0.d2s_inputs_c_0.sb_C2 sg13_hv_pmos ad=1.9p pd=10.38u as=3.4p ps=20.68u w=10u l=1u
X150 d2s_block_0.d2s_inputs_c_0.sa_C1 d2s_block_0.vref d2s_block_0.d2s_inputs_c_0.y d2s_block_0.d2s_inputs_c_0.sa_C1 sg13_hv_pmos ad=3.4p pd=20.68u as=1.9p ps=10.38u w=10u l=1u
X151 d2s_block_0.d2s_inputs_c_0.x d2s_block_0.sinks_6x6_c_0.vbn Clamp_N_M1_1.iovss Clamp_N_M1_1.iovss sg13_hv_nmos ad=2.04p pd=12.68u as=2.04p ps=12.68u w=6u l=6u
X152 DCNDiode_0.guard d2s_cma_0.a pad DCNDiode_0.guard sg13_hv_pmos ad=2.1312p pd=7.3u as=3.9294p ps=7.84u w=6.66u l=0.6u
X153 DCNDiode_0.guard d2s_cma_0.a pad DCNDiode_0.guard sg13_hv_pmos ad=2.1312p pd=7.3u as=3.9294p ps=7.84u w=6.66u l=0.6u
X154 Clamp_N_M1_1.iovss Clamp_N_M1_wiring_0.b pad Clamp_N_M1_1.iovss sg13_hv_nmos ad=1.408p pd=5.04u as=2.596p ps=5.58u w=4.4u l=1u
X155 d2s_block_0.d2s_inputs_c_0.sb_B a_4586_18030# Clamp_N_M1_1.iovss rhigh l=12.65u w=0.5u
X156 Clamp_N_M1_1.iovss Clamp_N_M1_wiring_0.b pad Clamp_N_M1_1.iovss sg13_hv_nmos ad=1.408p pd=5.04u as=2.596p ps=5.58u w=4.4u l=1u
X157 d2s_block_0.d2s_inputs_c_0.sa_C1 a_3634_18030# Clamp_N_M1_1.iovss rhigh l=12.65u w=0.5u
X158 pad d2s_cma_0.a DCNDiode_0.guard DCNDiode_0.guard sg13_hv_pmos ad=3.9294p pd=7.84u as=3.1302p ps=14.26u w=6.66u l=0.6u
X159 Clamp_N_M1_wiring_0.dabn Clamp_N_M1_wiring_0.dabn Clamp_N_M1_1.iovss Clamp_N_M1_1.iovss sg13_hv_nmos ad=2.596p pd=5.58u as=1.408p ps=5.04u w=4.4u l=1u
X160 DCNDiode_0.guard d2s_cma_0.a pad DCNDiode_0.guard sg13_hv_pmos ad=2.1312p pd=7.3u as=3.9294p ps=7.84u w=6.66u l=0.6u
X161 Clamp_N_M1_1.iovss Clamp_N_M1_1.iovss Clamp_N_M1_1.iovss rhigh l=12.65u w=0.5u
X162 pad d2s_cma_0.a DCNDiode_0.guard DCNDiode_0.guard sg13_hv_pmos ad=3.9294p pd=7.84u as=2.1312p ps=7.3u w=6.66u l=0.6u
X163 pad d2s_cma_0.a DCNDiode_0.guard DCNDiode_0.guard sg13_hv_pmos ad=3.9294p pd=7.84u as=2.1312p ps=7.3u w=6.66u l=0.6u
X164 Clamp_N_M1_wiring_0.b d2s_block_0.d2s_casc_n_c_0.vbnc d2s_block_0.d2s_inputs_c_0.y Clamp_N_M1_1.iovss sg13_hv_nmos ad=5.1p pd=30.68u as=5.1p ps=30.68u w=15u l=3u
X165 pad Clamp_N_M1_wiring_0.b Clamp_N_M1_1.iovss Clamp_N_M1_1.iovss sg13_hv_nmos ad=2.596p pd=5.58u as=1.408p ps=5.04u w=4.4u l=1u
X166 DCNDiode_0.guard d2s_cma_0.a pad DCNDiode_0.guard sg13_hv_pmos ad=2.1312p pd=7.3u as=3.9294p ps=7.84u w=6.66u l=0.6u
X167 pad d2s_cma_0.a DCNDiode_0.guard DCNDiode_0.guard sg13_hv_pmos ad=3.9294p pd=7.84u as=2.1312p ps=7.3u w=6.66u l=0.6u
X168 d2s_block_0.d2s_inputs_c_0.sa_A d2s_block_0.vinp d2s_block_0.d2s_inputs_c_0.y d2s_block_0.d2s_inputs_c_0.sa_A sg13_hv_pmos ad=3.4p pd=20.68u as=1.9p ps=10.38u w=10u l=1u
X169 Clamp_N_M1_wiring_0.b d2s_block_0.d2s_ab_p_c_0.vabp d2s_cma_0.a DCNDiode_0.guard sg13_hv_pmos ad=2.2644p pd=14u as=2.2644p ps=14u w=6.66u l=0.6u
X170 Clamp_N_M1_1.iovss Clamp_N_M1_wiring_0.b pad Clamp_N_M1_1.iovss sg13_hv_nmos ad=1.408p pd=5.04u as=2.596p ps=5.58u w=4.4u l=1u
X171 pad d2s_cma_0.a DCNDiode_0.guard DCNDiode_0.guard sg13_hv_pmos ad=3.9294p pd=7.84u as=2.1312p ps=7.3u w=6.66u l=0.6u
X172 d2s_block_0.d2s_loads_c_0.pr d2s_block_0.d2s_casc_p_c_0.vbpc d2s_cma_0.a DCNDiode_0.guard sg13_hv_pmos ad=5.1p pd=30.68u as=5.1p ps=30.68u w=15u l=3u
X173 pad Clamp_N_M1_wiring_0.b Clamp_N_M1_1.iovss Clamp_N_M1_1.iovss sg13_hv_nmos ad=2.596p pd=5.58u as=1.408p ps=5.04u w=4.4u l=1u
X174 d2s_block_0.d2s_inputs_c_0.sa_C1 d2s_block_0.d2s_tails_c_0.vbp DCNDiode_0.guard DCNDiode_0.guard sg13_hv_pmos ad=1.7p pd=10.68u as=1.7p ps=10.68u w=5u l=6u
X175 DCNDiode_0.guard d2s_cma_0.a pad DCNDiode_0.guard sg13_hv_pmos ad=2.1312p pd=7.3u as=3.9294p ps=7.84u w=6.66u l=0.6u
X176 d2s_block_0.d2s_loads_c_0.pr d2s_block_0.d2s_loads_c_0.l2 DCNDiode_0.guard DCNDiode_0.guard sg13_hv_pmos ad=2.04p pd=12.68u as=2.04p ps=12.68u w=6u l=4u
X177 pad d2s_cma_0.a DCNDiode_0.guard DCNDiode_0.guard sg13_hv_pmos ad=3.9294p pd=7.84u as=2.1312p ps=7.3u w=6.66u l=0.6u
X178 Clamp_N_M1_1.iovss Clamp_N_M1_wiring_0.b pad Clamp_N_M1_1.iovss sg13_hv_nmos ad=1.408p pd=5.04u as=2.596p ps=5.58u w=4.4u l=1u
X179 Clamp_N_M1_1.iovss d2s_block_0.sinks_6x6_c_0.vbn d2s_block_0.d2s_inputs_c_0.y Clamp_N_M1_1.iovss sg13_hv_nmos ad=2.04p pd=12.68u as=2.04p ps=12.68u w=6u l=6u
X180 DCNDiode_0.guard DCNDiode_0.guard DCNDiode_0.guard DCNDiode_0.guard sg13_hv_pmos ad=3.4p pd=20.68u as=0 ps=0 w=10u l=1u
X181 d2s_block_0.d2s_inputs_c_0.y d2s_block_0.sinks_6x6_c_0.vbn Clamp_N_M1_1.iovss Clamp_N_M1_1.iovss sg13_hv_nmos ad=2.04p pd=12.68u as=2.04p ps=12.68u w=6u l=6u
X182 DCNDiode_0.guard d2s_block_0.d2s_tails_c_0.vbp d2s_block_0.d2s_inputs_c_0.sb_C1 DCNDiode_0.guard sg13_hv_pmos ad=1.7p pd=10.68u as=1.7p ps=10.68u w=5u l=6u
X183 a_3906_20646# a_4858_18030# Clamp_N_M1_1.iovss rhigh l=12.65u w=0.5u
X184 DCNDiode_0.guard d2s_cma_0.a pad DCNDiode_0.guard sg13_hv_pmos ad=2.1312p pd=7.3u as=3.9294p ps=7.84u w=6.66u l=0.6u
X185 Clamp_P_M1_wiring_0.dabp DCNDiode_0.guard DCNDiode_0.guard DCNDiode_0.guard sg13_hv_pmos ad=3.9294p pd=7.84u as=2.1312p ps=7.3u w=6.66u l=0.6u
X186 Clamp_N_M1_1.iovss Clamp_N_M1_wiring_0.b pad Clamp_N_M1_1.iovss sg13_hv_nmos ad=1.408p pd=5.04u as=2.596p ps=5.58u w=4.4u l=1u
X187 DCNDiode_0.guard d2s_cma_0.a pad DCNDiode_0.guard sg13_hv_pmos ad=2.1312p pd=7.3u as=3.9294p ps=7.84u w=6.66u l=0.6u
X188 DCNDiode_0.guard d2s_cma_0.a pad DCNDiode_0.guard sg13_hv_pmos ad=2.1312p pd=7.3u as=3.9294p ps=7.84u w=6.66u l=0.6u
X189 d2s_block_0.d2s_casc_p_c_0.vbpc d2s_block_0.d2s_casc_p_c_0.vbpc DCNDiode_0.guard DCNDiode_0.guard sg13_hv_pmos ad=0.34p pd=2.68u as=0.34p ps=2.68u w=1u l=4u
X190 d2s_block_0.d2s_inputs_c_0.sa_C2 a_3770_18030# Clamp_N_M1_1.iovss rhigh l=12.65u w=0.5u
X191 pad Clamp_N_M1_wiring_0.b Clamp_N_M1_1.iovss Clamp_N_M1_1.iovss sg13_hv_nmos ad=2.596p pd=5.58u as=1.408p ps=5.04u w=4.4u l=1u
X192 Clamp_N_M1_1.iovss pad dantenna l=1.26u w=67.6u
X193 Clamp_N_M1_wiring_0.b d2s_block_0.d2s_casc_n_c_0.vbnc d2s_block_0.d2s_inputs_c_0.y Clamp_N_M1_1.iovss sg13_hv_nmos ad=5.1p pd=30.68u as=5.1p ps=30.68u w=15u l=3u
X194 pad d2s_cma_0.a DCNDiode_0.guard DCNDiode_0.guard sg13_hv_pmos ad=3.9294p pd=7.84u as=2.1312p ps=7.3u w=6.66u l=0.6u
X195 pad Clamp_N_M1_wiring_0.b Clamp_N_M1_1.iovss Clamp_N_M1_1.iovss sg13_hv_nmos ad=2.596p pd=5.58u as=1.408p ps=5.04u w=4.4u l=1u
X196 Clamp_N_M1_1.iovss d2s_block_0.sinks_6x6_c_0.vbn d2s_block_0.d2s_inputs_c_0.x Clamp_N_M1_1.iovss sg13_hv_nmos ad=2.04p pd=12.68u as=2.04p ps=12.68u w=6u l=6u
X197 DCNDiode_0.guard d2s_block_0.d2s_casc_p_c_0.vbpc DCNDiode_0.guard DCNDiode_0.guard sg13_hv_pmos ad=0.34p pd=2.68u as=0 ps=0 w=1u l=4u
X198 d2s_block_0.d2s_inputs_c_0.sa_A a_3362_18030# Clamp_N_M1_1.iovss rhigh l=12.65u w=0.5u
X199 DCNDiode_0.guard d2s_cma_0.a pad DCNDiode_0.guard sg13_hv_pmos ad=2.1312p pd=7.3u as=3.9294p ps=7.84u w=6.66u l=0.6u
X200 d2s_block_0.bias_tree_pd_0.bias_tree_swp_0.ni d2s_block_0.en_3v3_b Clamp_N_M1_1.iovss Clamp_N_M1_1.iovss sg13_hv_nmos ad=0.19p pd=1.38u as=0.34p ps=2.68u w=1u l=0.45u
X201 d2s_block_0.d2s_loads_c_0.l2 d2s_block_0.d2s_ab_n_c_0.vabn d2s_block_0.d2s_ab_p_c_0.l1 Clamp_N_M1_1.iovss sg13_hv_nmos ad=1.496p pd=9.48u as=1.496p ps=9.48u w=4.4u l=1u
X202 Clamp_N_M1_1.iovss Clamp_N_M1_wiring_0.b pad Clamp_N_M1_1.iovss sg13_hv_nmos ad=1.408p pd=5.04u as=2.596p ps=5.58u w=4.4u l=1u
X203 pad d2s_cma_0.a DCNDiode_0.guard DCNDiode_0.guard sg13_hv_pmos ad=3.9294p pd=7.84u as=2.1312p ps=7.3u w=6.66u l=0.6u
X204 Clamp_N_M1_1.iovss Clamp_N_M1_wiring_0.b pad Clamp_N_M1_1.iovss sg13_hv_nmos ad=1.408p pd=5.04u as=2.596p ps=5.58u w=4.4u l=1u
X205 pad d2s_cma_0.a DCNDiode_0.guard DCNDiode_0.guard sg13_hv_pmos ad=3.9294p pd=7.84u as=2.1312p ps=7.3u w=6.66u l=0.6u
X206 pad Clamp_N_M1_wiring_0.b Clamp_N_M1_1.iovss Clamp_N_M1_1.iovss sg13_hv_nmos ad=3.256p pd=10.28u as=1.408p ps=5.04u w=4.4u l=1u
X207 pad Clamp_N_M1_wiring_0.b Clamp_N_M1_1.iovss Clamp_N_M1_1.iovss sg13_hv_nmos ad=2.596p pd=5.58u as=1.408p ps=5.04u w=4.4u l=1u
X208 pad d2s_cma_0.a DCNDiode_0.guard DCNDiode_0.guard sg13_hv_pmos ad=3.9294p pd=7.84u as=2.1312p ps=7.3u w=6.66u l=0.6u
X209 pad d2s_cma_0.a DCNDiode_0.guard DCNDiode_0.guard sg13_hv_pmos ad=3.9294p pd=7.84u as=2.1312p ps=7.3u w=6.66u l=0.6u
X210 pad d2s_cma_0.a DCNDiode_0.guard DCNDiode_0.guard sg13_hv_pmos ad=3.9294p pd=7.84u as=2.1312p ps=7.3u w=6.66u l=0.6u
X211 DCNDiode_0.guard d2s_cma_0.a pad DCNDiode_0.guard sg13_hv_pmos ad=2.1312p pd=7.3u as=3.9294p ps=7.84u w=6.66u l=0.6u
X212 d2s_block_0.d2s_ab_n_c_0.vabn d2s_block_0.d2s_tails_c_0.vbp DCNDiode_0.guard DCNDiode_0.guard sg13_hv_pmos ad=1.7p pd=10.68u as=1.7p ps=10.68u w=5u l=6u
X213 pad d2s_cma_0.a DCNDiode_0.guard DCNDiode_0.guard sg13_hv_pmos ad=3.9294p pd=7.84u as=2.1312p ps=7.3u w=6.66u l=0.6u
X214 Clamp_P_M1_wiring_0.dabp DCNDiode_0.guard DCNDiode_0.guard DCNDiode_0.guard sg13_hv_pmos ad=3.9294p pd=7.84u as=2.1312p ps=7.3u w=6.66u l=0.6u
X215 DCNDiode_0.guard d2s_cma_0.a pad DCNDiode_0.guard sg13_hv_pmos ad=2.1312p pd=7.3u as=3.9294p ps=7.84u w=6.66u l=0.6u
X216 d2s_block_0.d2s_loads_c_0.pr d2s_block_0.d2s_loads_c_0.l2 DCNDiode_0.guard DCNDiode_0.guard sg13_hv_pmos ad=2.04p pd=12.68u as=2.04p ps=12.68u w=6u l=4u
X217 DCNDiode_0.guard d2s_cma_0.a pad DCNDiode_0.guard sg13_hv_pmos ad=2.1312p pd=7.3u as=3.9294p ps=7.84u w=6.66u l=0.6u
X218 DCNDiode_0.guard d2s_cma_0.a pad DCNDiode_0.guard sg13_hv_pmos ad=2.1312p pd=7.3u as=3.9294p ps=7.84u w=6.66u l=0.6u
X219 d2s_block_0.d2s_inputs_c_0.x d2s_block_0.vinn d2s_block_0.d2s_inputs_c_0.sb_B d2s_block_0.d2s_inputs_c_0.sb_B sg13_hv_pmos ad=1.9p pd=10.38u as=3.4p ps=20.68u w=10u l=1u
X220 d2s_block_0.d2s_inputs_c_0.sb_C2 a_4858_18030# Clamp_N_M1_1.iovss rhigh l=12.65u w=0.5u
X221 d2s_block_0.d2s_loads_c_0.l2 d2s_block_0.d2s_casc_p_c_0.vbpc d2s_block_0.d2s_loads_c_0.pl DCNDiode_0.guard sg13_hv_pmos ad=5.1p pd=30.68u as=5.1p ps=30.68u w=15u l=3u
X222 a_4178_20646# a_4586_18030# Clamp_N_M1_1.iovss rhigh l=12.65u w=0.5u
X223 pad d2s_cma_0.a DCNDiode_0.guard DCNDiode_0.guard sg13_hv_pmos ad=3.9294p pd=7.84u as=2.1312p ps=7.3u w=6.66u l=0.6u
X224 pad Clamp_N_M1_wiring_0.b Clamp_N_M1_1.iovss Clamp_N_M1_1.iovss sg13_hv_nmos ad=2.596p pd=5.58u as=1.408p ps=5.04u w=4.4u l=1u
X225 pad Clamp_N_M1_wiring_0.b Clamp_N_M1_1.iovss Clamp_N_M1_1.iovss sg13_hv_nmos ad=2.596p pd=5.58u as=1.408p ps=5.04u w=4.4u l=1u
X226 a_4178_20646# a_3498_18030# Clamp_N_M1_1.iovss rhigh l=12.65u w=0.5u
X227 DCNDiode_0.guard d2s_cma_0.a pad DCNDiode_0.guard sg13_hv_pmos ad=2.1312p pd=7.3u as=3.9294p ps=7.84u w=6.66u l=0.6u
X228 pad Clamp_N_M1_wiring_0.b Clamp_N_M1_1.iovss Clamp_N_M1_1.iovss sg13_hv_nmos ad=2.596p pd=5.58u as=1.408p ps=5.04u w=4.4u l=1u
X229 d2s_block_0.d2s_inputs_c_0.x pad d2s_block_0.d2s_inputs_c_0.sb_C1 d2s_block_0.d2s_inputs_c_0.sb_C1 sg13_hv_pmos ad=1.9p pd=10.38u as=3.4p ps=20.68u w=10u l=1u
X230 DCNDiode_0.guard d2s_block_0.d2s_tails_c_0.vbp d2s_block_0.d2s_inputs_c_0.sa_A DCNDiode_0.guard sg13_hv_pmos ad=1.7p pd=10.68u as=1.7p ps=10.68u w=5u l=6u
X231 pad d2s_cma_0.a DCNDiode_0.guard DCNDiode_0.guard sg13_hv_pmos ad=3.9294p pd=7.84u as=2.1312p ps=7.3u w=6.66u l=0.6u
X232 d2s_block_0.d2s_casc_n_c_0.vbnc d2s_block_0.d2s_tails_c_0.vbp DCNDiode_0.guard DCNDiode_0.guard sg13_hv_pmos ad=0.68p pd=4.68u as=0.68p ps=4.68u w=2u l=6u
X233 d2s_block_0.d2s_inputs_c_0.sa_C2 d2s_block_0.vref d2s_block_0.d2s_inputs_c_0.y d2s_block_0.d2s_inputs_c_0.sa_C2 sg13_hv_pmos ad=3.4p pd=20.68u as=1.9p ps=10.38u w=10u l=1u
X234 pad d2s_cma_0.a DCNDiode_0.guard DCNDiode_0.guard sg13_hv_pmos ad=3.9294p pd=7.84u as=2.1312p ps=7.3u w=6.66u l=0.6u
X235 DCNDiode_0.guard d2s_cma_0.a pad DCNDiode_0.guard sg13_hv_pmos ad=2.1312p pd=7.3u as=3.9294p ps=7.84u w=6.66u l=0.6u
X236 Clamp_N_M1_1.iovss Clamp_N_M1_wiring_0.b pad Clamp_N_M1_1.iovss sg13_hv_nmos ad=1.408p pd=5.04u as=2.596p ps=5.58u w=4.4u l=1u
X237 Clamp_N_M1_1.iovss Clamp_N_M1_wiring_0.b pad Clamp_N_M1_1.iovss sg13_hv_nmos ad=1.408p pd=5.04u as=2.596p ps=5.58u w=4.4u l=1u
X238 Clamp_N_M1_1.iovss Clamp_N_M1_wiring_0.b pad Clamp_N_M1_1.iovss sg13_hv_nmos ad=1.408p pd=5.04u as=2.596p ps=5.58u w=4.4u l=1u
X239 d2s_block_0.d2s_tails_c_0.vbp d2s_block_0.bias_tree_pd_0.bias_tree_swp_0.ni Clamp_N_M1_1.iovss Clamp_N_M1_1.iovss sg13_hv_nmos ad=2.04p pd=12.68u as=2.04p ps=12.68u w=6u l=6u
X240 d2s_block_0.d2s_loads_c_0.pr d2s_block_0.d2s_loads_c_0.l2 DCNDiode_0.guard DCNDiode_0.guard sg13_hv_pmos ad=2.04p pd=12.68u as=2.04p ps=12.68u w=6u l=4u
X241 pad d2s_cma_0.a DCNDiode_0.guard DCNDiode_0.guard sg13_hv_pmos ad=3.9294p pd=7.84u as=2.1312p ps=7.3u w=6.66u l=0.6u
X242 pad Clamp_N_M1_wiring_0.b Clamp_N_M1_1.iovss Clamp_N_M1_1.iovss sg13_hv_nmos ad=2.596p pd=5.58u as=1.408p ps=5.04u w=4.4u l=1u
X243 Clamp_N_M1_1.iovss d2s_block_0.sinks_6x6_c_0.vbn d2s_block_0.d2s_inputs_c_0.x Clamp_N_M1_1.iovss sg13_hv_nmos ad=2.04p pd=12.68u as=2.04p ps=12.68u w=6u l=6u
X244 pad d2s_cma_0.a DCNDiode_0.guard DCNDiode_0.guard sg13_hv_pmos ad=3.9294p pd=7.84u as=2.1312p ps=7.3u w=6.66u l=0.6u
X245 pad Clamp_N_M1_wiring_0.b Clamp_N_M1_1.iovss Clamp_N_M1_1.iovss sg13_hv_nmos ad=2.596p pd=5.58u as=1.408p ps=5.04u w=4.4u l=1u
X246 pad d2s_cma_0.a DCNDiode_0.guard DCNDiode_0.guard sg13_hv_pmos ad=3.9294p pd=7.84u as=2.1312p ps=7.3u w=6.66u l=0.6u
X247 d2s_block_0.sinks_6x6_c_0.vbn d2s_block_0.d2s_tails_c_0.vbp DCNDiode_0.guard DCNDiode_0.guard sg13_hv_pmos ad=1.7p pd=10.68u as=1.7p ps=10.68u w=5u l=6u
X248 pad d2s_cma_0.a DCNDiode_0.guard DCNDiode_0.guard sg13_hv_pmos ad=3.9294p pd=7.84u as=2.1312p ps=7.3u w=6.66u l=0.6u
X249 Clamp_N_M1_1.iovss Clamp_N_M1_wiring_0.b pad Clamp_N_M1_1.iovss sg13_hv_nmos ad=1.408p pd=5.04u as=2.596p ps=5.58u w=4.4u l=1u
X250 d2s_block_0.d2s_inputs_c_0.x d2s_block_0.sinks_6x6_c_0.vbn Clamp_N_M1_1.iovss Clamp_N_M1_1.iovss sg13_hv_nmos ad=2.04p pd=12.68u as=2.04p ps=12.68u w=6u l=6u
X251 Clamp_N_M1_1.iovss d2s_block_0.sinks_6x6_c_0.vbn d2s_block_0.d2s_inputs_c_0.y Clamp_N_M1_1.iovss sg13_hv_nmos ad=2.04p pd=12.68u as=2.04p ps=12.68u w=6u l=6u
X252 DCNDiode_0.guard d2s_cma_0.a pad DCNDiode_0.guard sg13_hv_pmos ad=2.1312p pd=7.3u as=3.9294p ps=7.84u w=6.66u l=0.6u
X253 Clamp_N_M1_1.iovss Clamp_N_M1_wiring_0.b pad Clamp_N_M1_1.iovss sg13_hv_nmos ad=1.408p pd=5.04u as=2.596p ps=5.58u w=4.4u l=1u
X254 Clamp_N_M1_1.iovss Clamp_N_M1_wiring_0.dabn Clamp_N_M1_wiring_0.dabn Clamp_N_M1_1.iovss sg13_hv_nmos ad=1.408p pd=5.04u as=2.596p ps=5.58u w=4.4u l=1u
X255 pad Clamp_N_M1_wiring_0.b Clamp_N_M1_1.iovss Clamp_N_M1_1.iovss sg13_hv_nmos ad=2.596p pd=5.58u as=2.068p ps=9.74u w=4.4u l=1u
X256 DCNDiode_0.guard DCNDiode_0.guard DCNDiode_0.guard DCNDiode_0.guard sg13_hv_pmos ad=3.4p pd=20.68u as=0 ps=0 w=10u l=1u
X257 DCNDiode_0.guard d2s_cma_0.a pad DCNDiode_0.guard sg13_hv_pmos ad=2.1312p pd=7.3u as=3.9294p ps=7.84u w=6.66u l=0.6u
X258 pad Clamp_N_M1_wiring_0.b Clamp_N_M1_1.iovss Clamp_N_M1_1.iovss sg13_hv_nmos ad=2.596p pd=5.58u as=1.408p ps=5.04u w=4.4u l=1u
X259 pad Clamp_N_M1_wiring_0.b Clamp_N_M1_1.iovss Clamp_N_M1_1.iovss sg13_hv_nmos ad=2.596p pd=5.58u as=1.408p ps=5.04u w=4.4u l=1u
X260 pad d2s_cma_0.a DCNDiode_0.guard DCNDiode_0.guard sg13_hv_pmos ad=4.9284p pd=14.8u as=2.1312p ps=7.3u w=6.66u l=0.6u
X261 d2s_block_0.d2s_inputs_c_0.y d2s_block_0.sinks_6x6_c_0.vbn Clamp_N_M1_1.iovss Clamp_N_M1_1.iovss sg13_hv_nmos ad=2.04p pd=12.68u as=2.04p ps=12.68u w=6u l=6u
X262 DCNDiode_0.guard d2s_cma_0.a pad DCNDiode_0.guard sg13_hv_pmos ad=2.1312p pd=7.3u as=3.9294p ps=7.84u w=6.66u l=0.6u
X263 d2s_block_0.bias_tree_pd_0.bias_tree_swp_0.ni d2s_block_0.bias_tree_pd_0.bias_tree_swp_0.ni Clamp_N_M1_1.iovss Clamp_N_M1_1.iovss sg13_hv_nmos ad=2.04p pd=12.68u as=2.04p ps=12.68u w=6u l=6u
X264 d2s_block_0.d2s_inputs_c_0.sb_C2 pad d2s_block_0.d2s_inputs_c_0.x d2s_block_0.d2s_inputs_c_0.sb_C2 sg13_hv_pmos ad=3.4p pd=20.68u as=1.9p ps=10.38u w=10u l=1u
X265 pad d2s_cma_0.a DCNDiode_0.guard DCNDiode_0.guard sg13_hv_pmos ad=3.9294p pd=7.84u as=2.1312p ps=7.3u w=6.66u l=0.6u
X266 Clamp_N_M1_1.iovss Clamp_N_M1_wiring_0.b pad Clamp_N_M1_1.iovss sg13_hv_nmos ad=1.408p pd=5.04u as=2.596p ps=5.58u w=4.4u l=1u
X267 DCNDiode_0.guard d2s_cma_0.a pad DCNDiode_0.guard sg13_hv_pmos ad=2.1312p pd=7.3u as=3.9294p ps=7.84u w=6.66u l=0.6u
X268 Clamp_N_M1_1.iovss Clamp_N_M1_wiring_0.b pad Clamp_N_M1_1.iovss sg13_hv_nmos ad=1.408p pd=5.04u as=2.596p ps=5.58u w=4.4u l=1u
X269 DCNDiode_0.guard d2s_cma_0.a pad DCNDiode_0.guard sg13_hv_pmos ad=2.1312p pd=7.3u as=3.9294p ps=7.84u w=6.66u l=0.6u
X270 pad Clamp_N_M1_wiring_0.b Clamp_N_M1_1.iovss Clamp_N_M1_1.iovss sg13_hv_nmos ad=2.596p pd=5.58u as=1.408p ps=5.04u w=4.4u l=1u
C0 d2s_block_0.d2s_tails_c_0.vbp d2s_block_0.d2s_inputs_c_0.sa_C1 0.82553f
C1 a_3906_18116# a_3770_18116# 0.63642f
C2 d2s_block_0.d2s_loads_c_0.pl d2s_block_0.d2s_loads_c_0.l2 3.46591f
C3 d2s_block_0.d2s_ab_p_c_0.l1 d2s_block_0.en_3v3 0.13629f
C4 d2s_block_0.vinn d2s_block_0.d2s_inputs_c_0.sb_C1 0.02259f
C5 d2s_block_0.d2s_ab_p_c_0.vabp d2s_block_0.d2s_ab_n_c_0.vabn 0.05997f
C6 d2s_block_0.vinp d2s_block_0.d2s_ab_n_c_0.vabn 0.02052f
C7 TopLayersTo4_0.vdd d2s_block_0.d2s_ab_n_c_0.vabn 1.00253f
C8 Clamp_N_M1_wiring_0.b d2s_block_0.en_3v3 0.0322f
C9 a_4178_18116# a_4178_20646# 0.01887f
C10 d2s_block_0.d2s_inputs_c_0.sa_B a_3498_18116# 0.02712f
C11 a_3498_18030# a_3362_18030# 0.20168f
C12 a_5402_18116# a_5538_18116# 0.63642f
C13 d2s_block_0.d2s_tails_c_0.vbp d2s_block_0.d2s_inputs_c_0.y 0.02745f
C14 d2s_block_0.en_3v3_b d2s_block_0.d2s_inputs_c_0.x 0.19792f
C15 d2s_block_0.sinks_6x6_c_0.vbn d2s_block_0.d2s_inputs_c_0.x 3.18788f
C16 DCNDiode_0.guard a_4450_18030# 0.10185f
C17 d2s_block_0.d2s_tails_c_0.vbp d2s_block_0.d2s_inputs_c_0.sa_A 0.82427f
C18 d2s_block_0.d2s_inputs_c_0.sb_A d2s_block_0.d2s_ab_p_c_0.vabp 0.01477f
C19 d2s_block_0.d2s_inputs_c_0.sa_C2 d2s_block_0.d2s_inputs_c_0.sb_A 0.14455f
C20 TopLayersTo4_0.vdd d2s_block_0.d2s_inputs_c_0.sb_A 0.01342f
C21 a_3906_18116# a_3770_18030# 0.01899f
C22 d2s_block_0.d2s_tails_c_0.vbp d2s_block_0.d2s_inputs_c_0.sb_C2 0.83011f
C23 DCNDiode_0.guard a_3498_18116# 0.10901f
C24 d2s_block_0.d2s_tails_c_0.vbp d2s_block_0.d2s_casc_p_c_0.vbpc 0.13974f
C25 DCNDiode_0.guard a_4858_18030# 0.0252f
C26 d2s_block_0.d2s_ab_p_c_0.vabp a_4450_18116# 0.01456f
C27 a_3498_18030# d2s_block_0.d2s_loads_c_0.l2 0.01885f
C28 a_5402_18116# a_4450_18030# 0.01869f
C29 d2s_block_0.d2s_ab_p_c_0.vabp d2s_block_0.en_3v3 0.21689f
C30 d2s_block_0.d2s_tails_c_0.vbp d2s_block_0.vref 0.01759f
C31 d2s_block_0.d2s_ab_p_c_0.vabp a_5266_18116# 0.01705f
C32 d2s_block_0.vinp d2s_block_0.en_3v3 0.03543f
C33 d2s_block_0.en_3v3_b d2s_block_0.d2s_casc_n_c_0.vbnc 0.05294f
C34 d2s_block_0.sinks_6x6_c_0.vbn d2s_block_0.d2s_casc_n_c_0.vbnc 0.56977f
C35 d2s_block_0.d2s_ab_n_c_0.vabn d2s_block_0.d2s_inputs_c_0.x 0.02745f
C36 TopLayersTo4_0.vdd d2s_block_0.en_3v3 1.50492f
C37 d2s_block_0.d2s_tails_c_0.vbp d2s_block_0.d2s_inputs_c_0.sa_B 0.91301f
C38 d2s_block_0.d2s_inputs_c_0.sb_B d2s_block_0.d2s_inputs_c_0.sa_C1 0.27686f
C39 d2s_block_0.d2s_casc_p_c_0.vbpc d2s_block_0.d2s_loads_c_0.l2 1.68876f
C40 a_4586_18030# a_4994_18116# 0.01247f
C41 d2s_block_0.d2s_inputs_c_0.sa_C1 a_3634_18116# 0.02699f
C42 d2s_block_0.d2s_inputs_c_0.sb_A d2s_block_0.d2s_inputs_c_0.x 0.59841f
C43 DCNDiode_0.guard a_3362_18030# 0.10181f
C44 d2s_block_0.d2s_tails_c_0.vbp DCNDiode_0.guard 61.1157f
C45 d2s_block_0.d2s_ab_p_c_0.vabp a_4314_18116# 0.01489f
C46 d2s_block_0.bias_tree_pd_0.bias_tree_swp_0.ni d2s_block_0.d2s_ab_p_c_0.vabp 0.60475f
C47 d2s_block_0.d2s_casc_n_c_0.vbnc d2s_block_0.d2s_ab_n_c_0.vabn 7.7331f
C48 d2s_block_0.d2s_tails_c_0.vbp d2s_block_0.vinn 0.02485f
C49 TopLayersTo4_0.vdd d2s_block_0.bias_tree_pd_0.bias_tree_swp_0.ni 4.61763f
C50 d2s_block_0.sinks_6x6_c_0.vbn d2s_block_0.en_3v3_b 0.8922f
C51 TopLayersTo4_0.vdd d2s_block_0.iref 1.06751f
C52 d2s_block_0.d2s_inputs_c_0.sb_B d2s_block_0.d2s_inputs_c_0.sa_A 0.92466f
C53 a_3498_18030# a_3634_18116# 0.01247f
C54 a_4178_20646# a_3906_20646# 0.30865f
C55 a_3906_18116# a_4042_18116# 0.63642f
C56 d2s_block_0.d2s_ab_p_c_0.vabp a_3362_18116# 0.03878f
C57 d2s_block_0.en_3v3 d2s_block_0.d2s_inputs_c_0.x 0.03553f
C58 d2s_block_0.d2s_inputs_c_0.sb_B d2s_block_0.d2s_inputs_c_0.sb_C2 0.23356f
C59 d2s_block_0.d2s_casc_p_c_0.vbpc d2s_block_0.d2s_loads_c_0.pl 1.36273f
C60 d2s_block_0.d2s_inputs_c_0.sa_C1 d2s_block_0.d2s_inputs_c_0.y 0.60094f
C61 DCNDiode_0.guard d2s_block_0.d2s_loads_c_0.l2 28.6877f
C62 DCNDiode_0.guard Clamp_P_M1_wiring_0.dabp 6.64089f
C63 d2s_block_0.d2s_inputs_c_0.sa_A d2s_block_0.d2s_inputs_c_0.sa_C1 0.30274f
C64 a_4450_18116# a_4314_20646# 0.01899f
C65 d2s_block_0.d2s_inputs_c_0.sa_C1 d2s_block_0.d2s_inputs_c_0.sb_C2 0.89202f
C66 d2s_block_0.en_3v3_b d2s_block_0.d2s_ab_n_c_0.vabn 0.27563f
C67 d2s_block_0.sinks_6x6_c_0.vbn d2s_block_0.d2s_ab_n_c_0.vabn 7.54492f
C68 d2s_block_0.d2s_inputs_c_0.sb_B d2s_block_0.d2s_inputs_c_0.sa_B 0.04161f
C69 d2s_block_0.en_3v3 d2s_block_0.d2s_casc_n_c_0.vbnc 0.60167f
C70 a_3634_18030# a_3362_18030# 0.30865f
C71 d2s_block_0.d2s_inputs_c_0.sa_A d2s_block_0.d2s_inputs_c_0.y 0.78589f
C72 d2s_block_0.d2s_inputs_c_0.sa_C1 d2s_block_0.vref 2.73547f
C73 d2s_block_0.d2s_inputs_c_0.sa_B d2s_block_0.d2s_inputs_c_0.sa_C1 0.23194f
C74 DCNDiode_0.guard d2s_block_0.d2s_loads_c_0.pl 3.57012f
C75 d2s_block_0.d2s_inputs_c_0.sb_B DCNDiode_0.guard 2.37092f
C76 d2s_block_0.d2s_inputs_c_0.sb_C2 d2s_block_0.d2s_inputs_c_0.y 0.3008f
C77 a_4586_18116# a_4042_20646# 0.01247f
C78 DCNDiode_0.guard a_3634_18116# 0.10945f
C79 d2s_block_0.d2s_inputs_c_0.sa_A d2s_block_0.d2s_inputs_c_0.sb_C2 0.2382f
C80 d2s_block_0.d2s_inputs_c_0.sb_B d2s_block_0.vinn 2.69548f
C81 a_4314_18116# a_4314_20646# 0.01899f
C82 DCNDiode_0.guard a_5130_18116# 0.10901f
C83 DCNDiode_0.guard a_4586_18116# 0.10901f
C84 d2s_block_0.vref d2s_block_0.d2s_inputs_c_0.y 3.42557f
C85 DCNDiode_0.guard d2s_block_0.d2s_inputs_c_0.sa_C1 2.30566f
C86 d2s_block_0.d2s_ab_p_c_0.vabp a_5538_18116# 0.04419f
C87 d2s_block_0.sinks_6x6_c_0.vbn d2s_block_0.en_3v3 0.0356f
C88 d2s_block_0.en_3v3_b d2s_block_0.en_3v3 12.9155f
C89 d2s_block_0.d2s_inputs_c_0.sa_B d2s_block_0.d2s_inputs_c_0.y 0.86482f
C90 d2s_block_0.d2s_inputs_c_0.sa_A d2s_block_0.vref 0.04103f
C91 d2s_block_0.d2s_inputs_c_0.sa_C2 d2s_block_0.d2s_inputs_c_0.sb_C1 0.99812f
C92 TopLayersTo4_0.vdd d2s_block_0.d2s_inputs_c_0.sb_C1 0.10429f
C93 d2s_block_0.d2s_inputs_c_0.sa_B d2s_block_0.d2s_inputs_c_0.sa_A 0.9806f
C94 d2s_block_0.d2s_inputs_c_0.sb_A d2s_block_0.d2s_ab_n_c_0.vabn 0.01659f
C95 d2s_block_0.d2s_inputs_c_0.sb_C2 d2s_block_0.vref 0.25617f
C96 a_4858_18030# a_4858_18116# 0.01899f
C97 a_4586_18030# a_5266_18116# 0.02961f
C98 a_4722_18116# a_4586_18116# 0.63642f
C99 d2s_block_0.d2s_inputs_c_0.sa_B d2s_block_0.d2s_inputs_c_0.sb_C2 0.04093f
C100 d2s_block_0.d2s_inputs_c_0.sa_A a_4042_20646# 0.01166f
C101 DCNDiode_0.guard d2s_block_0.d2s_inputs_c_0.y 2.45683f
C102 DCNDiode_0.guard a_3498_18030# 0.37258f
C103 d2s_cma_0.a d2s_block_0.d2s_loads_c_0.l2 0.04694f
C104 Clamp_P_M1_wiring_0.dabp d2s_cma_0.a 0.17661f
C105 DCNDiode_0.guard d2s_block_0.d2s_inputs_c_0.sa_A 1.94226f
C106 d2s_block_0.d2s_inputs_c_0.sb_C2 a_4042_20646# 0.02041f
C107 d2s_block_0.d2s_ab_p_c_0.vabp a_4450_18030# 0.0391f
C108 d2s_block_0.vinn d2s_block_0.d2s_inputs_c_0.y 0.22169f
C109 d2s_block_0.d2s_inputs_c_0.sa_B d2s_block_0.vref 3.12749f
C110 d2s_block_0.en_3v3 d2s_block_0.d2s_ab_n_c_0.vabn 1.42904f
C111 d2s_block_0.bias_tree_pd_0.bias_tree_swp_0.ni d2s_block_0.en_3v3_b 0.16855f
C112 d2s_block_0.iref d2s_block_0.en_3v3_b 0.25824f
C113 d2s_block_0.d2s_inputs_c_0.sa_A d2s_block_0.vinn 0.44412f
C114 DCNDiode_0.guard d2s_block_0.d2s_inputs_c_0.sb_C2 1.66185f
C115 a_3634_18030# a_3634_18116# 0.01887f
C116 a_4178_20646# a_4314_20646# 0.24073f
C117 DCNDiode_0.guard d2s_block_0.d2s_casc_p_c_0.vbpc 25.4717f
C118 d2s_block_0.d2s_ab_p_c_0.vabp a_3498_18116# 0.02464f
C119 d2s_block_0.d2s_inputs_c_0.x d2s_block_0.d2s_inputs_c_0.sb_C1 0.74718f
C120 d2s_block_0.d2s_inputs_c_0.sa_B a_4042_20646# 0.0111f
C121 d2s_block_0.d2s_inputs_c_0.sb_C2 d2s_block_0.vinn 0.01751f
C122 DCNDiode_0.guard d2s_block_0.vref 0.11269f
C123 d2s_block_0.d2s_inputs_c_0.sa_B DCNDiode_0.guard 2.83123f
C124 DCNDiode_0.guard a_3226_18116# 0.18891f
C125 d2s_block_0.vinn d2s_block_0.vref 4.95083f
C126 d2s_block_0.d2s_ab_p_c_0.l1 d2s_block_0.d2s_loads_c_0.l2 0.65122f
C127 a_4722_18030# a_4586_18030# 0.18033f
C128 d2s_block_0.d2s_inputs_c_0.sa_B d2s_block_0.vinn 0.04518f
C129 DCNDiode_0.guard a_4042_20646# 0.43318f
C130 Clamp_N_M1_wiring_0.b d2s_block_0.d2s_loads_c_0.l2 0.27487f
C131 a_4178_18116# a_3498_18030# 0.02961f
C132 Clamp_N_M1_wiring_0.b Clamp_P_M1_wiring_0.dabp 0.06406f
C133 d2s_block_0.d2s_loads_c_0.l2 d2s_block_0.d2s_loads_c_0.pr 1.77955f
C134 Clamp_N_M1_wiring_0.dabn Clamp_P_M1_wiring_0.dabp 1.09608f
C135 pad d2s_block_0.d2s_inputs_c_0.sb_C1 2.73547f
C136 a_3634_18030# a_3498_18030# 0.18033f
C137 d2s_block_0.d2s_ab_p_c_0.vabp a_3362_18030# 0.03882f
C138 d2s_block_0.d2s_tails_c_0.vbp d2s_block_0.d2s_ab_p_c_0.vabp 3.39401f
C139 d2s_block_0.d2s_tails_c_0.vbp d2s_block_0.vinp 0.02234f
C140 d2s_block_0.d2s_inputs_c_0.sa_C2 d2s_block_0.d2s_tails_c_0.vbp 0.82525f
C141 TopLayersTo4_0.vdd d2s_block_0.d2s_tails_c_0.vbp 4.17122f
C142 DCNDiode_0.guard d2s_block_0.vinn 0.24317f
C143 a_4722_18116# a_4042_20646# 0.02961f
C144 a_4314_18116# a_4450_18116# 0.63642f
C145 DCNDiode_0.guard a_5402_18116# 0.10901f
C146 DCNDiode_0.guard a_4722_18116# 0.10901f
C147 d2s_block_0.d2s_ab_p_c_0.vabp d2s_block_0.d2s_loads_c_0.l2 3.25139f
C148 d2s_block_0.bias_tree_pd_0.bias_tree_swp_0.ni d2s_block_0.en_3v3 0.12793f
C149 d2s_block_0.d2s_ab_p_c_0.vabp Clamp_P_M1_wiring_0.dabp 0.35017f
C150 d2s_block_0.iref d2s_block_0.en_3v3 0.543f
C151 d2s_block_0.d2s_loads_c_0.pl d2s_block_0.d2s_loads_c_0.pr 7.00095f
C152 TopLayersTo4_0.vdd d2s_block_0.d2s_loads_c_0.l2 0.11357f
C153 a_4042_20646# a_4178_18116# 0.01247f
C154 d2s_block_0.d2s_casc_p_c_0.vbpc d2s_cma_0.a 1.15446f
C155 a_4858_18030# a_4994_18116# 0.01899f
C156 d2s_block_0.d2s_tails_c_0.vbp d2s_block_0.d2s_inputs_c_0.x 0.02756f
C157 DCNDiode_0.guard a_4178_18116# 0.10901f
C158 DCNDiode_0.guard a_3634_18030# 0.03742f
C159 d2s_block_0.d2s_ab_p_c_0.vabp d2s_block_0.d2s_loads_c_0.pl 0.07782f
C160 d2s_block_0.bias_tree_pd_0.bias_tree_swp_0.ni d2s_block_0.iref 0.35563f
C161 d2s_block_0.d2s_inputs_c_0.sb_B d2s_block_0.d2s_ab_p_c_0.vabp 0.07555f
C162 TopLayersTo4_0.vdd d2s_block_0.d2s_loads_c_0.pl 0.07658f
C163 d2s_block_0.d2s_inputs_c_0.sb_B d2s_block_0.d2s_inputs_c_0.sa_C2 0.73012f
C164 d2s_block_0.d2s_inputs_c_0.sb_B TopLayersTo4_0.vdd 0.0138f
C165 d2s_block_0.d2s_ab_p_c_0.vabp a_3634_18116# 0.01721f
C166 Clamp_N_M1_wiring_0.b d2s_block_0.d2s_inputs_c_0.y 0.39645f
C167 a_4586_18030# a_4450_18030# 0.20168f
C168 d2s_block_0.d2s_ab_p_c_0.vabp a_5130_18116# 0.01155f
C169 d2s_block_0.d2s_tails_c_0.vbp d2s_block_0.d2s_casc_n_c_0.vbnc 0.17608f
C170 DCNDiode_0.guard d2s_cma_0.a 0.11793p
C171 d2s_block_0.d2s_inputs_c_0.sb_A d2s_block_0.d2s_inputs_c_0.sb_C1 0.21942f
C172 d2s_block_0.d2s_ab_p_c_0.vabp d2s_block_0.d2s_inputs_c_0.sa_C1 0.01949f
C173 d2s_block_0.d2s_inputs_c_0.sb_C2 a_3906_20646# 0.07072f
C174 d2s_block_0.d2s_inputs_c_0.sa_C2 d2s_block_0.d2s_inputs_c_0.sa_C1 0.43187f
C175 TopLayersTo4_0.vdd d2s_block_0.d2s_inputs_c_0.sa_C1 0.0135f
C176 Clamp_N_M1_wiring_0.b d2s_block_0.d2s_casc_p_c_0.vbpc 0.10372f
C177 d2s_block_0.d2s_casc_p_c_0.vbpc d2s_block_0.d2s_loads_c_0.pr 1.82541f
C178 a_4858_18030# a_4586_18030# 0.0185f
C179 a_3634_18116# a_3770_18116# 0.63642f
C180 pad d2s_block_0.d2s_loads_c_0.l2 0.12382f
C181 d2s_block_0.d2s_inputs_c_0.sa_B a_3906_20646# 0.14879f
C182 d2s_block_0.d2s_ab_p_c_0.vabp a_3498_18030# 0.09885f
C183 d2s_block_0.vinp d2s_block_0.d2s_inputs_c_0.y 0.58119f
C184 d2s_block_0.d2s_inputs_c_0.sb_B d2s_block_0.d2s_inputs_c_0.x 0.621f
C185 d2s_block_0.d2s_inputs_c_0.sa_C2 d2s_block_0.d2s_inputs_c_0.y 0.59841f
C186 TopLayersTo4_0.vdd d2s_block_0.d2s_inputs_c_0.y 0.35192f
C187 d2s_block_0.d2s_ab_p_c_0.vabp d2s_block_0.d2s_inputs_c_0.sa_A 0.03713f
C188 d2s_block_0.d2s_tails_c_0.vbp d2s_block_0.en_3v3_b 0.14332f
C189 d2s_block_0.sinks_6x6_c_0.vbn d2s_block_0.d2s_tails_c_0.vbp 7.57655f
C190 d2s_block_0.d2s_inputs_c_0.sa_A d2s_block_0.vinp 2.69624f
C191 a_4042_20646# a_3906_20646# 0.20168f
C192 d2s_block_0.d2s_inputs_c_0.sa_C2 d2s_block_0.d2s_inputs_c_0.sa_A 0.66656f
C193 DCNDiode_0.guard d2s_block_0.d2s_ab_p_c_0.l1 5.57688f
C194 TopLayersTo4_0.vdd d2s_block_0.d2s_inputs_c_0.sa_A 0.10408f
C195 d2s_block_0.d2s_ab_p_c_0.vabp d2s_block_0.d2s_casc_p_c_0.vbpc 10.1236f
C196 DCNDiode_0.guard a_3906_20646# 0.12852f
C197 d2s_block_0.d2s_inputs_c_0.sa_C2 d2s_block_0.d2s_inputs_c_0.sb_C2 0.36947f
C198 TopLayersTo4_0.vdd d2s_block_0.d2s_inputs_c_0.sb_C2 0.10447f
C199 Clamp_N_M1_wiring_0.b DCNDiode_0.guard 24.689f
C200 d2s_block_0.d2s_inputs_c_0.sa_C1 d2s_block_0.d2s_inputs_c_0.x 0.02259f
C201 DCNDiode_0.guard d2s_block_0.d2s_loads_c_0.pr 3.46424f
C202 TopLayersTo4_0.vdd d2s_block_0.d2s_casc_p_c_0.vbpc 2.14944f
C203 DCNDiode_0.guard Clamp_N_M1_wiring_0.dabn 5.11065f
C204 a_4450_18030# a_4450_18116# 0.01869f
C205 DCNDiode_0.guard a_4858_18116# 0.10901f
C206 a_3498_18030# a_3770_18116# 0.01247f
C207 d2s_block_0.vinp d2s_block_0.vref 5.24376f
C208 pad d2s_block_0.d2s_loads_c_0.pl 0.22107f
C209 d2s_block_0.d2s_inputs_c_0.sa_C2 d2s_block_0.vref 2.77802f
C210 TopLayersTo4_0.vdd d2s_block_0.vref 0.67531f
C211 d2s_block_0.d2s_ab_p_c_0.vabp a_3226_18116# 0.06014f
C212 d2s_block_0.d2s_tails_c_0.vbp d2s_block_0.d2s_ab_n_c_0.vabn 0.76685f
C213 d2s_block_0.d2s_inputs_c_0.sa_C2 d2s_block_0.d2s_inputs_c_0.sa_B 0.36384f
C214 TopLayersTo4_0.vdd d2s_block_0.d2s_inputs_c_0.sa_B 0.10369f
C215 d2s_block_0.d2s_inputs_c_0.y d2s_block_0.d2s_inputs_c_0.x 15.7022f
C216 a_4586_18030# d2s_block_0.d2s_loads_c_0.l2 0.01885f
C217 a_5130_18116# a_4994_18116# 0.63642f
C218 a_4858_18116# a_4722_18116# 0.63642f
C219 d2s_block_0.d2s_inputs_c_0.sa_A d2s_block_0.d2s_inputs_c_0.x 0.12697f
C220 d2s_block_0.d2s_inputs_c_0.sa_C2 a_4042_20646# 0.02468f
C221 DCNDiode_0.guard d2s_block_0.d2s_ab_p_c_0.vabp 7.57038f
C222 DCNDiode_0.guard d2s_block_0.vinp 0.50056f
C223 d2s_block_0.d2s_tails_c_0.vbp d2s_block_0.d2s_inputs_c_0.sb_A 0.83915f
C224 d2s_block_0.d2s_inputs_c_0.sa_C2 DCNDiode_0.guard 2.1365f
C225 d2s_block_0.d2s_inputs_c_0.sb_C2 d2s_block_0.d2s_inputs_c_0.x 0.74797f
C226 TopLayersTo4_0.vdd DCNDiode_0.guard 1.85704f
C227 a_3498_18030# a_3770_18030# 0.0185f
C228 d2s_block_0.d2s_loads_c_0.l2 d2s_block_0.d2s_ab_n_c_0.vabn 1.10586f
C229 d2s_block_0.vinn d2s_block_0.vinp 0.6139f
C230 TopLayersTo4_0.vdd d2s_block_0.vinn 0.90607f
C231 d2s_block_0.vref d2s_block_0.d2s_inputs_c_0.x 0.7855f
C232 d2s_block_0.d2s_casc_n_c_0.vbnc d2s_block_0.d2s_inputs_c_0.y 1.84021f
C233 a_4722_18030# a_4450_18030# 0.30865f
C234 d2s_block_0.d2s_ab_p_c_0.vabp a_5402_18116# 0.0283f
C235 d2s_block_0.d2s_tails_c_0.vbp d2s_block_0.en_3v3 0.04348f
C236 d2s_block_0.d2s_inputs_c_0.sa_B d2s_block_0.d2s_inputs_c_0.x 0.13144f
C237 d2s_block_0.d2s_inputs_c_0.sa_A pad 0.07859f
C238 DCNDiode_0.guard a_3770_18116# 0.10901f
C239 a_3498_18116# a_3362_18116# 0.63642f
C240 d2s_block_0.d2s_ab_p_c_0.l1 d2s_cma_0.a 0.77442f
C241 d2s_block_0.d2s_inputs_c_0.sb_C2 pad 2.76453f
C242 d2s_block_0.d2s_inputs_c_0.sb_C2 a_4994_18116# 0.02699f
C243 a_5130_18116# a_4586_18030# 0.01247f
C244 a_4858_18030# a_4722_18030# 0.24073f
C245 d2s_block_0.d2s_casc_p_c_0.vbpc pad 0.50929f
C246 a_4586_18030# a_4586_18116# 0.02961f
C247 DCNDiode_0.guard d2s_block_0.d2s_inputs_c_0.x 2.10884f
C248 Clamp_N_M1_wiring_0.b d2s_cma_0.a 5.6398f
C249 d2s_cma_0.a d2s_block_0.d2s_loads_c_0.pr 0.2193f
C250 d2s_block_0.vref d2s_block_0.d2s_casc_n_c_0.vbnc 0.03614f
C251 Clamp_N_M1_wiring_0.dabn d2s_cma_0.a 0.10957f
C252 pad d2s_block_0.vref 0.07557f
C253 a_4314_18116# a_3362_18030# 0.01869f
C254 a_3906_18116# a_3498_18030# 0.01247f
C255 d2s_block_0.vinn d2s_block_0.d2s_inputs_c_0.x 0.72696f
C256 d2s_block_0.sinks_6x6_c_0.vbn d2s_block_0.d2s_inputs_c_0.y 3.15668f
C257 d2s_block_0.en_3v3_b d2s_block_0.d2s_inputs_c_0.y 0.06417f
C258 d2s_block_0.bias_tree_pd_0.bias_tree_swp_0.ni d2s_block_0.d2s_tails_c_0.vbp 3.87043f
C259 d2s_block_0.d2s_tails_c_0.vbp d2s_block_0.iref 0.05062f
C260 a_4042_20646# a_4314_20646# 0.0185f
C261 DCNDiode_0.guard a_3770_18030# 0.02519f
C262 a_3362_18030# a_3362_18116# 0.01869f
C263 a_3498_18030# a_4042_18116# 0.01247f
C264 d2s_block_0.d2s_inputs_c_0.sb_B d2s_block_0.d2s_inputs_c_0.sb_A 0.1724f
C265 a_4586_18030# a_3498_18030# 0.01257f
C266 DCNDiode_0.guard a_4314_20646# 0.03131f
C267 DCNDiode_0.guard d2s_block_0.d2s_casc_n_c_0.vbnc 4.40815f
C268 DCNDiode_0.guard pad 0.13157p
C269 DCNDiode_0.guard a_4994_18116# 0.10901f
C270 d2s_block_0.d2s_ab_p_c_0.vabp d2s_cma_0.a 0.15892f
C271 Clamp_N_M1_wiring_0.b d2s_block_0.d2s_ab_p_c_0.l1 0.18532f
C272 d2s_block_0.en_3v3_b d2s_block_0.vref 0.02125f
C273 d2s_block_0.sinks_6x6_c_0.vbn d2s_block_0.vref 0.01371f
C274 d2s_block_0.vinn d2s_block_0.d2s_casc_n_c_0.vbnc 0.03828f
C275 pad d2s_block_0.vinn 1.15545f
C276 d2s_block_0.d2s_ab_n_c_0.vabn d2s_block_0.d2s_inputs_c_0.y 0.02745f
C277 d2s_block_0.d2s_inputs_c_0.sb_B a_5266_18116# 0.02699f
C278 a_4858_18116# a_3906_20646# 0.01869f
C279 a_4586_18116# a_4450_18116# 0.63642f
C280 Clamp_N_M1_wiring_0.b Clamp_N_M1_wiring_0.dabn 0.14161f
C281 a_5130_18116# a_5266_18116# 0.63642f
C282 DCNDiode_0.guard a_3906_18116# 0.10901f
C283 d2s_block_0.d2s_inputs_c_0.sb_A d2s_block_0.d2s_inputs_c_0.y 0.02906f
C284 a_4042_20646# a_4042_18116# 0.02961f
C285 DCNDiode_0.guard d2s_block_0.en_3v3_b 2.48127f
C286 d2s_block_0.sinks_6x6_c_0.vbn DCNDiode_0.guard 1.26769f
C287 a_3634_18030# a_3770_18030# 0.24073f
C288 d2s_block_0.vref d2s_block_0.d2s_ab_n_c_0.vabn 0.0134f
C289 d2s_block_0.d2s_ab_p_c_0.vabp d2s_block_0.d2s_ab_p_c_0.l1 1.77636f
C290 DCNDiode_0.guard a_4042_18116# 0.10901f
C291 d2s_block_0.vinn d2s_block_0.en_3v3_b 0.04567f
C292 d2s_block_0.sinks_6x6_c_0.vbn d2s_block_0.vinn 0.02419f
C293 d2s_block_0.d2s_inputs_c_0.sa_B d2s_block_0.d2s_ab_n_c_0.vabn 0.01061f
C294 DCNDiode_0.guard a_4586_18030# 0.37233f
C295 d2s_block_0.en_3v3 d2s_block_0.d2s_inputs_c_0.y 0.03553f
C296 Clamp_N_M1_wiring_0.b d2s_block_0.d2s_ab_p_c_0.vabp 1.73569f
C297 d2s_block_0.d2s_inputs_c_0.sa_C2 a_3906_20646# 0.07107f
C298 d2s_block_0.d2s_ab_p_c_0.vabp d2s_block_0.d2s_loads_c_0.pr 0.11266f
C299 d2s_block_0.d2s_tails_c_0.vbp d2s_block_0.d2s_inputs_c_0.sb_C1 0.83098f
C300 TopLayersTo4_0.vdd d2s_block_0.d2s_loads_c_0.pr 0.07161f
C301 d2s_block_0.d2s_inputs_c_0.sb_A d2s_block_0.vref 2.73751f
C302 d2s_block_0.d2s_inputs_c_0.sb_A d2s_block_0.d2s_inputs_c_0.sa_B 2.43842f
C303 DCNDiode_0.guard d2s_block_0.d2s_ab_n_c_0.vabn 4.51046f
C304 a_5130_18116# a_4722_18030# 0.01887f
C305 a_4586_18030# a_4722_18116# 0.01247f
C306 d2s_block_0.vinn d2s_block_0.d2s_ab_n_c_0.vabn 0.02052f
C307 pad d2s_cma_0.a 74.5762f
C308 d2s_block_0.vref d2s_block_0.en_3v3 0.0217f
C309 a_4450_18030# a_3362_18030# 0.10092f
C310 d2s_block_0.d2s_ab_p_c_0.l1 d2s_block_0.d2s_inputs_c_0.x 0.39187f
C311 d2s_block_0.d2s_inputs_c_0.sb_A DCNDiode_0.guard 2.56678f
C312 TopLayersTo4_0.vdd d2s_block_0.d2s_ab_p_c_0.vabp 1.44322f
C313 a_4178_18116# a_4042_18116# 0.63642f
C314 a_4042_20646# a_4450_18116# 0.01247f
C315 TopLayersTo4_0.vdd d2s_block_0.vinp 0.97282f
C316 TopLayersTo4_0.vdd d2s_block_0.d2s_inputs_c_0.sa_C2 0.01311f
C317 a_3634_18030# a_4042_18116# 0.01887f
C318 d2s_block_0.d2s_inputs_c_0.sa_A a_3362_18116# 0.02709f
C319 a_4586_18116# a_4178_20646# 0.01887f
C320 d2s_block_0.bias_tree_pd_0.bias_tree_swp_0.ni d2s_block_0.d2s_casc_p_c_0.vbpc 0.24809f
C321 DCNDiode_0.guard a_4450_18116# 0.10901f
C322 DCNDiode_0.guard d2s_block_0.en_3v3 2.79161f
C323 d2s_block_0.d2s_inputs_c_0.sb_A a_5402_18116# 0.02717f
C324 DCNDiode_0.guard a_5266_18116# 0.10901f
C325 a_4450_18030# d2s_block_0.d2s_loads_c_0.l2 0.34569f
C326 d2s_block_0.d2s_ab_p_c_0.vabp a_3770_18116# 0.01308f
C327 d2s_block_0.d2s_ab_p_c_0.l1 d2s_block_0.d2s_casc_n_c_0.vbnc 1.74229f
C328 d2s_block_0.vinn d2s_block_0.en_3v3 1.80206f
C329 d2s_block_0.d2s_inputs_c_0.sa_C2 a_3770_18116# 0.02699f
C330 d2s_block_0.d2s_inputs_c_0.sb_B d2s_block_0.d2s_inputs_c_0.sb_C1 0.31767f
C331 Clamp_N_M1_wiring_0.b d2s_block_0.d2s_casc_n_c_0.vbnc 1.8461f
C332 Clamp_N_M1_wiring_0.b pad 65.7616f
C333 a_4042_20646# a_4314_18116# 0.01247f
C334 pad d2s_block_0.d2s_loads_c_0.pr 0.23964f
C335 pad Clamp_N_M1_wiring_0.dabn 2.28999f
C336 a_5130_18116# d2s_block_0.d2s_inputs_c_0.sb_C1 0.02699f
C337 a_5402_18116# a_5266_18116# 0.63642f
C338 a_3226_18116# a_3362_18116# 0.63642f
C339 a_4994_18116# a_4858_18116# 0.63642f
C340 TopLayersTo4_0.vdd d2s_block_0.d2s_inputs_c_0.x 0.60209f
C341 d2s_block_0.d2s_inputs_c_0.sa_C1 d2s_block_0.d2s_inputs_c_0.sb_C1 0.20629f
C342 DCNDiode_0.guard a_4314_18116# 0.10901f
C343 d2s_block_0.bias_tree_pd_0.bias_tree_swp_0.ni DCNDiode_0.guard 0.07244f
C344 DCNDiode_0.guard d2s_block_0.iref 0.14428f
C345 d2s_cma_0.a d2s_block_0.d2s_ab_n_c_0.vabn 0.16617f
C346 DCNDiode_0.guard a_3362_18116# 0.10901f
C347 d2s_block_0.d2s_ab_p_c_0.l1 d2s_block_0.en_3v3_b 0.09802f
C348 a_3906_18116# a_3906_20646# 0.01869f
C349 DCNDiode_0.guard a_4722_18030# 0.03742f
C350 d2s_block_0.d2s_inputs_c_0.y d2s_block_0.d2s_inputs_c_0.sb_C1 0.28042f
C351 a_3362_18030# d2s_block_0.d2s_loads_c_0.l2 0.34569f
C352 d2s_block_0.d2s_ab_p_c_0.vabp pad 0.43567f
C353 Clamp_N_M1_wiring_0.b d2s_block_0.en_3v3_b 0.03926f
C354 d2s_block_0.vinp d2s_block_0.d2s_casc_n_c_0.vbnc 1.38841f
C355 pad d2s_block_0.vinp 0.2405f
C356 TopLayersTo4_0.vdd d2s_block_0.d2s_casc_n_c_0.vbnc 1.55815f
C357 TopLayersTo4_0.vdd pad 0.01361f
C358 a_3634_18116# a_3498_18116# 0.63642f
C359 a_3770_18030# a_3770_18116# 0.01899f
C360 a_4042_20646# a_4178_20646# 0.18033f
C361 d2s_block_0.d2s_inputs_c_0.sb_C2 d2s_block_0.d2s_inputs_c_0.sb_C1 1.11323f
C362 a_4586_18030# a_4858_18116# 0.01247f
C363 a_4722_18030# a_4722_18116# 0.01887f
C364 d2s_block_0.d2s_ab_p_c_0.l1 d2s_block_0.d2s_ab_n_c_0.vabn 2.55379f
C365 DCNDiode_0.guard a_4178_20646# 0.04403f
C366 a_4178_18116# a_4314_18116# 0.63642f
C367 d2s_cma_0.a d2s_block_0.en_3v3 0.027f
C368 d2s_block_0.vref d2s_block_0.d2s_inputs_c_0.sb_C1 0.32074f
C369 d2s_block_0.d2s_ab_p_c_0.vabp a_3906_18116# 0.01021f
C370 Clamp_N_M1_wiring_0.b d2s_block_0.d2s_ab_n_c_0.vabn 0.22889f
C371 d2s_block_0.d2s_inputs_c_0.sa_B d2s_block_0.d2s_inputs_c_0.sb_C1 0.24841f
C372 Clamp_N_M1_wiring_0.dabn d2s_block_0.d2s_ab_n_c_0.vabn 0.2178f
C373 d2s_block_0.d2s_ab_p_c_0.vabp d2s_block_0.en_3v3_b 0.10062f
C374 d2s_block_0.en_3v3_b d2s_block_0.vinp 0.03531f
C375 d2s_block_0.sinks_6x6_c_0.vbn d2s_block_0.vinp 0.02098f
C376 d2s_block_0.d2s_inputs_c_0.sb_B d2s_block_0.d2s_tails_c_0.vbp 0.74509f
C377 d2s_block_0.sinks_6x6_c_0.vbn TopLayersTo4_0.vdd 2.56876f
C378 TopLayersTo4_0.vdd d2s_block_0.en_3v3_b 2.56924f
C379 a_3498_18030# a_3498_18116# 0.02961f
C380 pad d2s_block_0.d2s_inputs_c_0.x 1.1754f
C381 d2s_block_0.d2s_casc_n_c_0.vbnc d2s_block_0.d2s_inputs_c_0.x 1.85731f
C382 d2s_block_0.d2s_ab_p_c_0.vabp a_4586_18030# 0.0992f
C383 DCNDiode_0.guard d2s_block_0.d2s_inputs_c_0.sb_C1 1.89808f
C384 DCNDiode_0.guard a_5538_18116# 0.14985f
C385 a_4858_18030# Clamp_N_M1_1.iovss 0.89471f
C386 a_4722_18030# Clamp_N_M1_1.iovss 0.96343f
C387 a_4586_18030# Clamp_N_M1_1.iovss 1.00417f
C388 a_4450_18030# Clamp_N_M1_1.iovss 1.16631f
C389 a_4314_20646# Clamp_N_M1_1.iovss 0.8896f
C390 a_4178_20646# Clamp_N_M1_1.iovss 0.95702f
C391 a_4042_20646# Clamp_N_M1_1.iovss 1.04026f
C392 a_3906_20646# Clamp_N_M1_1.iovss 1.15712f
C393 a_3770_18030# Clamp_N_M1_1.iovss 0.89471f
C394 a_3634_18030# Clamp_N_M1_1.iovss 0.96343f
C395 a_3498_18030# Clamp_N_M1_1.iovss 1.00453f
C396 a_3362_18030# Clamp_N_M1_1.iovss 1.16631f
C397 d2s_block_0.d2s_ab_p_c_0.l1 Clamp_N_M1_1.iovss 4.32486f
C398 d2s_block_0.d2s_loads_c_0.pr Clamp_N_M1_1.iovss 10.26833f
C399 d2s_block_0.d2s_loads_c_0.pl Clamp_N_M1_1.iovss 6.41539f
C400 d2s_block_0.d2s_inputs_c_0.y Clamp_N_M1_1.iovss 42.36963f
C401 d2s_block_0.d2s_inputs_c_0.x Clamp_N_M1_1.iovss 15.58292f
C402 d2s_block_0.iref Clamp_N_M1_1.iovss 4.07741f
C403 d2s_block_0.d2s_inputs_c_0.sb_A Clamp_N_M1_1.iovss 4.41819f
C404 d2s_block_0.d2s_inputs_c_0.sa_C2 Clamp_N_M1_1.iovss 4.57235f
C405 d2s_block_0.d2s_inputs_c_0.sa_C1 Clamp_N_M1_1.iovss 1.61662f
C406 d2s_block_0.d2s_inputs_c_0.sb_B Clamp_N_M1_1.iovss 4.13048f
C407 d2s_block_0.d2s_inputs_c_0.sa_B Clamp_N_M1_1.iovss 2.97298f
C408 d2s_block_0.d2s_inputs_c_0.sb_C1 Clamp_N_M1_1.iovss 2.5731f
C409 d2s_block_0.d2s_inputs_c_0.sb_C2 Clamp_N_M1_1.iovss 4.50903f
C410 d2s_block_0.d2s_inputs_c_0.sa_A Clamp_N_M1_1.iovss 4.54075f
C411 TopLayersTo4_0.vdd Clamp_N_M1_1.iovss 0.21052p ; **FLOATING
.ends
