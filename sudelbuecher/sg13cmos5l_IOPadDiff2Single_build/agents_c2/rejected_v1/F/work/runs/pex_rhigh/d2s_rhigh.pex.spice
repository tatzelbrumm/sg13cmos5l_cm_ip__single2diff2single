* PEX produced on Sat Oct 31 16:38:13 UTC 2026 using /usr/local/bin/sak-pex.sh with m=2 and s=1
* NGSPICE file created from d2s_rhigh_pex.ext - technology: ihp-sg13cmos5l

.subckt d2s_rhigh_pex vss sa_A sb_A sa_B sb_B sa_C1 sb_C1 sa_C2 sb_C2
X0 vss vss vss rhigh l=12.65u w=0.5u
X1 sa_A a_136_n86# vss rhigh l=12.65u w=0.5u
X2 sa_C1 a_408_n86# vss rhigh l=12.65u w=0.5u
X3 sb_A a_1224_n86# vss rhigh l=12.65u w=0.5u
X4 sa_B a_272_n86# vss rhigh l=12.65u w=0.5u
X5 sa_C2 a_544_n86# vss rhigh l=12.65u w=0.5u
X6 a_1088_2530# a_1224_n86# vss rhigh l=12.65u w=0.5u
X7 a_816_2530# a_408_n86# vss rhigh l=12.65u w=0.5u
X8 a_1088_2530# a_136_n86# vss rhigh l=12.65u w=0.5u
X9 a_680_2530# a_544_n86# vss rhigh l=12.65u w=0.5u
X10 a_952_2530# a_272_n86# vss rhigh l=12.65u w=0.5u
X11 a_952_2530# a_1360_n86# vss rhigh l=12.65u w=0.5u
X12 a_680_2530# a_1632_n86# vss rhigh l=12.65u w=0.5u
X13 sb_C1 a_1496_n86# vss rhigh l=12.65u w=0.5u
X14 a_816_2530# a_1496_n86# vss rhigh l=12.65u w=0.5u
X15 sb_C2 a_1632_n86# vss rhigh l=12.65u w=0.5u
X16 sb_B a_1360_n86# vss rhigh l=12.65u w=0.5u
X17 vss vss vss rhigh l=12.65u w=0.5u
C0 a_1224_n86# a_1496_n86# 0.30865f
C1 a_136_0# a_0_0# 0.63642f
C2 sb_B sb_C1 0.13189f
C3 a_1360_0# a_1360_n86# 0.02961f
C4 a_544_0# a_408_0# 0.63642f
C5 a_680_0# a_272_n86# 0.01247f
C6 a_952_0# a_816_0# 0.63642f
C7 a_680_2530# a_1632_0# 0.01869f
C8 a_544_n86# a_408_n86# 0.24073f
C9 a_952_2530# a_1360_0# 0.01887f
C10 a_816_2530# a_1360_0# 0.01247f
C11 a_136_0# sa_A 0.02699f
C12 a_1496_0# a_1632_0# 0.63642f
C13 a_952_0# a_272_n86# 0.02961f
C14 sa_B a_272_0# 0.02699f
C15 a_1904_0# sb_C1 0.02699f
C16 a_1768_0# a_1904_0# 0.63642f
C17 a_136_0# a_136_n86# 0.01869f
C18 a_680_0# a_544_n86# 0.01899f
C19 a_1224_0# a_1088_2530# 0.01899f
C20 a_952_0# a_952_2530# 0.01887f
C21 a_2040_0# sb_B 0.02699f
C22 a_408_0# a_272_0# 0.63642f
C23 sb_A sb_B 0.13189f
C24 a_272_n86# a_136_n86# 0.20168f
C25 a_1360_n86# a_1904_0# 0.01247f
C26 a_952_0# a_816_2530# 0.01247f
C27 a_1496_0# a_1360_n86# 0.01247f
C28 a_952_2530# a_680_2530# 0.30865f
C29 a_1496_n86# a_1904_0# 0.01887f
C30 a_544_0# a_272_n86# 0.01247f
C31 a_680_2530# sb_C2 0.07072f
C32 a_816_2530# a_1224_0# 0.01247f
C33 a_1496_0# a_1496_n86# 0.01887f
C34 a_816_2530# a_680_2530# 0.20168f
C35 a_1088_0# a_1088_2530# 0.01899f
C36 a_1768_0# a_1632_0# 0.63642f
C37 a_408_0# a_272_n86# 0.01247f
C38 a_408_n86# a_136_n86# 0.30865f
C39 a_816_2530# sa_C2 0.02041f
C40 a_2040_0# a_1904_0# 0.63642f
C41 a_1224_n86# a_1224_0# 0.01869f
C42 a_1496_0# a_816_2530# 0.02961f
C43 sa_B sa_C1 0.13189f
C44 sa_C2 sa_C1 0.13189f
C45 a_1632_0# a_1360_n86# 0.01247f
C46 a_1088_0# a_816_2530# 0.01247f
C47 a_1224_n86# a_136_n86# 0.10092f
C48 a_136_0# a_272_0# 0.63642f
C49 a_544_0# a_544_n86# 0.01899f
C50 a_680_2530# a_680_0# 0.01869f
C51 a_1768_0# a_1360_n86# 0.01247f
C52 a_408_n86# a_408_0# 0.01887f
C53 a_408_0# sa_C1 0.02699f
C54 a_1224_0# a_1360_0# 0.63642f
C55 a_1632_n86# a_1632_0# 0.01899f
C56 a_272_n86# a_272_0# 0.02961f
C57 a_816_0# a_272_n86# 0.01247f
C58 a_680_0# a_544_0# 0.63642f
C59 a_1632_n86# a_1768_0# 0.01899f
C60 a_1496_n86# a_1360_n86# 0.18033f
C61 sb_C2 sb_C1 0.13189f
C62 a_1768_0# sb_C2 0.02699f
C63 a_1360_n86# a_272_n86# 0.01257f
C64 a_1496_0# a_1360_0# 0.63642f
C65 a_816_2530# a_816_0# 0.02961f
C66 a_1632_n86# a_1360_n86# 0.0185f
C67 a_816_0# a_408_n86# 0.01887f
C68 a_1632_n86# a_1496_n86# 0.24073f
C69 a_952_2530# a_1088_2530# 0.24073f
C70 a_2040_0# a_1360_n86# 0.02961f
C71 a_952_0# a_1088_0# 0.63642f
C72 a_2040_0# a_2176_0# 0.63642f
C73 a_816_2530# a_1088_2530# 0.0185f
C74 a_2176_0# sb_A 0.02699f
C75 sa_B sa_A 0.13189f
C76 a_816_0# a_680_0# 0.63642f
C77 a_680_2530# sa_C2 0.07072f
C78 a_408_n86# a_272_n86# 0.18033f
C79 a_1088_0# a_1224_0# 0.63642f
C80 a_952_2530# a_816_2530# 0.18033f
C81 a_1224_n86# a_1360_n86# 0.20168f
C82 a_816_2530# sb_C2 0.02041f
C83 a_2312_0# a_2176_0# 0.63642f
C84 a_1088_0# a_136_n86# 0.01869f
C85 a_544_0# sa_C2 0.02699f
C86 a_1224_n86# a_2176_0# 0.01869f
C87 a_544_n86# a_272_n86# 0.0185f
C88 sb_A vss 0.59872f
C89 sb_B vss 0.49359f
C90 sb_C1 vss 0.48799f
C91 sb_C2 vss 0.4906f
C92 sa_C2 vss 0.4906f
C93 sa_C1 vss 0.48799f
C94 sa_B vss 0.49359f
C95 sa_A vss 0.59872f
C96 a_1632_n86# vss 0.89535f
C97 a_1496_n86# vss 0.96408f
C98 a_1360_n86# vss 1.12382f
C99 a_1224_n86# vss 1.342f
C100 a_1088_2530# vss 0.89263f
C101 a_952_2530# vss 0.96004f
C102 a_816_2530# vss 1.09058f
C103 a_680_2530# vss 1.30081f
C104 a_544_n86# vss 0.89535f
C105 a_408_n86# vss 0.96408f
C106 a_272_n86# vss 1.12382f
C107 a_136_n86# vss 1.342f
.ends
