* Extracted by KLayout with SG13CMOS5L LVS runset on : 31/10/2026 16:50

.SUBCKT d2s_casc_p_c a l2 pl pr vbpc vdd
M$1 a vbpc pr vdd sg13_hv_pmos L=3u W=30u AS=10.2p AD=10.2p PS=61.36u PD=61.36u
+ rfmode=0
M$2 pl vbpc l2 vdd sg13_hv_pmos L=3u W=30u AS=10.2p AD=10.2p PS=61.36u
+ PD=61.36u rfmode=0
M$5 vdd vbpc vdd vdd sg13_hv_pmos L=4u W=1u AS=0.34p AD=0.34p PS=2.68u PD=2.68u
+ rfmode=0
M$6 vdd vbpc vbpc vdd sg13_hv_pmos L=4u W=1u AS=0.34p AD=0.34p PS=2.68u
+ PD=2.68u rfmode=0
.ENDS d2s_casc_p_c
