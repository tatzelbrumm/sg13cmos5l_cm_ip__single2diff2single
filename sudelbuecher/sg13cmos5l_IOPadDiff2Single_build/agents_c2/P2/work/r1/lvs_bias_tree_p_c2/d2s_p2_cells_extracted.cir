* Extracted by KLayout with SG13CMOS5L LVS runset on : 31/10/2026 19:15

.SUBCKT bias_tree_p_c2 en_3v3_b iref ni vabn vbn vbnc vbp vdd
M$1 iref en_3v3_b ni vdd sg13_hv_pmos L=0.45u W=1u AS=0.34p AD=0.34p PS=2.68u
+ PD=2.68u rfmode=0
M$2 vdd vbp vbnc vdd sg13_hv_pmos L=6u W=2u AS=0.68p AD=0.68p PS=4.68u PD=4.68u
+ rfmode=0
M$3 vdd vbp vbn vdd sg13_hv_pmos L=6u W=5u AS=1.7p AD=1.7p PS=10.68u PD=10.68u
+ rfmode=0
M$4 vdd vbp vabn vdd sg13_hv_pmos L=6u W=5u AS=1.7p AD=1.7p PS=10.68u PD=10.68u
+ rfmode=0
M$5 vdd vbp vdd vdd sg13_hv_pmos L=6u W=2u AS=0.68p AD=0.68p PS=4.68u PD=4.68u
+ rfmode=0
.ENDS bias_tree_p_c2
