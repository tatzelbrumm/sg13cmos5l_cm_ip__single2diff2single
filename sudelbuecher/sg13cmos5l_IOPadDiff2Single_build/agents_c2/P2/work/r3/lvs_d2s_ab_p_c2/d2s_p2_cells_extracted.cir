* Extracted by KLayout with SG13CMOS5L LVS runset on : 31/10/2026 19:27

.SUBCKT d2s_ab_p_c2 a b dabp l1 l2 vabp vdd
M$1 vdd vdd vdd vdd sg13_hv_pmos L=0.6u W=13.32u AS=4.5288p AD=4.5288p PS=28u
+ PD=28u rfmode=0
M$2 l2 vabp l1 vdd sg13_hv_pmos L=0.6u W=6.66u AS=2.2644p AD=2.2644p PS=14u
+ PD=14u rfmode=0
M$3 vabp vabp dabp vdd sg13_hv_pmos L=0.6u W=6.66u AS=2.2644p AD=2.2644p PS=14u
+ PD=14u rfmode=0
M$4 a vabp b vdd sg13_hv_pmos L=0.6u W=6.66u AS=2.2644p AD=2.2644p PS=14u
+ PD=14u rfmode=0
.ENDS d2s_ab_p_c2
