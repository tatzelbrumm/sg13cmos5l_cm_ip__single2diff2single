** sch_path: /home/user/c2/BA/work/macros/sg13cmos5l_IOPadDiff2Single/verification/cace/templates/sg13cmos5l_IOPadDiff2Single_tb_pd.sch
.subckt sg13cmos5l_IOPadDiff2Single_tb_pd

x1 iovdd 0 vcore 0 pad vinp vinn vref iref en_3v3 en_3v3_b sg13cmos5l_IOPadDiff2Single
xc iovdd vcore 0 en s0 s1 s12 s33 en_3v3 sel0_3v3 sel1_3v3 en_3v3_b en_ctrl_3v3
xg iovdd 0 ibias iref en_3v3 sel0_3v3 sel1_3v3 bias_gen_pd
**** begin user architecture code

.lib cornerMOShv.lib mos_CACE{corner_mos}
.lib cornerMOSlv.lib mos_CACE{corner_mos}
.lib cornerRES.lib res_CACE{corner_r=typ}
.lib cornerCAP.lib cap_CACE{corner_c=typ}
.lib cornerPNP.lib CACE{corner_pnp=typ}
.lib cornerDIO.lib dio_tt
* IHP IO library (DCNDiode, DCPDiode); on the sourcepath of the PDK .spiceinit
.include sg13cmos5l_io.spice

* ---- supplies: iovdd = ring 3.3 V (front end, bias, output stage), vcore = 1.2 V core ring
Vio iovdd 0 dc CACE{vdd} ac 0
Vcore vcore 0 CACE[CACE{vddl=1.2}*ceil((CACE{pdstate=0} - 3)**2/99)]
* ---- slot-side controls (1.2 V logic) and the slot supplies seen by the presence detectors
* pdstate 0: en_1v2 low | 1: slot vdd_1v2 gated off | 2: slot vdd_3v3 gated off | 3: chip core 1.2 V off
* (core ring, slot vdd_1v2 and en_1v2 all 0) | 4: enabled.  ceil((s-k)**2/99) is 0 for s = k, else 1
Ven en 0 CACE[1.2*ceil(CACE{pdstate=0}**2/99)*ceil((CACE{pdstate=0} - 3)**2/99)]
Vs0 s0 0 CACE[(CACE{sel=0} % 2)*CACE{vddl=1.2}]
Vs1 s1 0 CACE[floor(CACE{sel=0} / 2)*CACE{vddl=1.2}]
Vs12 s12 0 CACE[1.2*ceil((CACE{pdstate=0} - 1)**2/99)*ceil((CACE{pdstate=0} - 3)**2/99)]
Vs33 s33 0 CACE[3.3*ceil((CACE{pdstate=0} - 2)**2/99)]
* ---- harness iDAC: a sourced current from a PMOS mirror on its own 3.3 V supply
Vext vext 0 3.3
Iext xg 0 CACE{ibias=5e-6}
XEd xg xg vext vext sg13_hv_pmos w=5u l=6u
XEm ibias xg vext vext sg13_hv_pmos w=5u l=6u
* ---- differential input around vicm: vinp - vinn = v(dp)
Vref vref 0 CACE{vref=1.65}
Vic vic 0 dc CACE{vicm=1.65} ac 0
Vd dp 0 dc 0 ac 0
Ep vinp vic dp 0 0.5
En vinn vic dp 0 -0.5
Vpad pad 0 CACE{vpad=1.65}

.include CACE{DUT_path}
.temp CACE{temp}
.options savecurrents klu method=gear reltol=1e-4 abstol=1e-15 gmin=1e-15 SEED=CACE[CACE{seed=12345} + CACE{iterations=0}] rshunt=1e14
.option warn=1
.control
save all
op
let Iio_pd = -i(vio)
let Icore_pd = -i(vcore)
let Ipad_pd = -i(vpad)
let Is12_pd = -i(vs12)
let Is33_pd = -i(vs33)
let Ven3 = v(en_3v3)
echo $&Iio_pd $&Icore_pd $&Ipad_pd $&Is12_pd $&Is33_pd $&Ven3 > CACE{filename}_CACE{N}.data
.endc

**** end user architecture code
.ends

* expanding   symbol:  sg13cmos5l_IOPadDiff2Single.sym # of pins=11
** sym_path: /home/user/c2/BA/work/macros/sg13cmos5l_IOPadDiff2Single/schematic/xschem/sg13cmos5l_IOPadDiff2Single.sym
** sch_path: /home/user/c2/BA/work/macros/sg13cmos5l_IOPadDiff2Single/schematic/xschem/sg13cmos5l_IOPadDiff2Single.sch
.subckt sg13cmos5l_IOPadDiff2Single iovdd iovss vdd vss pad vinp vinn vref iref en_3v3 en_3v3_b
*.PININFO iovdd:B iovss:B vdd:B vss:B pad:B vinp:I vinn:I vref:I iref:B en_3v3:I en_3v3_b:I
xt iovdd iovss iref vbp vbn vbpc vbnc vabp vabn en_3v3 en_3v3_b bias_tree_pd
xd iovdd iovss iovdd iovss vinp vinn vref pad a b dabp dabn vbp vbn vbpc vbnc vabp vabn en_3v3 en_3v3_b d2s_mpdda_pd
xfp iovdd a pad dabp d2s_out_p
xfn iovss b pad dabn d2s_out_n
MCMA pa a pa pa sg13_hv_pmos w=7.96u l=32.16u ng=1
XSPA pa iovdd iovss pad d2s_sp2k
MCMB b pb b b sg13_hv_pmos w=7.96u l=32.16u ng=1
XSPB pb iovdd iovss pad d2s_sp2k
XDP pad iovdd iovss sg13cmos5l_DCPDiode
XDN iovss pad iovdd sg13cmos5l_DCNDiode
MMDBP iovdd vbp iovdd iovdd sg13_hv_pmos w=2u l=6u ng=1
MMDBN ni ni ni iovss sg13_hv_nmos w=2.4u l=6u ng=1
.ends

* expanding   symbol:  en_ctrl_3v3.sym # of pins=12
** sym_path: /home/user/c2/BA/work/macros/en_ctrl_3v3/schematic/xschem/en_ctrl_3v3.sym
** sch_path: /home/user/c2/BA/work/macros/en_ctrl_3v3/schematic/xschem/en_ctrl_3v3.sch
.subckt en_ctrl_3v3 vddh vddl vss en_1v2 sel0_1v2 sel1_1v2 vdd1v2_sense vdd3v3_sense en_3v3 sel0_3v3 sel1_3v3 en_3v3_b
*.PININFO vddh:B vddl:B vss:B en_1v2:I sel0_1v2:I sel1_1v2:I vdd1v2_sense:I vdd3v3_sense:I en_3v3:O sel0_3v3:O sel1_3v3:O
*+ en_3v3_b:O
XLE vss vddl vddh en_ls en_1v2 ls_up_1v2_3v3
XL0 vss vddl vddh sel0_3v3 sel0_1v2 ls_up_1v2_3v3
XL1 vss vddl vddh sel1_3v3 sel1_1v2 ls_up_1v2_3v3
XIE vddh vss en_ls en_ls_b inv_hv
XG1 vddh vss vdd1v2_sense pg1_b en_ls en_ls_b pg_det
XG3 vddh vss vdd3v3_sense pg3_b en_ls en_ls_b pg_det
XNO vddh vss en_ls_b pg1_b pg3_b en_3v3 nor3_hv
XIB vddh vss en_3v3 en_3v3_b inv_hv
.ends

* expanding   symbol:  bias_gen_pd.sym # of pins=7
** sym_path: /home/user/c2/BA/work/macros/bias_gen_pd/schematic/xschem/bias_gen_pd.sym
** sch_path: /home/user/c2/BA/work/macros/bias_gen_pd/schematic/xschem/bias_gen_pd.sch
.subckt bias_gen_pd vdd vss ibias iref en_3v3 sel0_3v3 sel1_3v3
*.PININFO vdd:B vss:B ibias:B iref:O en_3v3:I sel0_3v3:I sel1_3v3:I
XDA vdd vss en_3v3 sel0_3v3 en_oa_b nand2_hv
XDB vdd vss en_oa_b en_oa inv_hv
XDC vdd vss en_3v3 sel1_3v3 en_bg_b nand2_hv
XDD vdd vss en_bg_b en_bg inv_hv
XDE vdd vss sel0_3v3 sel1_3v3 s00 nor2_hv
XDF vdd vss en_3v3 s00 en_ext_b nand2_hv
XDG vdd vss en_ext_b en_ext inv_hv
Xoa vdd vss iref en_oa en_oa_b oa_core_pd
Xbg vdd vss iref en_bg en_bg_b bg_core_pd
MTEN iref en_ext ibias vss sg13_hv_nmos w=1u l=0.45u ng=1
MTEP iref en_ext_b ibias vdd sg13_hv_pmos w=1u l=0.45u ng=1
.ends

* expanding   symbol:  bias_tree_pd.sym # of pins=11
** sym_path: /home/user/c2/BA/work/macros/bias_tree_pd/schematic/xschem/bias_tree_pd.sym
** sch_path: /home/user/c2/BA/work/macros/bias_tree_pd/schematic/xschem/bias_tree_pd.sch
.subckt bias_tree_pd vdd vss iref vbp vbn vbpc vbnc vabp vabn en_3v3 en_3v3_b
*.PININFO vdd:B vss:B iref:B vbp:O vbn:O vbpc:O vbnc:O vabp:O vabn:O en_3v3:I en_3v3_b:I
MNI ni ni vss vss sg13_hv_nmos w=6u l=6u ng=1
MBPC vbpc vbpc vdd vdd sg13_hv_pmos w=1u l=4u ng=1
MNBPC vbpc ni vss vss sg13_hv_nmos w=2.4u l=6u ng=1
MBP vbp vbp vdd vdd sg13_hv_pmos w=5u l=6u ng=1
MNBP vbp ni vss vss sg13_hv_nmos w=6u l=6u ng=1
MNABP vabp ni vss vss sg13_hv_nmos w=6u l=6u ng=1
MPBNC vbnc vbp vdd vdd sg13_hv_pmos w=2u l=6u ng=1
MBNC vbnc vbnc vss vss sg13_hv_nmos w=1u l=8u ng=1
MPBN vbn vbp vdd vdd sg13_hv_pmos w=5u l=6u ng=1
MBN vbn vbn vss vss sg13_hv_nmos w=6u l=6u ng=1
MPABN vabn vbp vdd vdd sg13_hv_pmos w=5u l=6u ng=1
MTGP ni en_3v3_b iref vdd sg13_hv_pmos w=1u l=0.45u ng=1
MTGN iref en_3v3 ni vss sg13_hv_nmos w=1u l=0.45u ng=1
MTDN ni en_3v3_b vss vss sg13_hv_nmos w=1u l=0.45u ng=1
.ends

* expanding   symbol:  d2s_mpdda_pd.sym # of pins=20
** sym_path: /home/user/c2/BA/work/macros/sg13cmos5l_IOPadDiff2Single/schematic/xschem/d2s_mpdda_pd.sym
** sch_path: /home/user/c2/BA/work/macros/sg13cmos5l_IOPadDiff2Single/schematic/xschem/d2s_mpdda_pd.sch
.subckt d2s_mpdda_pd vdd vss vddo vsso vinp vinn vref vfb a b dabp dabn vbp vbn vbpc vbnc vabp vabn en_3v3 en_3v3_b
*.PININFO vdd:B vss:B vddo:B vsso:B vinp:I vinn:I vref:I vfb:I vbp:I vbn:I vbpc:I vbnc:I vabp:I vabn:I en_3v3:I en_3v3_b:I a:O b:O
*+ dabp:B dabn:B
XA x y vinp vref vdd vss vbp unit_r2
XB x y vref vinn vdd vss vbp unit_r2
XC1 x y vref vfb vdd vss vbp unit_r2
XC2 x y vref vfb vdd vss vbp unit_r2
MFNL l2 vabn l1 vss sg13_hv_nmos w=4.4u l=1u ng=1
MCX l1 vbnc x vss sg13_hv_nmos w=30u l=3u ng=2
MSX x vbn vss vss sg13_hv_nmos w=36u l=6u ng=6
MPL pl l2 vdd vdd sg13_hv_pmos w=24u l=4u ng=4
MPCL l2 vbpc pl vdd sg13_hv_pmos w=30u l=3u ng=2
MFPL l1 vabp l2 vdd sg13_hv_pmos w=6.66u l=0.6u ng=1
MPR pr l2 vdd vdd sg13_hv_pmos w=24u l=4u ng=4
MPCR a vbpc pr vdd sg13_hv_pmos w=30u l=3u ng=2
MABP b vabp a vdd sg13_hv_pmos w=6.66u l=0.6u ng=1
MABN a vabn b vss sg13_hv_nmos w=4.4u l=1u ng=1
MCY b vbnc y vss sg13_hv_nmos w=30u l=3u ng=2
MSY y vbn vss vss sg13_hv_nmos w=36u l=6u ng=6
MSABP vabp en_3v3 vdd vdd sg13_hv_pmos w=1u l=0.45u ng=1
MSA a en_3v3 vddo vdd sg13_hv_pmos w=1u l=0.45u ng=1
MSABN vabn en_3v3_b vss vss sg13_hv_nmos w=1u l=0.45u ng=1
MSB b en_3v3_b vsso vss sg13_hv_nmos w=1u l=0.45u ng=1
MRP2 vabp vabp dabp vdd sg13_hv_pmos w=6.66u l=0.6u ng=1
MRN2 vabn vabn dabn vss sg13_hv_nmos w=4.4u l=1u ng=1
MMDT[3] vdd vdd vdd vdd sg13_hv_pmos w=20u l=1u ng=2
MDT[2] vdd vdd vdd vdd sg13_hv_pmos w=20u l=1u ng=2
MDT[1] vdd vdd vdd vdd sg13_hv_pmos w=20u l=1u ng=2
MDT[0] vdd vdd vdd vdd sg13_hv_pmos w=20u l=1u ng=2
MMDTL[2] vdd vbp vdd vdd sg13_hv_pmos w=5u l=6u ng=1
MDTL[1] vdd vbp vdd vdd sg13_hv_pmos w=5u l=6u ng=1
MDTL[0] vdd vbp vdd vdd sg13_hv_pmos w=5u l=6u ng=1
MMDL[3] vdd l2 vdd vdd sg13_hv_pmos w=1u l=4u ng=1
MDL[2] vdd l2 vdd vdd sg13_hv_pmos w=1u l=4u ng=1
MDL[1] vdd l2 vdd vdd sg13_hv_pmos w=1u l=4u ng=1
MDL[0] vdd l2 vdd vdd sg13_hv_pmos w=1u l=4u ng=1
MMDPC vdd vbpc vdd vdd sg13_hv_pmos w=1u l=4u ng=1
MMDABP[1] vdd vdd vdd vdd sg13_hv_pmos w=6.66u l=0.6u ng=1
MDABP[0] vdd vdd vdd vdd sg13_hv_pmos w=6.66u l=0.6u ng=1
MMDABN[1] vss vss vss vss sg13_hv_nmos w=4.4u l=1u ng=1
MDABN[0] vss vss vss vss sg13_hv_nmos w=4.4u l=1u ng=1
MMDCN[3] vbnc vbnc vbnc vss sg13_hv_nmos w=2u l=3u ng=1
MDCN[2] vbnc vbnc vbnc vss sg13_hv_nmos w=2u l=3u ng=1
MDCN[1] vbnc vbnc vbnc vss sg13_hv_nmos w=2u l=3u ng=1
MDCN[0] vbnc vbnc vbnc vss sg13_hv_nmos w=2u l=3u ng=1
MMDSK[3] vbn vbn vbn vss sg13_hv_nmos w=2u l=6u ng=1
MDSK[2] vbn vbn vbn vss sg13_hv_nmos w=2u l=6u ng=1
MDSK[1] vbn vbn vbn vss sg13_hv_nmos w=2u l=6u ng=1
MDSK[0] vbn vbn vbn vss sg13_hv_nmos w=2u l=6u ng=1
MMDBNT vbn vbn vbn vss sg13_hv_nmos w=6u l=6u ng=1
RRD[1] vss vss 37.72k $SUB=vss $[rhigh] w=0.5u l=12.65u b=0
RD[0] vss vss 37.72k $SUB=vss $[rhigh] w=0.5u l=12.65u b=0
.ends

* expanding   symbol:  d2s_out_p.sym # of pins=4
** sym_path: /home/user/c2/BA/work/macros/sg13cmos5l_IOPadDiff2Single/schematic/xschem/d2s_out_p.sym
** sch_path: /home/user/c2/BA/work/macros/sg13cmos5l_IOPadDiff2Single/schematic/xschem/d2s_out_p.sch
.subckt d2s_out_p vddo a vout dabp
*.PININFO vddo:B a:I vout:B dabp:B
MOP vout a vddo vddo sg13_hv_pmos w=546.12u l=0.6u ng=82
MRP1 dabp dabp vddo vddo sg13_hv_pmos w=13.32u l=0.6u ng=2
MRPD dabp vddo vddo vddo sg13_hv_pmos w=13.32u l=0.6u ng=2
.ends

* expanding   symbol:  d2s_out_n.sym # of pins=4
** sym_path: /home/user/c2/BA/work/macros/sg13cmos5l_IOPadDiff2Single/schematic/xschem/d2s_out_n.sym
** sch_path: /home/user/c2/BA/work/macros/sg13cmos5l_IOPadDiff2Single/schematic/xschem/d2s_out_n.sch
.subckt d2s_out_n vsso b vout dabn
*.PININFO vsso:B b:I vout:B dabn:B
MON vout b vsso vsso sg13_hv_nmos w=299.2u l=1u ng=68
MRN1 dabn dabn vsso vsso sg13_hv_nmos w=8.8u l=1u ng=2
.ends

* expanding   symbol:  d2s_sp2k.sym # of pins=4
** sym_path: /home/user/c2/BA/work/macros/sg13cmos5l_IOPadDiff2Single/schematic/xschem/d2s_sp2k.sym
** sch_path: /home/user/c2/BA/work/macros/sg13cmos5l_IOPadDiff2Single/schematic/xschem/d2s_sp2k.sch
.subckt d2s_sp2k core iovdd iovss pad
*.PININFO core:B iovdd:B iovss:B pad:B
RR0 pad core 1.992k $SUB=iovss $[rppd] w=1u l=7.435u b=0
DD0 core iovdd dpantenna l=4.98u w=0.64u
DD1 iovss core dantenna l=3.1u w=0.64u
.ends

* expanding   symbol:  ls_up_1v2_3v3.sym # of pins=5
** sym_path: /home/user/c2/BA/work/macros/ls_up_1v2_3v3/schematic/xschem/ls_up_1v2_3v3.sym
** sch_path: /home/user/c2/BA/work/macros/ls_up_1v2_3v3/schematic/xschem/ls_up_1v2_3v3.sch
.subckt ls_up_1v2_3v3 vss vddl vddh out in
*.PININFO vss:B vddl:B vddh:B out:O in:I
MM2 inb in vddl vddl sg13_lv_pmos w=1.2u l=0.13u ng=1
MM1 inb in vss vss sg13_lv_nmos w=0.6u l=0.13u ng=1
MM3 a in vss vss sg13_hv_nmos w=2u l=0.45u ng=1 m=4
MM6 a b vddh vddh sg13_hv_pmos w=2u l=0.4u ng=1
MM5 b a vddh vddh sg13_hv_pmos w=2u l=0.4u ng=1
MM4 b inb vss vss sg13_hv_nmos w=2u l=0.45u ng=1 m=4
MM16 out a vddh vddh sg13_hv_pmos w=2u l=0.4u ng=1 m=2
MM12 out a vss vss sg13_hv_nmos w=2u l=0.45u ng=1
.ends

* expanding   symbol:  inv_hv.sym # of pins=4
** sym_path: /home/user/c2/BA/work/macros/hv_logic/schematic/xschem/inv_hv.sym
** sch_path: /home/user/c2/BA/work/macros/hv_logic/schematic/xschem/inv_hv.sch
.subckt inv_hv vdd vss a y
*.PININFO vdd:B vss:B a:I y:O
MP y a vdd vdd sg13_hv_pmos w=1u l=0.45u ng=1
MN y a vss vss sg13_hv_nmos w=1u l=0.45u ng=1
.ends

* expanding   symbol:  pg_det.sym # of pins=6
** sym_path: /home/user/c2/BA/work/macros/en_ctrl_3v3/schematic/xschem/pg_det.sym
** sch_path: /home/user/c2/BA/work/macros/en_ctrl_3v3/schematic/xschem/pg_det.sch
.subckt pg_det vddh vss sense pg_b ena ena_b
*.PININFO vddh:B vss:B sense:I pg_b:O ena:I ena_b:I
MPU pg_b ena_b vddh vddh sg13_hv_pmos w=0.3u l=50u ng=1
MND pg_b sense vss vss sg13_hv_nmos w=2u l=0.45u ng=1
MRD sense ena vss vss sg13_hv_nmos w=0.3u l=100u ng=1
.ends

* expanding   symbol:  nor3_hv.sym # of pins=6
** sym_path: /home/user/c2/BA/work/macros/hv_logic/schematic/xschem/nor3_hv.sym
** sch_path: /home/user/c2/BA/work/macros/hv_logic/schematic/xschem/nor3_hv.sch
.subckt nor3_hv vdd vss a b c y
*.PININFO vdd:B vss:B a:I b:I c:I y:O
MPA p1 a vdd vdd sg13_hv_pmos w=3u l=0.45u ng=1
MPB p2 b p1 vdd sg13_hv_pmos w=3u l=0.45u ng=1
MPC y c p2 vdd sg13_hv_pmos w=3u l=0.45u ng=1
MNA y a vss vss sg13_hv_nmos w=1u l=0.45u ng=1
MNB y b vss vss sg13_hv_nmos w=1u l=0.45u ng=1
MNC y c vss vss sg13_hv_nmos w=1u l=0.45u ng=1
.ends

* expanding   symbol:  nand2_hv.sym # of pins=5
** sym_path: /home/user/c2/BA/work/macros/hv_logic/schematic/xschem/nand2_hv.sym
** sch_path: /home/user/c2/BA/work/macros/hv_logic/schematic/xschem/nand2_hv.sch
.subckt nand2_hv vdd vss a b y
*.PININFO vdd:B vss:B a:I b:I y:O
MPA y a vdd vdd sg13_hv_pmos w=1u l=0.45u ng=1
MPB y b vdd vdd sg13_hv_pmos w=1u l=0.45u ng=1
MNA y a n1 vss sg13_hv_nmos w=1u l=0.45u ng=1
MNB n1 b vss vss sg13_hv_nmos w=1u l=0.45u ng=1
.ends

* expanding   symbol:  nor2_hv.sym # of pins=5
** sym_path: /home/user/c2/BA/work/macros/hv_logic/schematic/xschem/nor2_hv.sym
** sch_path: /home/user/c2/BA/work/macros/hv_logic/schematic/xschem/nor2_hv.sch
.subckt nor2_hv vdd vss a b y
*.PININFO vdd:B vss:B a:I b:I y:O
MPA p1 a vdd vdd sg13_hv_pmos w=2u l=0.45u ng=1
MPB y b p1 vdd sg13_hv_pmos w=2u l=0.45u ng=1
MNA y a vss vss sg13_hv_nmos w=1u l=0.45u ng=1
MNB y b vss vss sg13_hv_nmos w=1u l=0.45u ng=1
.ends

* expanding   symbol:  oa_core_pd.sym # of pins=5
** sym_path: /home/user/c2/BA/work/macros/oa_core_pd/schematic/xschem/oa_core_pd.sym
** sch_path: /home/user/c2/BA/work/macros/oa_core_pd/schematic/xschem/oa_core_pd.sch
.subckt oa_core_pd vdd vss iout en_3v3 en_3v3_b
*.PININFO vdd:B vss:B en_3v3:I en_3v3_b:I iout:O
MMS2 ks vbr vss vss sg13_hv_nmos w=10u l=1u ng=1
MMS3 vpc ks vss vss sg13_hv_nmos w=0.5u l=2u ng=1
MP0 vpg vpg vdd vdd sg13_hv_pmos w=2u l=8u ng=1
MP0C vpc vpc vpg vdd sg13_hv_pmos w=0.5u l=2u ng=1
MMC10 vpc vbr d10 vss sg13_hv_nmos w=10u l=1u ng=1
MM10 d10 vnc vres vss sg13_hv_nmos w=180u l=1u ng=18
MMCL vres vbr vss vss sg13_hv_nmos w=3.4u l=30u ng=1
MP8 c8 vpg vdd vdd sg13_hv_pmos w=16u l=8u ng=8
MP8C vnc vpc c8 vdd sg13_hv_pmos w=4u l=2u ng=2
MM11 vnc vnc vss vss sg13_hv_nmos w=90u l=1u ng=9
MP2 c2 vpg vdd vdd sg13_hv_pmos w=4u l=8u ng=2
MP2C vbr vpc c2 vdd sg13_hv_pmos w=1u l=2u ng=1
MMCS vbr vbr vss vss sg13_hv_nmos w=3.4u l=30u ng=1
MPO co vpg vdd vdd sg13_hv_pmos w=40u l=8u ng=20
MPOC iout vpc co vdd sg13_hv_pmos w=10u l=2u ng=5
MSKS ks en_3v3_b vss vss sg13_hv_nmos w=1u l=0.45u ng=1
MSVPG vpg en_3v3 vdd vdd sg13_hv_pmos w=1u l=0.45u ng=1
MMS1_0 net1 en_3v3_b vdd vdd sg13_hv_pmos w=0.5u l=12.5u ng=1
MMS1_1 net2 en_3v3_b net1 vdd sg13_hv_pmos w=0.5u l=12.5u ng=1
MMS1_2 net3 en_3v3_b net2 vdd sg13_hv_pmos w=0.5u l=12.5u ng=1
MMS1_3 net4 en_3v3_b net3 vdd sg13_hv_pmos w=0.5u l=12.5u ng=1
MMS1_4 net5 en_3v3_b net4 vdd sg13_hv_pmos w=0.5u l=12.5u ng=1
MMS1_5 net6 en_3v3_b net5 vdd sg13_hv_pmos w=0.5u l=12.5u ng=1
MMS1_6 net7 en_3v3_b net6 vdd sg13_hv_pmos w=0.5u l=12.5u ng=1
MMS1_7 ks en_3v3_b net7 vdd sg13_hv_pmos w=0.5u l=12.5u ng=1
MMDUM0 vdd vpg vdd vdd sg13_hv_pmos w=4.4u l=8u ng=9
MMDUM1 vss vnc vss vss sg13_hv_nmos w=36u l=1u ng=18
MMDUM2 vss vbr vss vss sg13_hv_nmos w=4u l=1u ng=2
.ends

* expanding   symbol:  bg_core_pd.sym # of pins=5
** sym_path: /home/user/c2/BA/work/macros/bg_core_pd/schematic/xschem/bg_core_pd.sym
** sch_path: /home/user/c2/BA/work/macros/bg_core_pd/schematic/xschem/bg_core_pd.sch
.subckt bg_core_pd vdd vss iout en_3v3 en_3v3_b
*.PININFO vdd:B vss:B en_3v3:I en_3v3_b:I iout:O
MMS2 ks g vss vss sg13_hv_nmos w=10u l=1u ng=1
MMS3 vpc ks vss vss sg13_hv_nmos w=0.5u l=2u ng=1
MPB vpg vpg vdd vdd sg13_hv_pmos w=40u l=1u ng=4
MPBC vpc vpc vpg vdd sg13_hv_pmos w=40u l=1u ng=4
MNB vpc g eb vss sg13_hv_nmos w=20u l=4u ng=2
QQ2 vss vss e2 pnpMPA a=4e-12 p=8e-06 m=8
MPA ca vpg vdd vdd sg13_hv_pmos w=40u l=1u ng=4
MPAC g vpc ca vdd sg13_hv_pmos w=40u l=1u ng=4
MNA g g ea vss sg13_hv_nmos w=20u l=4u ng=2
QQ1 vss vss ea pnpMPA a=4e-12 p=8e-06
MPO co vpg vdd vdd sg13_hv_pmos w=80u l=1u ng=8
MPOC iout vpc co vdd sg13_hv_pmos w=80u l=1u ng=8
MSKS ks en_3v3_b vss vss sg13_hv_nmos w=1u l=0.45u ng=1
MSVPG vpg en_3v3 vdd vdd sg13_hv_pmos w=1u l=0.45u ng=1
RR1B[9] eb n1b[8] 29.71k $SUB=vss $[rhigh] w=0.5u l=9.94u b=0
R1B[8] n1b[8] n1b[7] 29.71k $SUB=vss $[rhigh] w=0.5u l=9.94u b=0
R1B[7] n1b[7] n1b[6] 29.71k $SUB=vss $[rhigh] w=0.5u l=9.94u b=0
R1B[6] n1b[6] n1b[5] 29.71k $SUB=vss $[rhigh] w=0.5u l=9.94u b=0
R1B[5] n1b[5] n1b[4] 29.71k $SUB=vss $[rhigh] w=0.5u l=9.94u b=0
R1B[4] n1b[4] n1b[3] 29.71k $SUB=vss $[rhigh] w=0.5u l=9.94u b=0
R1B[3] n1b[3] n1b[2] 29.71k $SUB=vss $[rhigh] w=0.5u l=9.94u b=0
R1B[2] n1b[2] n1b[1] 29.71k $SUB=vss $[rhigh] w=0.5u l=9.94u b=0
R1B[1] n1b[1] n1b[0] 29.71k $SUB=vss $[rhigh] w=0.5u l=9.94u b=0
R1B[0] n1b[0] vss 29.71k $SUB=vss $[rhigh] w=0.5u l=9.94u b=0
RR0[17] eb n0[16] 29.71k $SUB=vss $[rhigh] w=0.5u l=9.94u b=0
R0[16] n0[16] n0[15] 29.71k $SUB=vss $[rhigh] w=0.5u l=9.94u b=0
R0[15] n0[15] n0[14] 29.71k $SUB=vss $[rhigh] w=0.5u l=9.94u b=0
R0[14] n0[14] n0[13] 29.71k $SUB=vss $[rhigh] w=0.5u l=9.94u b=0
R0[13] n0[13] n0[12] 29.71k $SUB=vss $[rhigh] w=0.5u l=9.94u b=0
R0[12] n0[12] n0[11] 29.71k $SUB=vss $[rhigh] w=0.5u l=9.94u b=0
R0[11] n0[11] n0[10] 29.71k $SUB=vss $[rhigh] w=0.5u l=9.94u b=0
R0[10] n0[10] n0[9] 29.71k $SUB=vss $[rhigh] w=0.5u l=9.94u b=0
R0[9] n0[9] n0[8] 29.71k $SUB=vss $[rhigh] w=0.5u l=9.94u b=0
R0[8] n0[8] n0[7] 29.71k $SUB=vss $[rhigh] w=0.5u l=9.94u b=0
R0[7] n0[7] n0[6] 29.71k $SUB=vss $[rhigh] w=0.5u l=9.94u b=0
R0[6] n0[6] n0[5] 29.71k $SUB=vss $[rhigh] w=0.5u l=9.94u b=0
R0[5] n0[5] n0[4] 29.71k $SUB=vss $[rhigh] w=0.5u l=9.94u b=0
R0[4] n0[4] n0[3] 29.71k $SUB=vss $[rhigh] w=0.5u l=9.94u b=0
R0[3] n0[3] n0[2] 29.71k $SUB=vss $[rhigh] w=0.5u l=9.94u b=0
R0[2] n0[2] n0[1] 29.71k $SUB=vss $[rhigh] w=0.5u l=9.94u b=0
R0[1] n0[1] n0[0] 29.71k $SUB=vss $[rhigh] w=0.5u l=9.94u b=0
R0[0] n0[0] e2 29.71k $SUB=vss $[rhigh] w=0.5u l=9.94u b=0
RR1A[10] ea n1a[9] 29.71k $SUB=vss $[rhigh] w=0.5u l=9.94u b=0
R1A[9] n1a[9] n1a[8] 29.71k $SUB=vss $[rhigh] w=0.5u l=9.94u b=0
R1A[8] n1a[8] n1a[7] 29.71k $SUB=vss $[rhigh] w=0.5u l=9.94u b=0
R1A[7] n1a[7] n1a[6] 29.71k $SUB=vss $[rhigh] w=0.5u l=9.94u b=0
R1A[6] n1a[6] n1a[5] 29.71k $SUB=vss $[rhigh] w=0.5u l=9.94u b=0
R1A[5] n1a[5] n1a[4] 29.71k $SUB=vss $[rhigh] w=0.5u l=9.94u b=0
R1A[4] n1a[4] n1a[3] 29.71k $SUB=vss $[rhigh] w=0.5u l=9.94u b=0
R1A[3] n1a[3] n1a[2] 29.71k $SUB=vss $[rhigh] w=0.5u l=9.94u b=0
R1A[2] n1a[2] n1a[1] 29.71k $SUB=vss $[rhigh] w=0.5u l=9.94u b=0
R1A[1] n1a[1] n1a[0] 29.71k $SUB=vss $[rhigh] w=0.5u l=9.94u b=0
R1A[0] n1a[0] vss 29.71k $SUB=vss $[rhigh] w=0.5u l=9.94u b=0
MMS1_0 net1 en_3v3_b vdd vdd sg13_hv_pmos w=0.5u l=12.5u ng=1
MMS1_1 net2 en_3v3_b net1 vdd sg13_hv_pmos w=0.5u l=12.5u ng=1
MMS1_2 net3 en_3v3_b net2 vdd sg13_hv_pmos w=0.5u l=12.5u ng=1
MMS1_3 net4 en_3v3_b net3 vdd sg13_hv_pmos w=0.5u l=12.5u ng=1
MMS1_4 net5 en_3v3_b net4 vdd sg13_hv_pmos w=0.5u l=12.5u ng=1
MMS1_5 net6 en_3v3_b net5 vdd sg13_hv_pmos w=0.5u l=12.5u ng=1
MMS1_6 net7 en_3v3_b net6 vdd sg13_hv_pmos w=0.5u l=12.5u ng=1
MMS1_7 ks en_3v3_b net7 vdd sg13_hv_pmos w=0.5u l=12.5u ng=1
MMDUM0 vdd vpg vdd vdd sg13_hv_pmos w=2.4u l=1u ng=8
MMDUM1 vdd vpc vdd vdd sg13_hv_pmos w=2.4u l=1u ng=8
MMDUM2 g g g vss sg13_hv_nmos w=2u l=1u ng=1
MMDUM3 g g g vss sg13_hv_nmos w=16u l=4u ng=8
RRDUM[1] vss vss 29.71k $SUB=vss $[rhigh] w=0.5u l=9.94u b=0
RDUM[0] vss vss 29.71k $SUB=vss $[rhigh] w=0.5u l=9.94u b=0
.ends

* expanding   symbol:  unit_r2.sym # of pins=7
** sym_path: /home/user/c2/BA/work/macros/sg13cmos5l_IOPadDiff2Single/schematic/xschem/unit_r2.sym
** sch_path: /home/user/c2/BA/work/macros/sg13cmos5l_IOPadDiff2Single/schematic/xschem/unit_r2.sch
.subckt unit_r2 x y gp gn vdd vss vbp
*.PININFO x:O y:O gp:I gn:I vdd:B vss:B vbp:I
MTa sa vbp vdd vdd sg13_hv_pmos w=5u l=6u ng=1
MTb sb vbp vdd vdd sg13_hv_pmos w=5u l=6u ng=1
MMa y gp sa sa sg13_hv_pmos w=20u l=1u ng=2
MMb x gn sb sb sg13_hv_pmos w=20u l=1u ng=2
RR[3] sa n1 37.72k $SUB=vss $[rhigh] w=0.5u l=12.65u b=0
R[2] n1 n2 37.72k $SUB=vss $[rhigh] w=0.5u l=12.65u b=0
R[1] n2 n3 37.72k $SUB=vss $[rhigh] w=0.5u l=12.65u b=0
R[0] n3 sb 37.72k $SUB=vss $[rhigh] w=0.5u l=12.65u b=0
.ends
