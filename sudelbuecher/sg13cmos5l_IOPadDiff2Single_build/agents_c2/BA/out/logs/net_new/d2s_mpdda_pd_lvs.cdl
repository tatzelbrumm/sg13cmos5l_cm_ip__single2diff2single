** sch_path: /home/user/c2/BA/work/macros/sg13cmos5l_IOPadDiff2Single/schematic/xschem/d2s_mpdda_pd.sch
.subckt d2s_mpdda_pd vdd vss vddo vsso vinp vinn vref vfb a b dabp dabn vbp vbn vbpc vbnc vabp vabn en_3v3 en_3v3_b
*.PININFO vdd:B vss:B vddo:B vsso:B vinp:I vinn:I vref:I vfb:I vbp:I vbn:I vbpc:I vbnc:I vabp:I vabn:I en_3v3:I en_3v3_b:I a:O b:O
*+ dabp:B dabn:B
XA x y vinp vref vdd vss vbp unit_r2
XB x y vref vinn vdd vss vbp unit_r2
XC1 x y vref vfb vdd vss vbp unit_r2
XC2 x y vref vfb vdd vss vbp unit_r2
MFNL l2 vabn l1 vss sg13_hv_nmos w=4.4u l=1u ng=1
MCX l1 vbnc x vss sg13_hv_nmos w=30u l=3u ng=2
MSX x vbn vss vss sg13_hv_nmos w=36u l=6u ng=6
MPL pl l2 vdd vdd sg13_hv_pmos w=24u l=4u ng=4
MPCL l2 vbpc pl vdd sg13_hv_pmos w=30u l=3u ng=2
MFPL l1 vabp l2 vdd sg13_hv_pmos w=6.66u l=0.6u ng=1
MPR pr l2 vdd vdd sg13_hv_pmos w=24u l=4u ng=4
MPCR a vbpc pr vdd sg13_hv_pmos w=30u l=3u ng=2
MABP b vabp a vdd sg13_hv_pmos w=6.66u l=0.6u ng=1
MABN a vabn b vss sg13_hv_nmos w=4.4u l=1u ng=1
MCY b vbnc y vss sg13_hv_nmos w=30u l=3u ng=2
MSY y vbn vss vss sg13_hv_nmos w=36u l=6u ng=6
MSABP vabp en_3v3 vdd vdd sg13_hv_pmos w=1u l=0.45u ng=1
MSA a en_3v3 vddo vdd sg13_hv_pmos w=1u l=0.45u ng=1
MSABN vabn en_3v3_b vss vss sg13_hv_nmos w=1u l=0.45u ng=1
MSB b en_3v3_b vsso vss sg13_hv_nmos w=1u l=0.45u ng=1
MRP2 vabp vabp dabp vdd sg13_hv_pmos w=6.66u l=0.6u ng=1
MRN2 vabn vabn dabn vss sg13_hv_nmos w=4.4u l=1u ng=1
MMDT[3] vdd vdd vdd vdd sg13_hv_pmos w=20u l=1u ng=2
MDT[2] vdd vdd vdd vdd sg13_hv_pmos w=20u l=1u ng=2
MDT[1] vdd vdd vdd vdd sg13_hv_pmos w=20u l=1u ng=2
MDT[0] vdd vdd vdd vdd sg13_hv_pmos w=20u l=1u ng=2
MMDTL[2] vdd vbp vdd vdd sg13_hv_pmos w=5u l=6u ng=1
MDTL[1] vdd vbp vdd vdd sg13_hv_pmos w=5u l=6u ng=1
MDTL[0] vdd vbp vdd vdd sg13_hv_pmos w=5u l=6u ng=1
MMDL[3] vdd l2 vdd vdd sg13_hv_pmos w=1u l=4u ng=1
MDL[2] vdd l2 vdd vdd sg13_hv_pmos w=1u l=4u ng=1
MDL[1] vdd l2 vdd vdd sg13_hv_pmos w=1u l=4u ng=1
MDL[0] vdd l2 vdd vdd sg13_hv_pmos w=1u l=4u ng=1
MMDPC vdd vbpc vdd vdd sg13_hv_pmos w=1u l=4u ng=1
MMDABP[1] vdd vdd vdd vdd sg13_hv_pmos w=6.66u l=0.6u ng=1
MDABP[0] vdd vdd vdd vdd sg13_hv_pmos w=6.66u l=0.6u ng=1
MMDABN[1] vss vss vss vss sg13_hv_nmos w=4.4u l=1u ng=1
MDABN[0] vss vss vss vss sg13_hv_nmos w=4.4u l=1u ng=1
MMDCN[3] vbnc vbnc vbnc vss sg13_hv_nmos w=2u l=3u ng=1
MDCN[2] vbnc vbnc vbnc vss sg13_hv_nmos w=2u l=3u ng=1
MDCN[1] vbnc vbnc vbnc vss sg13_hv_nmos w=2u l=3u ng=1
MDCN[0] vbnc vbnc vbnc vss sg13_hv_nmos w=2u l=3u ng=1
MMDSK[3] vbn vbn vbn vss sg13_hv_nmos w=2u l=6u ng=1
MDSK[2] vbn vbn vbn vss sg13_hv_nmos w=2u l=6u ng=1
MDSK[1] vbn vbn vbn vss sg13_hv_nmos w=2u l=6u ng=1
MDSK[0] vbn vbn vbn vss sg13_hv_nmos w=2u l=6u ng=1
MMDBNT vbn vbn vbn vss sg13_hv_nmos w=6u l=6u ng=1
RRD[1] vss vss 37.72k $SUB=vss $[rhigh] w=0.5u l=12.65u b=0
RD[0] vss vss 37.72k $SUB=vss $[rhigh] w=0.5u l=12.65u b=0
.ends

* expanding   symbol:  unit_r2.sym # of pins=7
** sym_path: /home/user/c2/BA/work/macros/sg13cmos5l_IOPadDiff2Single/schematic/xschem/unit_r2.sym
** sch_path: /home/user/c2/BA/work/macros/sg13cmos5l_IOPadDiff2Single/schematic/xschem/unit_r2.sch
.subckt unit_r2 x y gp gn vdd vss vbp
*.PININFO x:O y:O gp:I gn:I vdd:B vss:B vbp:I
MTa sa vbp vdd vdd sg13_hv_pmos w=5u l=6u ng=1
MTb sb vbp vdd vdd sg13_hv_pmos w=5u l=6u ng=1
MMa y gp sa sa sg13_hv_pmos w=20u l=1u ng=2
MMb x gn sb sb sg13_hv_pmos w=20u l=1u ng=2
RR[3] sa n1 37.72k $SUB=vss $[rhigh] w=0.5u l=12.65u b=0
R[2] n1 n2 37.72k $SUB=vss $[rhigh] w=0.5u l=12.65u b=0
R[1] n2 n3 37.72k $SUB=vss $[rhigh] w=0.5u l=12.65u b=0
R[0] n3 sb 37.72k $SUB=vss $[rhigh] w=0.5u l=12.65u b=0
.ends
