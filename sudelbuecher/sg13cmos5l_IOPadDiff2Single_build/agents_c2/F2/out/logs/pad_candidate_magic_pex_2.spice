* PEX produced on Tue Nov  3 14:56:24 UTC 2026 using /usr/local/bin/sak-pex.sh with m=2 and s=1
* NGSPICE file created from sg13cmos5l_IOPadDiff2Single.ext - technology: ihp-sg13cmos5l

.subckt sg13cmos5l_IOPadDiff2Single pad
X0 DCNDiode_0.guard d2s_block_0.bias_tree_n_f2_0.vbpc DCNDiode_0.guard DCNDiode_0.guard sg13_hv_pmos ad=0.34p pd=2.68u as=0.90339n ps=3.59803m w=1u l=4u
X1 pad d2s_cma_0.a DCNDiode_0.guard DCNDiode_0.guard sg13_hv_pmos ad=3.9294p pd=7.84u as=2.1312p ps=7.3u w=6.66u l=0.6u
X2 pad Clamp_N_M1_wiring_0.b Clamp_N_M1_1.iovss Clamp_N_M1_1.iovss sg13_hv_nmos ad=2.596p pd=5.58u as=1.408p ps=5.04u w=4.4u l=1u
X3 d2s_block_0.d2s_sp2k_f2_1.core d2s_cma_0.a d2s_block_0.d2s_sp2k_f2_1.core d2s_block_0.d2s_sp2k_f2_1.core sg13_hv_pmos ad=2.7064p pd=16.6u as=40.5004p ps=0.1292m w=7.96u l=32.16u
X4 d2s_block_0.bias_tree_n_f2_0.ni d2s_block_0.en_3v3_b d2s_block_0.iref DCNDiode_0.guard sg13_hv_pmos ad=0.34p pd=2.68u as=0.34p ps=2.68u w=1u l=0.45u
X5 Clamp_N_M1_1.iovss pad dantenna l=1.26u w=67.6u
X6 pad d2s_cma_0.a DCNDiode_0.guard DCNDiode_0.guard sg13_hv_pmos ad=3.9294p pd=7.84u as=2.1312p ps=7.3u w=6.66u l=0.6u
X7 d2s_block_0.sinks_6x6_f2_0.vbn d2s_block_0.sinks_6x6_f2_0.vbn d2s_block_0.sinks_6x6_f2_0.vbn Clamp_N_M1_1.iovss sg13_hv_nmos ad=0.68p pd=4.68u as=31.08205p ps=0.23533m w=2u l=6u
X8 Clamp_N_M1_1.iovss d2s_block_0.en_3v3_b Clamp_N_M1_wiring_0.b Clamp_N_M1_1.iovss sg13_hv_nmos ad=0.34p pd=2.68u as=0.34p ps=2.68u w=1u l=0.45u
X9 d2s_block_0.d2s_sp2k_f2_0.core pad Clamp_N_M1_1.iovss rppd l=7.435u w=1u
X10 DCNDiode_0.guard d2s_cma_0.a pad DCNDiode_0.guard sg13_hv_pmos ad=2.1312p pd=7.3u as=3.9294p ps=7.84u w=6.66u l=0.6u
X11 Clamp_N_M1_1.iovss Clamp_N_M1_wiring_0.b pad Clamp_N_M1_1.iovss sg13_hv_nmos ad=1.408p pd=5.04u as=2.596p ps=5.58u w=4.4u l=1u
X12 Clamp_N_M1_1.iovss d2s_block_0.sinks_6x6_f2_0.vbn d2s_block_0.d2s_casc_n_f2_0.y Clamp_N_M1_1.iovss sg13_hv_nmos ad=2.04p pd=12.68u as=2.04p ps=12.68u w=6u l=6u
X13 d2s_block_0.d2s_ab_n_f2_0.l1 d2s_block_0.bias_tree_n_f2_0.vabp d2s_block_0.d2s_ab_n_f2_0.l2 DCNDiode_0.guard sg13_hv_pmos ad=2.2644p pd=14u as=2.2644p ps=14u w=6.66u l=0.6u
X14 d2s_block_0.d2s_ab_n_f2_0.l1 d2s_block_0.d2s_ab_n_f2_0.vabn d2s_block_0.d2s_ab_n_f2_0.l2 Clamp_N_M1_1.iovss sg13_hv_nmos ad=1.496p pd=9.48u as=1.496p ps=9.48u w=4.4u l=1u
X15 pad d2s_cma_0.a DCNDiode_0.guard DCNDiode_0.guard sg13_hv_pmos ad=3.9294p pd=7.84u as=2.1312p ps=7.3u w=6.66u l=0.6u
X16 pad Clamp_N_M1_wiring_0.b Clamp_N_M1_1.iovss Clamp_N_M1_1.iovss sg13_hv_nmos ad=2.596p pd=5.58u as=1.408p ps=5.04u w=4.4u l=1u
X17 d2s_block_0.d2s_casc_n_f2_0.y d2s_block_0.vref d2s_block_0.d2s_rhigh_f2_0.sa_C2 d2s_block_0.d2s_rhigh_f2_0.sa_C2 sg13_hv_pmos ad=1.9p pd=10.38u as=3.4p ps=20.68u w=10u l=1u
X18 Clamp_N_M1_1.iovss d2s_block_0.sinks_6x6_f2_0.vbn d2s_block_0.d2s_casc_n_f2_0.x Clamp_N_M1_1.iovss sg13_hv_nmos ad=2.04p pd=12.68u as=2.04p ps=12.68u w=6u l=6u
X19 DCNDiode_0.guard d2s_block_0.d2s_ab_n_f2_0.l2 d2s_block_0.d2s_casc_p_c2_0.pr DCNDiode_0.guard sg13_hv_pmos ad=2.04p pd=12.68u as=2.04p ps=12.68u w=6u l=4u
X20 pad d2s_cma_0.a DCNDiode_0.guard DCNDiode_0.guard sg13_hv_pmos ad=3.9294p pd=7.84u as=2.1312p ps=7.3u w=6.66u l=0.6u
X21 pad DCNDiode_0.guard dpantenna l=1.26u w=65.8u
X22 Clamp_N_M1_1.iovss d2s_block_0.d2s_casc_n_f2_0.vbnc d2s_block_0.d2s_casc_n_f2_0.vbnc Clamp_N_M1_1.iovss sg13_hv_nmos ad=0.34p pd=2.68u as=0.34p ps=2.68u w=1u l=8u
X23 pad d2s_cma_0.a DCNDiode_0.guard DCNDiode_0.guard sg13_hv_pmos ad=4.9284p pd=14.8u as=2.1312p ps=7.3u w=6.66u l=0.6u
X24 d2s_block_0.d2s_casc_n_f2_0.x pad d2s_block_0.d2s_rhigh_f2_0.sb_C2 d2s_block_0.d2s_rhigh_f2_0.sb_C2 sg13_hv_pmos ad=1.9p pd=10.38u as=3.4p ps=20.68u w=10u l=1u
X25 Clamp_N_M1_1.iovss Clamp_N_M1_wiring_0.b pad Clamp_N_M1_1.iovss sg13_hv_nmos ad=1.408p pd=5.04u as=2.596p ps=5.58u w=4.4u l=1u
X26 pad d2s_cma_0.a DCNDiode_0.guard DCNDiode_0.guard sg13_hv_pmos ad=3.9294p pd=7.84u as=2.1312p ps=7.3u w=6.66u l=0.6u
X27 pad Clamp_N_M1_wiring_0.b Clamp_N_M1_1.iovss Clamp_N_M1_1.iovss sg13_hv_nmos ad=2.596p pd=5.58u as=1.408p ps=5.04u w=4.4u l=1u
X28 pad Clamp_N_M1_wiring_0.b Clamp_N_M1_1.iovss Clamp_N_M1_1.iovss sg13_hv_nmos ad=2.596p pd=5.58u as=1.408p ps=5.04u w=4.4u l=1u
X29 DCNDiode_0.guard d2s_cma_0.a pad DCNDiode_0.guard sg13_hv_pmos ad=2.1312p pd=7.3u as=3.9294p ps=7.84u w=6.66u l=0.6u
X30 DCNDiode_0.guard d2s_cma_0.a pad DCNDiode_0.guard sg13_hv_pmos ad=2.1312p pd=7.3u as=3.9294p ps=7.84u w=6.66u l=0.6u
X31 d2s_block_0.d2s_casc_p_c2_0.pr d2s_block_0.bias_tree_n_f2_0.vbpc d2s_cma_0.a DCNDiode_0.guard sg13_hv_pmos ad=5.1p pd=30.68u as=5.1p ps=30.68u w=15u l=3u
X32 d2s_block_0.d2s_casc_p_c2_0.pl d2s_block_0.d2s_ab_n_f2_0.l2 DCNDiode_0.guard DCNDiode_0.guard sg13_hv_pmos ad=2.04p pd=12.68u as=2.04p ps=12.68u w=6u l=4u
X33 DCNDiode_0.guard d2s_cma_0.a pad DCNDiode_0.guard sg13_hv_pmos ad=2.1312p pd=7.3u as=3.9294p ps=7.84u w=6.66u l=0.6u
X34 Clamp_N_M1_1.iovss Clamp_N_M1_wiring_0.b pad Clamp_N_M1_1.iovss sg13_hv_nmos ad=1.408p pd=5.04u as=2.596p ps=5.58u w=4.4u l=1u
X35 Clamp_N_M1_1.iovss Clamp_N_M1_wiring_0.b pad Clamp_N_M1_1.iovss sg13_hv_nmos ad=1.408p pd=5.04u as=2.596p ps=5.58u w=4.4u l=1u
X36 Clamp_N_M1_1.iovss Clamp_N_M1_wiring_0.b pad Clamp_N_M1_1.iovss sg13_hv_nmos ad=1.408p pd=5.04u as=2.596p ps=5.58u w=4.4u l=1u
X37 DCNDiode_0.guard d2s_cma_0.a pad DCNDiode_0.guard sg13_hv_pmos ad=2.1312p pd=7.3u as=3.9294p ps=7.84u w=6.66u l=0.6u
X38 pad d2s_cma_0.a DCNDiode_0.guard DCNDiode_0.guard sg13_hv_pmos ad=3.9294p pd=7.84u as=2.1312p ps=7.3u w=6.66u l=0.6u
X39 pad d2s_cma_0.a DCNDiode_0.guard DCNDiode_0.guard sg13_hv_pmos ad=3.9294p pd=7.84u as=2.1312p ps=7.3u w=6.66u l=0.6u
X40 pad Clamp_N_M1_wiring_0.b Clamp_N_M1_1.iovss Clamp_N_M1_1.iovss sg13_hv_nmos ad=2.596p pd=5.58u as=1.408p ps=5.04u w=4.4u l=1u
X41 DCNDiode_0.guard d2s_block_0.d2s_ab_n_f2_0.l2 d2s_block_0.d2s_casc_p_c2_0.pr DCNDiode_0.guard sg13_hv_pmos ad=2.04p pd=12.68u as=2.04p ps=12.68u w=6u l=4u
X42 pad Clamp_N_M1_wiring_0.b Clamp_N_M1_1.iovss Clamp_N_M1_1.iovss sg13_hv_nmos ad=2.596p pd=5.58u as=1.408p ps=5.04u w=4.4u l=1u
X43 DCNDiode_0.guard d2s_cma_0.a pad DCNDiode_0.guard sg13_hv_pmos ad=2.1312p pd=7.3u as=3.9294p ps=7.84u w=6.66u l=0.6u
X44 DCNDiode_0.guard d2s_block_0.bias_tree_n_f2_0.vbp d2s_block_0.d2s_ab_n_f2_0.vabn DCNDiode_0.guard sg13_hv_pmos ad=1.7p pd=10.68u as=1.7p ps=10.68u w=5u l=6u
X45 a_10598_32196# a_10462_29580# Clamp_N_M1_1.iovss rhigh l=12.65u w=0.5u
X46 DCNDiode_0.guard d2s_block_0.bias_tree_n_f2_0.vbpc d2s_block_0.bias_tree_n_f2_0.vbpc DCNDiode_0.guard sg13_hv_pmos ad=0.34p pd=2.68u as=0.34p ps=2.68u w=1u l=4u
X47 pad d2s_cma_0.a DCNDiode_0.guard DCNDiode_0.guard sg13_hv_pmos ad=3.9294p pd=7.84u as=2.1312p ps=7.3u w=6.66u l=0.6u
X48 Clamp_N_M1_1.iovss Clamp_N_M1_wiring_0.b pad Clamp_N_M1_1.iovss sg13_hv_nmos ad=1.408p pd=5.04u as=2.596p ps=5.58u w=4.4u l=1u
X49 Clamp_N_M1_1.iovss d2s_block_0.bias_tree_n_f2_0.ni d2s_block_0.bias_tree_n_f2_0.vbp Clamp_N_M1_1.iovss sg13_hv_nmos ad=2.04p pd=12.68u as=2.04p ps=12.68u w=6u l=6u
X50 Clamp_N_M1_1.iovss d2s_block_0.bias_tree_n_f2_0.ni d2s_block_0.bias_tree_n_f2_0.ni Clamp_N_M1_1.iovss sg13_hv_nmos ad=2.04p pd=12.68u as=2.04p ps=12.68u w=6u l=6u
X51 pad Clamp_N_M1_wiring_0.b Clamp_N_M1_1.iovss Clamp_N_M1_1.iovss sg13_hv_nmos ad=2.596p pd=5.58u as=1.408p ps=5.04u w=4.4u l=1u
X52 Clamp_N_M1_wiring_0.b d2s_block_0.d2s_sp2k_f2_0.core Clamp_N_M1_wiring_0.b Clamp_N_M1_wiring_0.b sg13_hv_pmos ad=2.7064p pd=16.6u as=0.35189n ps=1.20463m w=7.96u l=32.16u
X53 d2s_block_0.sinks_6x6_f2_0.vbn d2s_block_0.sinks_6x6_f2_0.vbn d2s_block_0.sinks_6x6_f2_0.vbn Clamp_N_M1_1.iovss sg13_hv_nmos ad=0.68p pd=4.68u as=0 ps=0 w=2u l=6u
X54 d2s_block_0.d2s_casc_p_c2_0.pl d2s_block_0.d2s_ab_n_f2_0.l2 DCNDiode_0.guard DCNDiode_0.guard sg13_hv_pmos ad=2.04p pd=12.68u as=2.04p ps=12.68u w=6u l=4u
X55 DCNDiode_0.guard d2s_cma_0.a pad DCNDiode_0.guard sg13_hv_pmos ad=2.1312p pd=7.3u as=3.9294p ps=7.84u w=6.66u l=0.6u
X56 pad Clamp_N_M1_wiring_0.b Clamp_N_M1_1.iovss Clamp_N_M1_1.iovss sg13_hv_nmos ad=2.596p pd=5.58u as=1.408p ps=5.04u w=4.4u l=1u
X57 pad d2s_cma_0.a DCNDiode_0.guard DCNDiode_0.guard sg13_hv_pmos ad=3.9294p pd=7.84u as=2.1312p ps=7.3u w=6.66u l=0.6u
X58 DCNDiode_0.guard d2s_cma_0.a pad DCNDiode_0.guard sg13_hv_pmos ad=2.1312p pd=7.3u as=3.9294p ps=7.84u w=6.66u l=0.6u
X59 Clamp_N_M1_1.iovss Clamp_N_M1_wiring_0.b pad Clamp_N_M1_1.iovss sg13_hv_nmos ad=1.408p pd=5.04u as=2.596p ps=5.58u w=4.4u l=1u
X60 Clamp_N_M1_1.iovss d2s_block_0.d2s_sp2k_f2_1.core dantenna l=3.1u w=0.64u
X61 d2s_block_0.d2s_rhigh_f2_0.sb_A d2s_block_0.bias_tree_n_f2_0.vbp DCNDiode_0.guard DCNDiode_0.guard sg13_hv_pmos ad=1.7p pd=10.68u as=1.7p ps=10.68u w=5u l=6u
X62 Clamp_N_M1_1.iovss d2s_block_0.sinks_6x6_f2_0.vbn d2s_block_0.d2s_casc_n_f2_0.y Clamp_N_M1_1.iovss sg13_hv_nmos ad=2.04p pd=12.68u as=2.04p ps=12.68u w=6u l=6u
X63 d2s_block_0.d2s_rhigh_f2_0.sa_B d2s_block_0.vref d2s_block_0.d2s_casc_n_f2_0.y d2s_block_0.d2s_rhigh_f2_0.sa_B sg13_hv_pmos ad=3.4p pd=20.68u as=1.9p ps=10.38u w=10u l=1u
X64 d2s_block_0.d2s_casc_n_f2_0.y d2s_block_0.vref d2s_block_0.d2s_rhigh_f2_0.sa_C1 d2s_block_0.d2s_rhigh_f2_0.sa_C1 sg13_hv_pmos ad=1.9p pd=10.38u as=3.4p ps=20.68u w=10u l=1u
X65 d2s_block_0.d2s_casc_n_f2_0.y d2s_block_0.sinks_6x6_f2_0.vbn Clamp_N_M1_1.iovss Clamp_N_M1_1.iovss sg13_hv_nmos ad=2.04p pd=12.68u as=2.04p ps=12.68u w=6u l=6u
X66 DCNDiode_0.guard d2s_cma_0.a pad DCNDiode_0.guard sg13_hv_pmos ad=2.1312p pd=7.3u as=3.9294p ps=7.84u w=6.66u l=0.6u
X67 pad d2s_cma_0.a DCNDiode_0.guard DCNDiode_0.guard sg13_hv_pmos ad=3.9294p pd=7.84u as=2.1312p ps=7.3u w=6.66u l=0.6u
X68 DCNDiode_0.guard d2s_block_0.bias_tree_n_f2_0.vbp DCNDiode_0.guard DCNDiode_0.guard sg13_hv_pmos ad=0.68p pd=4.68u as=0 ps=0 w=2u l=6u
X69 d2s_block_0.bias_tree_n_f2_0.ni d2s_block_0.en_3v3 d2s_block_0.iref Clamp_N_M1_1.iovss sg13_hv_nmos ad=0.34p pd=2.68u as=0.34p ps=2.68u w=1u l=0.45u
X70 pad Clamp_N_M1_wiring_0.b Clamp_N_M1_1.iovss Clamp_N_M1_1.iovss sg13_hv_nmos ad=2.596p pd=5.58u as=1.408p ps=5.04u w=4.4u l=1u
X71 DCNDiode_0.guard d2s_block_0.en_3v3 d2s_cma_0.a DCNDiode_0.guard sg13_hv_pmos ad=0.34p pd=2.68u as=0.34p ps=2.68u w=1u l=0.45u
X72 pad DCNDiode_0.guard dpantenna l=1.26u w=65.8u
X73 d2s_block_0.bias_tree_n_f2_0.ni d2s_block_0.en_3v3_b Clamp_N_M1_1.iovss Clamp_N_M1_1.iovss sg13_hv_nmos ad=0.34p pd=2.68u as=0.34p ps=2.68u w=1u l=0.45u
X74 d2s_block_0.d2s_sp2k_f2_1.core pad Clamp_N_M1_1.iovss rppd l=7.435u w=1u
X75 DCNDiode_0.guard d2s_cma_0.a pad DCNDiode_0.guard sg13_hv_pmos ad=2.1312p pd=7.3u as=3.9294p ps=7.84u w=6.66u l=0.6u
X76 Clamp_N_M1_1.iovss Clamp_N_M1_wiring_0.b pad Clamp_N_M1_1.iovss sg13_hv_nmos ad=1.408p pd=5.04u as=2.596p ps=5.58u w=4.4u l=1u
X77 Clamp_N_M1_1.iovss Clamp_N_M1_wiring_0.b pad Clamp_N_M1_1.iovss sg13_hv_nmos ad=1.408p pd=5.04u as=2.596p ps=5.58u w=4.4u l=1u
X78 DCNDiode_0.guard d2s_cma_0.a pad DCNDiode_0.guard sg13_hv_pmos ad=2.1312p pd=7.3u as=3.9294p ps=7.84u w=6.66u l=0.6u
X79 d2s_block_0.d2s_rhigh_f2_0.sb_C1 pad d2s_block_0.d2s_casc_n_f2_0.x d2s_block_0.d2s_rhigh_f2_0.sb_C1 sg13_hv_pmos ad=3.4p pd=20.68u as=1.9p ps=10.38u w=10u l=1u
X80 a_9510_32196# d2s_block_0.d2s_rhigh_f2_0.sa_A Clamp_N_M1_1.iovss rhigh l=12.65u w=0.5u
X81 DCNDiode_0.guard DCNDiode_0.guard DCNDiode_0.guard DCNDiode_0.guard sg13_hv_pmos ad=3.4p pd=20.68u as=0 ps=0 w=10u l=1u
X82 DCNDiode_0.guard d2s_block_0.bias_tree_n_f2_0.vbp DCNDiode_0.guard DCNDiode_0.guard sg13_hv_pmos ad=1.7p pd=10.68u as=0 ps=0 w=5u l=6u
X83 Clamp_N_M1_1.iovss Clamp_N_M1_wiring_0.b pad Clamp_N_M1_1.iovss sg13_hv_nmos ad=1.408p pd=5.04u as=2.596p ps=5.58u w=4.4u l=1u
X84 d2s_block_0.d2s_ab_n_f2_0.l2 d2s_block_0.bias_tree_n_f2_0.vbpc d2s_block_0.d2s_casc_p_c2_0.pl DCNDiode_0.guard sg13_hv_pmos ad=5.1p pd=30.68u as=5.1p ps=30.68u w=15u l=3u
X85 pad d2s_cma_0.a DCNDiode_0.guard DCNDiode_0.guard sg13_hv_pmos ad=3.9294p pd=7.84u as=2.1312p ps=7.3u w=6.66u l=0.6u
X86 DCNDiode_0.guard d2s_cma_0.a pad DCNDiode_0.guard sg13_hv_pmos ad=2.1312p pd=7.3u as=3.9294p ps=7.84u w=6.66u l=0.6u
X87 DCNDiode_0.guard DCNDiode_0.guard DCNDiode_0.guard DCNDiode_0.guard sg13_hv_pmos ad=2.2644p pd=14u as=0 ps=0 w=6.66u l=0.6u
X88 Clamp_N_M1_1.iovss Clamp_N_M1_wiring_0.b pad Clamp_N_M1_1.iovss sg13_hv_nmos ad=1.408p pd=5.04u as=2.596p ps=5.58u w=4.4u l=1u
X89 pad Clamp_N_M1_wiring_0.b Clamp_N_M1_1.iovss Clamp_N_M1_1.iovss sg13_hv_nmos ad=2.596p pd=5.58u as=2.068p ps=9.74u w=4.4u l=1u
X90 pad Clamp_N_M1_wiring_0.b Clamp_N_M1_1.iovss Clamp_N_M1_1.iovss sg13_hv_nmos ad=2.596p pd=5.58u as=1.408p ps=5.04u w=4.4u l=1u
X91 Clamp_N_M1_1.iovss d2s_block_0.bias_tree_n_f2_0.ni d2s_block_0.bias_tree_n_f2_0.vbpc Clamp_N_M1_1.iovss sg13_hv_nmos ad=0.816p pd=5.48u as=0.816p ps=5.48u w=2.4u l=6u
X92 a_10734_32196# d2s_block_0.d2s_rhigh_f2_0.sb_B Clamp_N_M1_1.iovss rhigh l=12.65u w=0.5u
X93 Clamp_P_M1_wiring_0.dabp d2s_block_0.bias_tree_n_f2_0.vabp d2s_block_0.bias_tree_n_f2_0.vabp DCNDiode_0.guard sg13_hv_pmos ad=2.2644p pd=14u as=2.2644p ps=14u w=6.66u l=0.6u
X94 pad d2s_cma_0.a DCNDiode_0.guard DCNDiode_0.guard sg13_hv_pmos ad=3.9294p pd=7.84u as=2.1312p ps=7.3u w=6.66u l=0.6u
X95 d2s_block_0.d2s_rhigh_f2_0.sa_C1 d2s_block_0.bias_tree_n_f2_0.vbp DCNDiode_0.guard DCNDiode_0.guard sg13_hv_pmos ad=1.7p pd=10.68u as=1.7p ps=10.68u w=5u l=6u
X96 a_11006_32196# a_10054_29580# Clamp_N_M1_1.iovss rhigh l=12.65u w=0.5u
X97 pad d2s_cma_0.a DCNDiode_0.guard DCNDiode_0.guard sg13_hv_pmos ad=3.9294p pd=7.84u as=2.1312p ps=7.3u w=6.66u l=0.6u
X98 Clamp_N_M1_1.iovss Clamp_N_M1_wiring_0.b pad Clamp_N_M1_1.iovss sg13_hv_nmos ad=1.408p pd=5.04u as=2.596p ps=5.58u w=4.4u l=1u
X99 Clamp_N_M1_1.iovss Clamp_N_M1_wiring_0.b pad Clamp_N_M1_1.iovss sg13_hv_nmos ad=1.408p pd=5.04u as=2.596p ps=5.58u w=4.4u l=1u
X100 DCNDiode_0.guard d2s_cma_0.a pad DCNDiode_0.guard sg13_hv_pmos ad=2.1312p pd=7.3u as=3.9294p ps=7.84u w=6.66u l=0.6u
X101 DCNDiode_0.guard d2s_block_0.bias_tree_n_f2_0.vbp d2s_block_0.sinks_6x6_f2_0.vbn DCNDiode_0.guard sg13_hv_pmos ad=1.7p pd=10.68u as=1.7p ps=10.68u w=5u l=6u
X102 d2s_block_0.d2s_rhigh_f2_0.sb_A d2s_block_0.vref d2s_block_0.d2s_casc_n_f2_0.x d2s_block_0.d2s_rhigh_f2_0.sb_A sg13_hv_pmos ad=3.4p pd=20.68u as=1.9p ps=10.38u w=10u l=1u
X103 Clamp_N_M1_wiring_0.b d2s_block_0.d2s_ab_n_f2_0.vabn d2s_cma_0.a Clamp_N_M1_1.iovss sg13_hv_nmos ad=1.496p pd=9.48u as=1.496p ps=9.48u w=4.4u l=1u
X104 pad Clamp_N_M1_wiring_0.b Clamp_N_M1_1.iovss Clamp_N_M1_1.iovss sg13_hv_nmos ad=3.256p pd=10.28u as=1.408p ps=5.04u w=4.4u l=1u
X105 d2s_block_0.d2s_casc_n_f2_0.y d2s_block_0.vinp d2s_block_0.d2s_rhigh_f2_0.sa_A d2s_block_0.d2s_rhigh_f2_0.sa_A sg13_hv_pmos ad=1.9p pd=10.38u as=3.4p ps=20.68u w=10u l=1u
X106 pad Clamp_N_M1_wiring_0.b Clamp_N_M1_1.iovss Clamp_N_M1_1.iovss sg13_hv_nmos ad=2.596p pd=5.58u as=1.408p ps=5.04u w=4.4u l=1u
X107 d2s_block_0.d2s_casc_n_f2_0.y d2s_block_0.sinks_6x6_f2_0.vbn Clamp_N_M1_1.iovss Clamp_N_M1_1.iovss sg13_hv_nmos ad=2.04p pd=12.68u as=2.04p ps=12.68u w=6u l=6u
X108 DCNDiode_0.guard d2s_cma_0.a pad DCNDiode_0.guard sg13_hv_pmos ad=2.1312p pd=7.3u as=3.9294p ps=7.84u w=6.66u l=0.6u
X109 d2s_block_0.sinks_6x6_f2_0.vbn d2s_block_0.sinks_6x6_f2_0.vbn d2s_block_0.sinks_6x6_f2_0.vbn Clamp_N_M1_1.iovss sg13_hv_nmos ad=2.04p pd=12.68u as=0 ps=0 w=6u l=6u
X110 d2s_block_0.sinks_6x6_f2_0.vbn d2s_block_0.sinks_6x6_f2_0.vbn d2s_block_0.sinks_6x6_f2_0.vbn Clamp_N_M1_1.iovss sg13_hv_nmos ad=0.68p pd=4.68u as=0 ps=0 w=2u l=6u
X111 Clamp_N_M1_1.iovss Clamp_N_M1_wiring_0.b pad Clamp_N_M1_1.iovss sg13_hv_nmos ad=1.408p pd=5.04u as=2.596p ps=5.58u w=4.4u l=1u
X112 d2s_block_0.d2s_casc_n_f2_0.vbnc d2s_block_0.d2s_casc_n_f2_0.vbnc d2s_block_0.d2s_casc_n_f2_0.vbnc Clamp_N_M1_1.iovss sg13_hv_nmos ad=0.68p pd=4.68u as=19.07282p ps=0.15628m w=2u l=3u
X113 Clamp_N_M1_1.iovss Clamp_N_M1_1.iovss Clamp_N_M1_1.iovss Clamp_N_M1_1.iovss sg13_hv_nmos ad=1.496p pd=9.48u as=0.8943n ps=3.44684m w=4.4u l=1u
X114 d2s_block_0.d2s_sp2k_f2_0.core DCNDiode_0.guard dpantenna l=0.64u w=4.98u
X115 DCNDiode_0.guard d2s_cma_0.a pad DCNDiode_0.guard sg13_hv_pmos ad=2.1312p pd=7.3u as=3.9294p ps=7.84u w=6.66u l=0.6u
X116 DCNDiode_0.guard Clamp_P_M1_wiring_0.dabp Clamp_P_M1_wiring_0.dabp DCNDiode_0.guard sg13_hv_pmos ad=2.1312p pd=7.3u as=3.9294p ps=7.84u w=6.66u l=0.6u
X117 DCNDiode_0.guard d2s_block_0.d2s_ab_n_f2_0.l2 DCNDiode_0.guard DCNDiode_0.guard sg13_hv_pmos ad=0.34p pd=2.68u as=0 ps=0 w=1u l=4u
X118 pad d2s_cma_0.a DCNDiode_0.guard DCNDiode_0.guard sg13_hv_pmos ad=3.9294p pd=7.84u as=2.1312p ps=7.3u w=6.66u l=0.6u
X119 DCNDiode_0.guard d2s_cma_0.a pad DCNDiode_0.guard sg13_hv_pmos ad=2.1312p pd=7.3u as=3.9294p ps=7.84u w=6.66u l=0.6u
X120 d2s_block_0.d2s_rhigh_f2_0.sa_C2 d2s_block_0.vref d2s_block_0.d2s_casc_n_f2_0.y d2s_block_0.d2s_rhigh_f2_0.sa_C2 sg13_hv_pmos ad=3.4p pd=20.68u as=1.9p ps=10.38u w=10u l=1u
X121 d2s_block_0.d2s_rhigh_f2_0.sa_C2 d2s_block_0.bias_tree_n_f2_0.vbp DCNDiode_0.guard DCNDiode_0.guard sg13_hv_pmos ad=1.7p pd=10.68u as=1.7p ps=10.68u w=5u l=6u
X122 d2s_block_0.d2s_rhigh_f2_0.sa_A d2s_block_0.vinp d2s_block_0.d2s_casc_n_f2_0.y d2s_block_0.d2s_rhigh_f2_0.sa_A sg13_hv_pmos ad=3.4p pd=20.68u as=1.9p ps=10.38u w=10u l=1u
X123 Clamp_N_M1_wiring_0.b d2s_block_0.d2s_casc_n_f2_0.vbnc d2s_block_0.d2s_casc_n_f2_0.y Clamp_N_M1_1.iovss sg13_hv_nmos ad=5.1p pd=30.68u as=5.1p ps=30.68u w=15u l=3u
X124 Clamp_N_M1_1.iovss Clamp_N_M1_wiring_0.b pad Clamp_N_M1_1.iovss sg13_hv_nmos ad=1.408p pd=5.04u as=2.596p ps=5.58u w=4.4u l=1u
X125 DCNDiode_0.guard DCNDiode_0.guard DCNDiode_0.guard DCNDiode_0.guard sg13_hv_pmos ad=3.4p pd=20.68u as=0 ps=0 w=10u l=1u
X126 Clamp_N_M1_1.iovss d2s_block_0.sinks_6x6_f2_0.vbn d2s_block_0.d2s_casc_n_f2_0.x Clamp_N_M1_1.iovss sg13_hv_nmos ad=2.04p pd=12.68u as=2.04p ps=12.68u w=6u l=6u
X127 pad d2s_cma_0.a DCNDiode_0.guard DCNDiode_0.guard sg13_hv_pmos ad=3.9294p pd=7.84u as=2.1312p ps=7.3u w=6.66u l=0.6u
X128 pad Clamp_N_M1_wiring_0.b Clamp_N_M1_1.iovss Clamp_N_M1_1.iovss sg13_hv_nmos ad=2.596p pd=5.58u as=1.408p ps=5.04u w=4.4u l=1u
X129 pad Clamp_N_M1_wiring_0.b Clamp_N_M1_1.iovss Clamp_N_M1_1.iovss sg13_hv_nmos ad=2.596p pd=5.58u as=1.408p ps=5.04u w=4.4u l=1u
X130 DCNDiode_0.guard d2s_cma_0.a pad DCNDiode_0.guard sg13_hv_pmos ad=2.1312p pd=7.3u as=3.9294p ps=7.84u w=6.66u l=0.6u
X131 pad d2s_cma_0.a DCNDiode_0.guard DCNDiode_0.guard sg13_hv_pmos ad=3.9294p pd=7.84u as=2.1312p ps=7.3u w=6.66u l=0.6u
X132 pad Clamp_N_M1_wiring_0.b Clamp_N_M1_1.iovss Clamp_N_M1_1.iovss sg13_hv_nmos ad=2.596p pd=5.58u as=1.408p ps=5.04u w=4.4u l=1u
X133 a_10598_32196# d2s_block_0.d2s_rhigh_f2_0.sb_A Clamp_N_M1_1.iovss rhigh l=12.65u w=0.5u
X134 DCNDiode_0.guard d2s_block_0.d2s_ab_n_f2_0.l2 DCNDiode_0.guard DCNDiode_0.guard sg13_hv_pmos ad=0.34p pd=2.68u as=0 ps=0 w=1u l=4u
X135 DCNDiode_0.guard d2s_cma_0.a pad DCNDiode_0.guard sg13_hv_pmos ad=2.1312p pd=7.3u as=3.9294p ps=7.84u w=6.66u l=0.6u
X136 pad d2s_cma_0.a DCNDiode_0.guard DCNDiode_0.guard sg13_hv_pmos ad=3.9294p pd=7.84u as=3.1302p ps=14.26u w=6.66u l=0.6u
X137 DCNDiode_0.guard d2s_block_0.bias_tree_n_f2_0.vbp DCNDiode_0.guard DCNDiode_0.guard sg13_hv_pmos ad=1.7p pd=10.68u as=0 ps=0 w=5u l=6u
X138 a_11006_32196# d2s_block_0.d2s_rhigh_f2_0.sb_C2 Clamp_N_M1_1.iovss rhigh l=12.65u w=0.5u
X139 Clamp_N_M1_1.iovss Clamp_N_M1_wiring_0.b pad Clamp_N_M1_1.iovss sg13_hv_nmos ad=1.408p pd=5.04u as=2.596p ps=5.58u w=4.4u l=1u
X140 Clamp_N_M1_1.iovss Clamp_N_M1_wiring_0.b pad Clamp_N_M1_1.iovss sg13_hv_nmos ad=1.408p pd=5.04u as=2.596p ps=5.58u w=4.4u l=1u
X141 Clamp_N_M1_1.iovss Clamp_N_M1_wiring_0.b pad Clamp_N_M1_1.iovss sg13_hv_nmos ad=1.408p pd=5.04u as=2.596p ps=5.58u w=4.4u l=1u
X142 pad d2s_cma_0.a DCNDiode_0.guard DCNDiode_0.guard sg13_hv_pmos ad=3.9294p pd=7.84u as=2.1312p ps=7.3u w=6.66u l=0.6u
X143 pad Clamp_N_M1_wiring_0.b Clamp_N_M1_1.iovss Clamp_N_M1_1.iovss sg13_hv_nmos ad=2.596p pd=5.58u as=1.408p ps=5.04u w=4.4u l=1u
X144 d2s_block_0.d2s_casc_n_f2_0.vbnc d2s_block_0.d2s_casc_n_f2_0.vbnc d2s_block_0.d2s_casc_n_f2_0.vbnc Clamp_N_M1_1.iovss sg13_hv_nmos ad=0.68p pd=4.68u as=0 ps=0 w=2u l=3u
X145 pad Clamp_N_M1_wiring_0.b Clamp_N_M1_1.iovss Clamp_N_M1_1.iovss sg13_hv_nmos ad=2.596p pd=5.58u as=1.408p ps=5.04u w=4.4u l=1u
X146 DCNDiode_0.guard DCNDiode_0.guard DCNDiode_0.guard DCNDiode_0.guard sg13_hv_pmos ad=1.9p pd=10.38u as=0 ps=0 w=10u l=1u
X147 DCNDiode_0.guard d2s_cma_0.a pad DCNDiode_0.guard sg13_hv_pmos ad=2.1312p pd=7.3u as=3.9294p ps=7.84u w=6.66u l=0.6u
X148 d2s_block_0.d2s_casc_n_f2_0.x d2s_block_0.vinn d2s_block_0.d2s_rhigh_f2_0.sb_B d2s_block_0.d2s_rhigh_f2_0.sb_B sg13_hv_pmos ad=1.9p pd=10.38u as=3.4p ps=20.68u w=10u l=1u
X149 DCNDiode_0.guard d2s_block_0.d2s_ab_n_f2_0.l2 d2s_block_0.d2s_casc_p_c2_0.pl DCNDiode_0.guard sg13_hv_pmos ad=2.04p pd=12.68u as=2.04p ps=12.68u w=6u l=4u
X150 DCNDiode_0.guard d2s_cma_0.a pad DCNDiode_0.guard sg13_hv_pmos ad=2.1312p pd=7.3u as=3.9294p ps=7.84u w=6.66u l=0.6u
X151 DCNDiode_0.guard Clamp_P_M1_wiring_0.dabp Clamp_P_M1_wiring_0.dabp DCNDiode_0.guard sg13_hv_pmos ad=2.1312p pd=7.3u as=3.9294p ps=7.84u w=6.66u l=0.6u
X152 Clamp_N_M1_1.iovss Clamp_N_M1_wiring_0.b pad Clamp_N_M1_1.iovss sg13_hv_nmos ad=1.408p pd=5.04u as=2.596p ps=5.58u w=4.4u l=1u
X153 DCNDiode_0.guard d2s_block_0.bias_tree_n_f2_0.vbp d2s_block_0.d2s_rhigh_f2_0.sa_B DCNDiode_0.guard sg13_hv_pmos ad=1.7p pd=10.68u as=1.7p ps=10.68u w=5u l=6u
X154 a_9918_32196# d2s_block_0.d2s_rhigh_f2_0.sa_C2 Clamp_N_M1_1.iovss rhigh l=12.65u w=0.5u
X155 d2s_block_0.d2s_casc_n_f2_0.x d2s_block_0.d2s_casc_n_f2_0.vbnc d2s_block_0.d2s_ab_n_f2_0.l1 Clamp_N_M1_1.iovss sg13_hv_nmos ad=5.1p pd=30.68u as=5.1p ps=30.68u w=15u l=3u
X156 pad d2s_cma_0.a DCNDiode_0.guard DCNDiode_0.guard sg13_hv_pmos ad=3.9294p pd=7.84u as=2.1312p ps=7.3u w=6.66u l=0.6u
X157 pad Clamp_N_M1_wiring_0.b Clamp_N_M1_1.iovss Clamp_N_M1_1.iovss sg13_hv_nmos ad=2.596p pd=5.58u as=1.408p ps=5.04u w=4.4u l=1u
X158 pad Clamp_N_M1_wiring_0.b Clamp_N_M1_1.iovss Clamp_N_M1_1.iovss sg13_hv_nmos ad=2.596p pd=5.58u as=1.408p ps=5.04u w=4.4u l=1u
X159 d2s_block_0.d2s_casc_n_f2_0.y d2s_block_0.vref d2s_block_0.d2s_rhigh_f2_0.sa_B d2s_block_0.d2s_rhigh_f2_0.sa_B sg13_hv_pmos ad=1.9p pd=10.38u as=3.4p ps=20.68u w=10u l=1u
X160 d2s_block_0.d2s_sp2k_f2_1.core DCNDiode_0.guard dpantenna l=0.64u w=4.98u
X161 DCNDiode_0.guard d2s_cma_0.a pad DCNDiode_0.guard sg13_hv_pmos ad=2.1312p pd=7.3u as=3.9294p ps=7.84u w=6.66u l=0.6u
X162 d2s_block_0.d2s_ab_n_f2_0.l1 d2s_block_0.d2s_casc_n_f2_0.vbnc d2s_block_0.d2s_casc_n_f2_0.x Clamp_N_M1_1.iovss sg13_hv_nmos ad=5.1p pd=30.68u as=5.1p ps=30.68u w=15u l=3u
X163 DCNDiode_0.guard d2s_cma_0.a pad DCNDiode_0.guard sg13_hv_pmos ad=2.1312p pd=7.3u as=3.9294p ps=7.84u w=6.66u l=0.6u
X164 Clamp_N_M1_1.iovss Clamp_N_M1_wiring_0.b pad Clamp_N_M1_1.iovss sg13_hv_nmos ad=1.408p pd=5.04u as=2.596p ps=5.58u w=4.4u l=1u
X165 d2s_block_0.d2s_rhigh_f2_0.sb_B d2s_block_0.bias_tree_n_f2_0.vbp DCNDiode_0.guard DCNDiode_0.guard sg13_hv_pmos ad=1.7p pd=10.68u as=1.7p ps=10.68u w=5u l=6u
X166 d2s_block_0.d2s_casc_p_c2_0.pr d2s_block_0.d2s_ab_n_f2_0.l2 DCNDiode_0.guard DCNDiode_0.guard sg13_hv_pmos ad=2.04p pd=12.68u as=2.04p ps=12.68u w=6u l=4u
X167 Clamp_N_M1_1.iovss Clamp_N_M1_wiring_0.b pad Clamp_N_M1_1.iovss sg13_hv_nmos ad=1.408p pd=5.04u as=2.596p ps=5.58u w=4.4u l=1u
X168 pad d2s_cma_0.a DCNDiode_0.guard DCNDiode_0.guard sg13_hv_pmos ad=3.9294p pd=7.84u as=3.1302p ps=14.26u w=6.66u l=0.6u
X169 Clamp_N_M1_wiring_0.dabn Clamp_N_M1_wiring_0.dabn Clamp_N_M1_1.iovss Clamp_N_M1_1.iovss sg13_hv_nmos ad=2.596p pd=5.58u as=1.408p ps=5.04u w=4.4u l=1u
X170 DCNDiode_0.guard d2s_cma_0.a pad DCNDiode_0.guard sg13_hv_pmos ad=2.1312p pd=7.3u as=3.9294p ps=7.84u w=6.66u l=0.6u
X171 d2s_block_0.d2s_casc_n_f2_0.x d2s_block_0.sinks_6x6_f2_0.vbn Clamp_N_M1_1.iovss Clamp_N_M1_1.iovss sg13_hv_nmos ad=2.04p pd=12.68u as=2.04p ps=12.68u w=6u l=6u
X172 a_10734_32196# a_10326_29580# Clamp_N_M1_1.iovss rhigh l=12.65u w=0.5u
X173 d2s_block_0.d2s_rhigh_f2_0.sb_B d2s_block_0.vinn d2s_block_0.d2s_casc_n_f2_0.x d2s_block_0.d2s_rhigh_f2_0.sb_B sg13_hv_pmos ad=3.4p pd=20.68u as=1.9p ps=10.38u w=10u l=1u
X174 pad d2s_cma_0.a DCNDiode_0.guard DCNDiode_0.guard sg13_hv_pmos ad=3.9294p pd=7.84u as=2.1312p ps=7.3u w=6.66u l=0.6u
X175 DCNDiode_0.guard d2s_block_0.bias_tree_n_f2_0.vbp d2s_block_0.d2s_casc_n_f2_0.vbnc DCNDiode_0.guard sg13_hv_pmos ad=0.68p pd=4.68u as=0.68p ps=4.68u w=2u l=6u
X176 a_9646_32196# a_10326_29580# Clamp_N_M1_1.iovss rhigh l=12.65u w=0.5u
X177 pad d2s_cma_0.a DCNDiode_0.guard DCNDiode_0.guard sg13_hv_pmos ad=3.9294p pd=7.84u as=2.1312p ps=7.3u w=6.66u l=0.6u
X178 DCNDiode_0.guard d2s_block_0.d2s_ab_n_f2_0.l2 d2s_block_0.d2s_casc_p_c2_0.pl DCNDiode_0.guard sg13_hv_pmos ad=2.04p pd=12.68u as=2.04p ps=12.68u w=6u l=4u
X179 d2s_block_0.d2s_casc_p_c2_0.pl d2s_block_0.bias_tree_n_f2_0.vbpc d2s_block_0.d2s_ab_n_f2_0.l2 DCNDiode_0.guard sg13_hv_pmos ad=5.1p pd=30.68u as=5.1p ps=30.68u w=15u l=3u
X180 Clamp_N_M1_1.iovss d2s_block_0.sinks_6x6_f2_0.vbn d2s_block_0.d2s_casc_n_f2_0.x Clamp_N_M1_1.iovss sg13_hv_nmos ad=2.04p pd=12.68u as=2.04p ps=12.68u w=6u l=6u
X181 pad Clamp_N_M1_wiring_0.b Clamp_N_M1_1.iovss Clamp_N_M1_1.iovss sg13_hv_nmos ad=2.596p pd=5.58u as=1.408p ps=5.04u w=4.4u l=1u
X182 DCNDiode_0.guard d2s_block_0.bias_tree_n_f2_0.vbp DCNDiode_0.guard DCNDiode_0.guard sg13_hv_pmos ad=1.7p pd=10.68u as=0 ps=0 w=5u l=6u
X183 Clamp_N_M1_1.iovss d2s_block_0.sinks_6x6_f2_0.vbn d2s_block_0.sinks_6x6_f2_0.vbn Clamp_N_M1_1.iovss sg13_hv_nmos ad=2.04p pd=12.68u as=2.04p ps=12.68u w=6u l=6u
X184 d2s_block_0.d2s_ab_n_f2_0.vabn d2s_block_0.en_3v3_b Clamp_N_M1_1.iovss Clamp_N_M1_1.iovss sg13_hv_nmos ad=0.34p pd=2.68u as=0.34p ps=2.68u w=1u l=0.45u
X185 DCNDiode_0.guard d2s_cma_0.a pad DCNDiode_0.guard sg13_hv_pmos ad=2.1312p pd=7.3u as=3.9294p ps=7.84u w=6.66u l=0.6u
X186 pad d2s_cma_0.a DCNDiode_0.guard DCNDiode_0.guard sg13_hv_pmos ad=3.9294p pd=7.84u as=2.1312p ps=7.3u w=6.66u l=0.6u
X187 d2s_block_0.bias_tree_n_f2_0.ni d2s_block_0.bias_tree_n_f2_0.ni d2s_block_0.bias_tree_n_f2_0.ni Clamp_N_M1_1.iovss sg13_hv_nmos ad=0.816p pd=5.48u as=8.86665p ps=64.93u w=2.4u l=6u
X188 d2s_block_0.d2s_casc_p_c2_0.pr d2s_block_0.d2s_ab_n_f2_0.l2 DCNDiode_0.guard DCNDiode_0.guard sg13_hv_pmos ad=2.04p pd=12.68u as=2.04p ps=12.68u w=6u l=4u
X189 Clamp_N_M1_1.iovss Clamp_N_M1_wiring_0.b pad Clamp_N_M1_1.iovss sg13_hv_nmos ad=1.408p pd=5.04u as=2.596p ps=5.58u w=4.4u l=1u
X190 pad d2s_cma_0.a DCNDiode_0.guard DCNDiode_0.guard sg13_hv_pmos ad=3.9294p pd=7.84u as=2.1312p ps=7.3u w=6.66u l=0.6u
X191 DCNDiode_0.guard DCNDiode_0.guard DCNDiode_0.guard DCNDiode_0.guard sg13_hv_pmos ad=1.9p pd=10.38u as=0 ps=0 w=10u l=1u
X192 d2s_block_0.d2s_casc_n_f2_0.y d2s_block_0.d2s_casc_n_f2_0.vbnc Clamp_N_M1_wiring_0.b Clamp_N_M1_1.iovss sg13_hv_nmos ad=5.1p pd=30.68u as=5.1p ps=30.68u w=15u l=3u
X193 pad Clamp_N_M1_wiring_0.b Clamp_N_M1_1.iovss Clamp_N_M1_1.iovss sg13_hv_nmos ad=2.596p pd=5.58u as=1.408p ps=5.04u w=4.4u l=1u
X194 DCNDiode_0.guard d2s_block_0.bias_tree_n_f2_0.vbp d2s_block_0.d2s_rhigh_f2_0.sb_C2 DCNDiode_0.guard sg13_hv_pmos ad=1.7p pd=10.68u as=1.7p ps=10.68u w=5u l=6u
X195 a_9646_32196# d2s_block_0.d2s_rhigh_f2_0.sa_B Clamp_N_M1_1.iovss rhigh l=12.65u w=0.5u
X196 DCNDiode_0.guard d2s_cma_0.a pad DCNDiode_0.guard sg13_hv_pmos ad=2.1312p pd=7.3u as=3.9294p ps=7.84u w=6.66u l=0.6u
X197 pad d2s_cma_0.a DCNDiode_0.guard DCNDiode_0.guard sg13_hv_pmos ad=3.9294p pd=7.84u as=2.1312p ps=7.3u w=6.66u l=0.6u
X198 Clamp_N_M1_1.iovss Clamp_N_M1_wiring_0.b pad Clamp_N_M1_1.iovss sg13_hv_nmos ad=1.408p pd=5.04u as=2.596p ps=5.58u w=4.4u l=1u
X199 DCNDiode_0.guard d2s_block_0.d2s_ab_n_f2_0.l2 DCNDiode_0.guard DCNDiode_0.guard sg13_hv_pmos ad=0.34p pd=2.68u as=0 ps=0 w=1u l=4u
X200 DCNDiode_0.guard d2s_cma_0.a pad DCNDiode_0.guard sg13_hv_pmos ad=2.1312p pd=7.3u as=3.9294p ps=7.84u w=6.66u l=0.6u
X201 Clamp_P_M1_wiring_0.dabp DCNDiode_0.guard DCNDiode_0.guard DCNDiode_0.guard sg13_hv_pmos ad=3.9294p pd=7.84u as=2.1312p ps=7.3u w=6.66u l=0.6u
X202 Clamp_N_M1_1.iovss Clamp_N_M1_wiring_0.b pad Clamp_N_M1_1.iovss sg13_hv_nmos ad=1.408p pd=5.04u as=2.596p ps=5.58u w=4.4u l=1u
X203 d2s_block_0.d2s_casc_n_f2_0.x d2s_block_0.vref d2s_block_0.d2s_rhigh_f2_0.sb_A d2s_block_0.d2s_rhigh_f2_0.sb_A sg13_hv_pmos ad=1.9p pd=10.38u as=3.4p ps=20.68u w=10u l=1u
X204 DCNDiode_0.guard d2s_cma_0.a pad DCNDiode_0.guard sg13_hv_pmos ad=2.1312p pd=7.3u as=3.9294p ps=7.84u w=6.66u l=0.6u
X205 DCNDiode_0.guard d2s_cma_0.a pad DCNDiode_0.guard sg13_hv_pmos ad=2.1312p pd=7.3u as=3.9294p ps=7.84u w=6.66u l=0.6u
X206 d2s_block_0.d2s_rhigh_f2_0.sb_C2 pad d2s_block_0.d2s_casc_n_f2_0.x d2s_block_0.d2s_rhigh_f2_0.sb_C2 sg13_hv_pmos ad=3.4p pd=20.68u as=1.9p ps=10.38u w=10u l=1u
X207 pad Clamp_N_M1_wiring_0.b Clamp_N_M1_1.iovss Clamp_N_M1_1.iovss sg13_hv_nmos ad=2.596p pd=5.58u as=1.408p ps=5.04u w=4.4u l=1u
X208 Clamp_N_M1_1.iovss pad dantenna l=1.26u w=67.6u
X209 Clamp_N_M1_1.iovss d2s_block_0.d2s_sp2k_f2_0.core dantenna l=3.1u w=0.64u
X210 pad d2s_cma_0.a DCNDiode_0.guard DCNDiode_0.guard sg13_hv_pmos ad=3.9294p pd=7.84u as=2.1312p ps=7.3u w=6.66u l=0.6u
X211 pad Clamp_N_M1_wiring_0.b Clamp_N_M1_1.iovss Clamp_N_M1_1.iovss sg13_hv_nmos ad=2.596p pd=5.58u as=1.408p ps=5.04u w=4.4u l=1u
X212 Clamp_N_M1_1.iovss d2s_block_0.bias_tree_n_f2_0.ni d2s_block_0.bias_tree_n_f2_0.vabp Clamp_N_M1_1.iovss sg13_hv_nmos ad=2.04p pd=12.68u as=2.04p ps=12.68u w=6u l=6u
X213 a_10870_32196# a_10190_29580# Clamp_N_M1_1.iovss rhigh l=12.65u w=0.5u
X214 d2s_block_0.d2s_casc_n_f2_0.vbnc d2s_block_0.d2s_casc_n_f2_0.vbnc d2s_block_0.d2s_casc_n_f2_0.vbnc Clamp_N_M1_1.iovss sg13_hv_nmos ad=0.68p pd=4.68u as=0 ps=0 w=2u l=3u
X215 Clamp_N_M1_wiring_0.dabn d2s_block_0.d2s_ab_n_f2_0.vabn d2s_block_0.d2s_ab_n_f2_0.vabn Clamp_N_M1_1.iovss sg13_hv_nmos ad=1.496p pd=9.48u as=1.496p ps=9.48u w=4.4u l=1u
X216 DCNDiode_0.guard d2s_cma_0.a pad DCNDiode_0.guard sg13_hv_pmos ad=2.1312p pd=7.3u as=3.9294p ps=7.84u w=6.66u l=0.6u
X217 a_9510_32196# a_10462_29580# Clamp_N_M1_1.iovss rhigh l=12.65u w=0.5u
X218 Clamp_N_M1_1.iovss Clamp_N_M1_wiring_0.b pad Clamp_N_M1_1.iovss sg13_hv_nmos ad=1.408p pd=5.04u as=2.596p ps=5.58u w=4.4u l=1u
X219 pad d2s_cma_0.a DCNDiode_0.guard DCNDiode_0.guard sg13_hv_pmos ad=3.9294p pd=7.84u as=2.1312p ps=7.3u w=6.66u l=0.6u
X220 a_9918_32196# a_10054_29580# Clamp_N_M1_1.iovss rhigh l=12.65u w=0.5u
X221 d2s_block_0.sinks_6x6_f2_0.vbn d2s_block_0.sinks_6x6_f2_0.vbn d2s_block_0.sinks_6x6_f2_0.vbn Clamp_N_M1_1.iovss sg13_hv_nmos ad=0.68p pd=4.68u as=0 ps=0 w=2u l=6u
X222 DCNDiode_0.guard d2s_block_0.d2s_ab_n_f2_0.l2 DCNDiode_0.guard DCNDiode_0.guard sg13_hv_pmos ad=0.34p pd=2.68u as=0 ps=0 w=1u l=4u
X223 Clamp_N_M1_1.iovss Clamp_N_M1_wiring_0.b pad Clamp_N_M1_1.iovss sg13_hv_nmos ad=1.408p pd=5.04u as=2.596p ps=5.58u w=4.4u l=1u
X224 pad d2s_cma_0.a DCNDiode_0.guard DCNDiode_0.guard sg13_hv_pmos ad=3.9294p pd=7.84u as=2.1312p ps=7.3u w=6.66u l=0.6u
X225 pad Clamp_N_M1_wiring_0.b Clamp_N_M1_1.iovss Clamp_N_M1_1.iovss sg13_hv_nmos ad=3.256p pd=10.28u as=1.408p ps=5.04u w=4.4u l=1u
X226 pad Clamp_N_M1_wiring_0.b Clamp_N_M1_1.iovss Clamp_N_M1_1.iovss sg13_hv_nmos ad=2.596p pd=5.58u as=1.408p ps=5.04u w=4.4u l=1u
X227 pad d2s_cma_0.a DCNDiode_0.guard DCNDiode_0.guard sg13_hv_pmos ad=3.9294p pd=7.84u as=2.1312p ps=7.3u w=6.66u l=0.6u
X228 d2s_block_0.d2s_casc_n_f2_0.x d2s_block_0.sinks_6x6_f2_0.vbn Clamp_N_M1_1.iovss Clamp_N_M1_1.iovss sg13_hv_nmos ad=2.04p pd=12.68u as=2.04p ps=12.68u w=6u l=6u
X229 DCNDiode_0.guard d2s_block_0.bias_tree_n_f2_0.vbp d2s_block_0.d2s_rhigh_f2_0.sb_C1 DCNDiode_0.guard sg13_hv_pmos ad=1.7p pd=10.68u as=1.7p ps=10.68u w=5u l=6u
X230 DCNDiode_0.guard DCNDiode_0.guard DCNDiode_0.guard DCNDiode_0.guard sg13_hv_pmos ad=1.9p pd=10.38u as=0 ps=0 w=10u l=1u
X231 d2s_block_0.d2s_casc_n_f2_0.y d2s_block_0.sinks_6x6_f2_0.vbn Clamp_N_M1_1.iovss Clamp_N_M1_1.iovss sg13_hv_nmos ad=2.04p pd=12.68u as=2.04p ps=12.68u w=6u l=6u
X232 pad d2s_cma_0.a DCNDiode_0.guard DCNDiode_0.guard sg13_hv_pmos ad=3.9294p pd=7.84u as=2.1312p ps=7.3u w=6.66u l=0.6u
X233 pad d2s_cma_0.a DCNDiode_0.guard DCNDiode_0.guard sg13_hv_pmos ad=3.9294p pd=7.84u as=2.1312p ps=7.3u w=6.66u l=0.6u
X234 DCNDiode_0.guard DCNDiode_0.guard DCNDiode_0.guard DCNDiode_0.guard sg13_hv_pmos ad=2.2644p pd=14u as=0 ps=0 w=6.66u l=0.6u
X235 DCNDiode_0.guard d2s_cma_0.a pad DCNDiode_0.guard sg13_hv_pmos ad=2.1312p pd=7.3u as=3.9294p ps=7.84u w=6.66u l=0.6u
X236 DCNDiode_0.guard d2s_block_0.bias_tree_n_f2_0.vbp d2s_block_0.bias_tree_n_f2_0.vbp DCNDiode_0.guard sg13_hv_pmos ad=1.7p pd=10.68u as=1.7p ps=10.68u w=5u l=6u
X237 a_9782_32196# d2s_block_0.d2s_rhigh_f2_0.sa_C1 Clamp_N_M1_1.iovss rhigh l=12.65u w=0.5u
X238 pad d2s_cma_0.a DCNDiode_0.guard DCNDiode_0.guard sg13_hv_pmos ad=3.9294p pd=7.84u as=2.1312p ps=7.3u w=6.66u l=0.6u
X239 Clamp_P_M1_wiring_0.dabp DCNDiode_0.guard DCNDiode_0.guard DCNDiode_0.guard sg13_hv_pmos ad=3.9294p pd=7.84u as=2.1312p ps=7.3u w=6.66u l=0.6u
X240 Clamp_N_M1_1.iovss Clamp_N_M1_1.iovss Clamp_N_M1_1.iovss rhigh l=12.65u w=0.5u
X241 DCNDiode_0.guard DCNDiode_0.guard DCNDiode_0.guard DCNDiode_0.guard sg13_hv_pmos ad=3.4p pd=20.68u as=0 ps=0 w=10u l=1u
X242 DCNDiode_0.guard d2s_cma_0.a pad DCNDiode_0.guard sg13_hv_pmos ad=2.1312p pd=7.3u as=3.9294p ps=7.84u w=6.66u l=0.6u
X243 DCNDiode_0.guard d2s_cma_0.a pad DCNDiode_0.guard sg13_hv_pmos ad=2.1312p pd=7.3u as=3.9294p ps=7.84u w=6.66u l=0.6u
X244 DCNDiode_0.guard d2s_cma_0.a pad DCNDiode_0.guard sg13_hv_pmos ad=2.1312p pd=7.3u as=3.9294p ps=7.84u w=6.66u l=0.6u
X245 d2s_block_0.d2s_casc_n_f2_0.vbnc d2s_block_0.d2s_casc_n_f2_0.vbnc d2s_block_0.d2s_casc_n_f2_0.vbnc Clamp_N_M1_1.iovss sg13_hv_nmos ad=0.68p pd=4.68u as=0 ps=0 w=2u l=3u
X246 Clamp_N_M1_1.iovss d2s_block_0.sinks_6x6_f2_0.vbn d2s_block_0.d2s_casc_n_f2_0.y Clamp_N_M1_1.iovss sg13_hv_nmos ad=2.04p pd=12.68u as=2.04p ps=12.68u w=6u l=6u
X247 pad d2s_cma_0.a DCNDiode_0.guard DCNDiode_0.guard sg13_hv_pmos ad=3.9294p pd=7.84u as=2.1312p ps=7.3u w=6.66u l=0.6u
X248 pad Clamp_N_M1_wiring_0.b Clamp_N_M1_1.iovss Clamp_N_M1_1.iovss sg13_hv_nmos ad=2.596p pd=5.58u as=1.408p ps=5.04u w=4.4u l=1u
X249 pad Clamp_N_M1_wiring_0.b Clamp_N_M1_1.iovss Clamp_N_M1_1.iovss sg13_hv_nmos ad=2.596p pd=5.58u as=1.408p ps=5.04u w=4.4u l=1u
X250 DCNDiode_0.guard d2s_cma_0.a pad DCNDiode_0.guard sg13_hv_pmos ad=2.1312p pd=7.3u as=3.9294p ps=7.84u w=6.66u l=0.6u
X251 pad Clamp_N_M1_wiring_0.b Clamp_N_M1_1.iovss Clamp_N_M1_1.iovss sg13_hv_nmos ad=2.596p pd=5.58u as=1.408p ps=5.04u w=4.4u l=1u
X252 Clamp_N_M1_1.iovss Clamp_N_M1_1.iovss Clamp_N_M1_1.iovss rhigh l=12.65u w=0.5u
X253 d2s_cma_0.a d2s_block_0.bias_tree_n_f2_0.vbpc d2s_block_0.d2s_casc_p_c2_0.pr DCNDiode_0.guard sg13_hv_pmos ad=5.1p pd=30.68u as=5.1p ps=30.68u w=15u l=3u
X254 pad d2s_cma_0.a DCNDiode_0.guard DCNDiode_0.guard sg13_hv_pmos ad=3.9294p pd=7.84u as=2.1312p ps=7.3u w=6.66u l=0.6u
X255 a_10870_32196# d2s_block_0.d2s_rhigh_f2_0.sb_C1 Clamp_N_M1_1.iovss rhigh l=12.65u w=0.5u
X256 pad d2s_cma_0.a DCNDiode_0.guard DCNDiode_0.guard sg13_hv_pmos ad=3.9294p pd=7.84u as=2.1312p ps=7.3u w=6.66u l=0.6u
X257 DCNDiode_0.guard d2s_cma_0.a pad DCNDiode_0.guard sg13_hv_pmos ad=2.1312p pd=7.3u as=3.9294p ps=7.84u w=6.66u l=0.6u
X258 d2s_block_0.d2s_casc_n_f2_0.x pad d2s_block_0.d2s_rhigh_f2_0.sb_C1 d2s_block_0.d2s_rhigh_f2_0.sb_C1 sg13_hv_pmos ad=1.9p pd=10.38u as=3.4p ps=20.68u w=10u l=1u
X259 d2s_block_0.d2s_rhigh_f2_0.sa_C1 d2s_block_0.vref d2s_block_0.d2s_casc_n_f2_0.y d2s_block_0.d2s_rhigh_f2_0.sa_C1 sg13_hv_pmos ad=3.4p pd=20.68u as=1.9p ps=10.38u w=10u l=1u
X260 Clamp_N_M1_1.iovss Clamp_N_M1_wiring_0.b pad Clamp_N_M1_1.iovss sg13_hv_nmos ad=1.408p pd=5.04u as=2.596p ps=5.58u w=4.4u l=1u
X261 Clamp_N_M1_1.iovss Clamp_N_M1_wiring_0.b pad Clamp_N_M1_1.iovss sg13_hv_nmos ad=1.408p pd=5.04u as=2.596p ps=5.58u w=4.4u l=1u
X262 Clamp_N_M1_1.iovss Clamp_N_M1_wiring_0.b pad Clamp_N_M1_1.iovss sg13_hv_nmos ad=1.408p pd=5.04u as=2.596p ps=5.58u w=4.4u l=1u
X263 a_9782_32196# a_10190_29580# Clamp_N_M1_1.iovss rhigh l=12.65u w=0.5u
X264 pad d2s_cma_0.a DCNDiode_0.guard DCNDiode_0.guard sg13_hv_pmos ad=3.9294p pd=7.84u as=2.1312p ps=7.3u w=6.66u l=0.6u
X265 pad Clamp_N_M1_wiring_0.b Clamp_N_M1_1.iovss Clamp_N_M1_1.iovss sg13_hv_nmos ad=2.596p pd=5.58u as=1.408p ps=5.04u w=4.4u l=1u
X266 d2s_block_0.bias_tree_n_f2_0.vabp d2s_block_0.en_3v3 DCNDiode_0.guard DCNDiode_0.guard sg13_hv_pmos ad=0.34p pd=2.68u as=0.34p ps=2.68u w=1u l=0.45u
X267 pad d2s_cma_0.a DCNDiode_0.guard DCNDiode_0.guard sg13_hv_pmos ad=3.9294p pd=7.84u as=2.1312p ps=7.3u w=6.66u l=0.6u
X268 pad Clamp_N_M1_wiring_0.b Clamp_N_M1_1.iovss Clamp_N_M1_1.iovss sg13_hv_nmos ad=2.596p pd=5.58u as=1.408p ps=5.04u w=4.4u l=1u
X269 pad d2s_cma_0.a DCNDiode_0.guard DCNDiode_0.guard sg13_hv_pmos ad=3.9294p pd=7.84u as=2.1312p ps=7.3u w=6.66u l=0.6u
X270 DCNDiode_0.guard d2s_block_0.bias_tree_n_f2_0.vbp d2s_block_0.d2s_rhigh_f2_0.sa_A DCNDiode_0.guard sg13_hv_pmos ad=1.7p pd=10.68u as=1.7p ps=10.68u w=5u l=6u
X271 Clamp_N_M1_wiring_0.b d2s_block_0.bias_tree_n_f2_0.vabp d2s_cma_0.a DCNDiode_0.guard sg13_hv_pmos ad=2.2644p pd=14u as=2.2644p ps=14u w=6.66u l=0.6u
X272 pad d2s_cma_0.a DCNDiode_0.guard DCNDiode_0.guard sg13_hv_pmos ad=3.9294p pd=7.84u as=2.1312p ps=7.3u w=6.66u l=0.6u
X273 Clamp_N_M1_1.iovss Clamp_N_M1_wiring_0.b pad Clamp_N_M1_1.iovss sg13_hv_nmos ad=1.408p pd=5.04u as=2.596p ps=5.58u w=4.4u l=1u
X274 DCNDiode_0.guard d2s_cma_0.a pad DCNDiode_0.guard sg13_hv_pmos ad=2.1312p pd=7.3u as=3.9294p ps=7.84u w=6.66u l=0.6u
X275 Clamp_N_M1_1.iovss Clamp_N_M1_wiring_0.b pad Clamp_N_M1_1.iovss sg13_hv_nmos ad=1.408p pd=5.04u as=2.596p ps=5.58u w=4.4u l=1u
X276 Clamp_N_M1_1.iovss Clamp_N_M1_wiring_0.dabn Clamp_N_M1_wiring_0.dabn Clamp_N_M1_1.iovss sg13_hv_nmos ad=1.408p pd=5.04u as=2.596p ps=5.58u w=4.4u l=1u
X277 pad Clamp_N_M1_wiring_0.b Clamp_N_M1_1.iovss Clamp_N_M1_1.iovss sg13_hv_nmos ad=2.596p pd=5.58u as=2.068p ps=9.74u w=4.4u l=1u
X278 DCNDiode_0.guard DCNDiode_0.guard DCNDiode_0.guard DCNDiode_0.guard sg13_hv_pmos ad=1.9p pd=10.38u as=0 ps=0 w=10u l=1u
X279 DCNDiode_0.guard d2s_cma_0.a pad DCNDiode_0.guard sg13_hv_pmos ad=2.1312p pd=7.3u as=3.9294p ps=7.84u w=6.66u l=0.6u
X280 pad Clamp_N_M1_wiring_0.b Clamp_N_M1_1.iovss Clamp_N_M1_1.iovss sg13_hv_nmos ad=2.596p pd=5.58u as=1.408p ps=5.04u w=4.4u l=1u
X281 pad Clamp_N_M1_wiring_0.b Clamp_N_M1_1.iovss Clamp_N_M1_1.iovss sg13_hv_nmos ad=2.596p pd=5.58u as=1.408p ps=5.04u w=4.4u l=1u
X282 pad d2s_cma_0.a DCNDiode_0.guard DCNDiode_0.guard sg13_hv_pmos ad=4.9284p pd=14.8u as=2.1312p ps=7.3u w=6.66u l=0.6u
X283 DCNDiode_0.guard d2s_cma_0.a pad DCNDiode_0.guard sg13_hv_pmos ad=2.1312p pd=7.3u as=3.9294p ps=7.84u w=6.66u l=0.6u
X284 d2s_block_0.d2s_casc_n_f2_0.x d2s_block_0.sinks_6x6_f2_0.vbn Clamp_N_M1_1.iovss Clamp_N_M1_1.iovss sg13_hv_nmos ad=2.04p pd=12.68u as=2.04p ps=12.68u w=6u l=6u
X285 pad d2s_cma_0.a DCNDiode_0.guard DCNDiode_0.guard sg13_hv_pmos ad=3.9294p pd=7.84u as=2.1312p ps=7.3u w=6.66u l=0.6u
X286 Clamp_N_M1_1.iovss Clamp_N_M1_wiring_0.b pad Clamp_N_M1_1.iovss sg13_hv_nmos ad=1.408p pd=5.04u as=2.596p ps=5.58u w=4.4u l=1u
X287 DCNDiode_0.guard d2s_cma_0.a pad DCNDiode_0.guard sg13_hv_pmos ad=2.1312p pd=7.3u as=3.9294p ps=7.84u w=6.66u l=0.6u
X288 Clamp_N_M1_1.iovss Clamp_N_M1_wiring_0.b pad Clamp_N_M1_1.iovss sg13_hv_nmos ad=1.408p pd=5.04u as=2.596p ps=5.58u w=4.4u l=1u
X289 DCNDiode_0.guard DCNDiode_0.guard DCNDiode_0.guard DCNDiode_0.guard sg13_hv_pmos ad=3.4p pd=20.68u as=0 ps=0 w=10u l=1u
X290 Clamp_N_M1_1.iovss Clamp_N_M1_1.iovss Clamp_N_M1_1.iovss Clamp_N_M1_1.iovss sg13_hv_nmos ad=1.496p pd=9.48u as=0 ps=0 w=4.4u l=1u
X291 DCNDiode_0.guard d2s_cma_0.a pad DCNDiode_0.guard sg13_hv_pmos ad=2.1312p pd=7.3u as=3.9294p ps=7.84u w=6.66u l=0.6u
X292 pad Clamp_N_M1_wiring_0.b Clamp_N_M1_1.iovss Clamp_N_M1_1.iovss sg13_hv_nmos ad=2.596p pd=5.58u as=1.408p ps=5.04u w=4.4u l=1u
C0 d2s_block_0.d2s_rhigh_f2_0.sb_A d2s_block_0.d2s_casc_n_f2_0.y 0.69671f
C1 d2s_block_0.d2s_rhigh_f2_0.sa_C1 d2s_block_0.d2s_casc_p_c2_0.pr 0.02505f
C2 d2s_block_0.d2s_casc_n_f2_0.x d2s_block_0.vinp 0.21699f
C3 TopLayersTo4_0.vdd d2s_block_0.d2s_rhigh_f2_0.sa_A 0.08381f
C4 TopLayersTo4_0.vdd DCNDiode_0.guard 3.87859f
C5 a_9510_32196# a_10462_29666# 0.02713f
C6 d2s_block_0.bias_tree_n_f2_0.vabp d2s_block_0.d2s_casc_p_c2_0.pr 0.01103f
C7 a_10054_29666# d2s_block_0.d2s_rhigh_f2_0.sa_C2 0.04588f
C8 a_10598_32196# d2s_block_0.d2s_ab_n_f2_0.vabn 0.14858f
C9 a_10598_32196# a_11550_29666# 0.02713f
C10 Clamp_P_M1_wiring_0.dabp d2s_block_0.bias_tree_n_f2_0.vabp 0.37452f
C11 d2s_block_0.d2s_rhigh_f2_0.sa_C1 d2s_block_0.d2s_rhigh_f2_0.sb_C1 0.01883f
C12 TopLayersTo4_0.vdd d2s_block_0.en_3v3 1.73652f
C13 d2s_block_0.d2s_rhigh_f2_0.sa_B d2s_block_0.d2s_rhigh_f2_0.sa_C2 0.1563f
C14 d2s_block_0.bias_tree_n_f2_0.vbp d2s_block_0.d2s_rhigh_f2_0.sa_B 0.44672f
C15 a_10462_29666# d2s_block_0.d2s_rhigh_f2_0.sb_B 0.04319f
C16 d2s_block_0.bias_tree_n_f2_0.vbpc d2s_block_0.d2s_rhigh_f2_0.sa_B 0.05519f
C17 d2s_block_0.vref d2s_block_0.d2s_rhigh_f2_0.sb_B 2.98966f
C18 a_9374_29666# d2s_block_0.d2s_rhigh_f2_0.sa_C2 0.05012f
C19 d2s_block_0.bias_tree_n_f2_0.vbp d2s_block_0.bias_tree_n_f2_0.ni 0.74118f
C20 d2s_block_0.bias_tree_n_f2_0.vbpc d2s_block_0.bias_tree_n_f2_0.ni 0.24074f
C21 a_10870_29666# d2s_block_0.d2s_rhigh_f2_0.sb_C1 0.02617f
C22 TopLayersTo4_0.vdd a_10462_29666# 0.01326f
C23 d2s_block_0.vinp d2s_block_0.d2s_rhigh_f2_0.sb_C1 0.10978f
C24 TopLayersTo4_0.vdd d2s_block_0.vref 1.49159f
C25 Clamp_N_M1_wiring_0.dabn pad 2.20295f
C26 d2s_block_0.d2s_sp2k_f2_1.core pad 6.30962f
C27 Clamp_N_M1_wiring_0.b DCNDiode_0.guard 25.88f
C28 d2s_block_0.d2s_rhigh_f2_0.sa_B d2s_block_0.d2s_casc_n_f2_0.y 1.99841f
C29 d2s_cma_0.a pad 48.1271f
C30 a_10598_29666# d2s_block_0.d2s_rhigh_f2_0.sb_C2 0.02096f
C31 TopLayersTo4_0.vdd d2s_block_0.en_3v3_b 1.59368f
C32 d2s_block_0.d2s_sp2k_f2_0.core d2s_cma_0.a 0.29723f
C33 Clamp_N_M1_wiring_0.b d2s_block_0.en_3v3 0.04914f
C34 d2s_block_0.vinn d2s_block_0.d2s_rhigh_f2_0.sa_C2 0.1108f
C35 d2s_block_0.d2s_ab_n_f2_0.l1 d2s_block_0.d2s_casc_n_f2_0.vbnc 6.86969f
C36 d2s_block_0.vinn d2s_block_0.bias_tree_n_f2_0.vbpc 0.01581f
C37 TopLayersTo4_0.vdd a_9510_32196# 0.29163f
C38 a_11006_32196# a_11006_29666# 0.02746f
C39 a_11414_29666# d2s_block_0.d2s_rhigh_f2_0.sb_B 0.07713f
C40 d2s_block_0.d2s_rhigh_f2_0.sb_A d2s_block_0.d2s_casc_n_f2_0.vbnc 0.15539f
C41 d2s_block_0.sinks_6x6_f2_0.vbn d2s_block_0.d2s_rhigh_f2_0.sa_C2 1.24398f
C42 d2s_block_0.d2s_rhigh_f2_0.sa_C2 d2s_block_0.d2s_rhigh_f2_0.sb_C2 0.08696f
C43 d2s_block_0.d2s_ab_n_f2_0.l1 d2s_block_0.d2s_casc_n_f2_0.x 0.35416f
C44 a_11006_29666# d2s_block_0.d2s_rhigh_f2_0.sb_C1 0.02689f
C45 d2s_block_0.bias_tree_n_f2_0.vbp d2s_block_0.sinks_6x6_f2_0.vbn 0.27681f
C46 d2s_block_0.d2s_rhigh_f2_0.sb_C1 a_11278_29666# 0.04835f
C47 d2s_block_0.bias_tree_n_f2_0.vbp d2s_block_0.d2s_rhigh_f2_0.sb_C2 0.23417f
C48 d2s_block_0.bias_tree_n_f2_0.vbpc d2s_block_0.sinks_6x6_f2_0.vbn 0.03128f
C49 d2s_block_0.bias_tree_n_f2_0.vbpc d2s_block_0.d2s_rhigh_f2_0.sb_C2 0.02864f
C50 d2s_block_0.d2s_casc_n_f2_0.x d2s_block_0.d2s_rhigh_f2_0.sb_A 0.97788f
C51 a_9646_29666# d2s_block_0.d2s_rhigh_f2_0.sb_B 0.03847f
C52 pad d2s_block_0.d2s_rhigh_f2_0.sa_B 0.03495f
C53 TopLayersTo4_0.vdd a_11414_29666# 0.01326f
C54 TopLayersTo4_0.vdd d2s_block_0.d2s_rhigh_f2_0.sb_B 0.77713f
C55 a_10870_32196# a_10734_32196# 0.55763f
C56 d2s_block_0.vinn d2s_block_0.d2s_casc_n_f2_0.y 0.07839f
C57 d2s_block_0.d2s_rhigh_f2_0.sa_C2 DCNDiode_0.guard 0.81272f
C58 TopLayersTo4_0.vdd a_9646_29666# 0.01326f
C59 d2s_block_0.bias_tree_n_f2_0.vbp d2s_block_0.d2s_rhigh_f2_0.sa_A 0.25372f
C60 d2s_block_0.en_3v3_b Clamp_N_M1_wiring_0.b 0.44392f
C61 d2s_block_0.bias_tree_n_f2_0.vbpc d2s_block_0.d2s_rhigh_f2_0.sa_A 0.02582f
C62 a_10734_29666# a_10734_32196# 0.02719f
C63 d2s_block_0.bias_tree_n_f2_0.vbp DCNDiode_0.guard 52.5035f
C64 d2s_block_0.d2s_ab_n_f2_0.l2 Clamp_N_M1_wiring_0.b 0.46037f
C65 a_10326_29666# d2s_block_0.d2s_rhigh_f2_0.sb_C2 0.02092f
C66 d2s_block_0.bias_tree_n_f2_0.vbpc DCNDiode_0.guard 28.8714f
C67 d2s_block_0.sinks_6x6_f2_0.vbn d2s_block_0.d2s_casc_n_f2_0.y 9.16822f
C68 d2s_block_0.d2s_rhigh_f2_0.sb_C2 d2s_block_0.d2s_casc_n_f2_0.y 0.21505f
C69 d2s_block_0.d2s_ab_n_f2_0.l1 Clamp_P_M1_wiring_0.dabp 0.09453f
C70 a_10598_29666# a_10462_29666# 0.63642f
C71 a_10734_29666# d2s_block_0.d2s_rhigh_f2_0.sb_C2 0.02102f
C72 d2s_block_0.iref d2s_block_0.bias_tree_n_f2_0.ni 0.10634f
C73 d2s_block_0.bias_tree_n_f2_0.vbp d2s_block_0.en_3v3 0.2049f
C74 Clamp_N_M1_wiring_0.dabn Clamp_P_M1_wiring_0.dabp 1.20516f
C75 d2s_block_0.en_3v3 d2s_block_0.bias_tree_n_f2_0.vbpc 0.06905f
C76 a_9918_32196# a_9918_29666# 0.02634f
C77 d2s_cma_0.a d2s_block_0.d2s_casc_p_c2_0.pr 0.29884f
C78 d2s_block_0.d2s_rhigh_f2_0.sb_A d2s_block_0.d2s_rhigh_f2_0.sb_C1 0.1631f
C79 d2s_block_0.d2s_rhigh_f2_0.sa_A d2s_block_0.d2s_casc_n_f2_0.y 0.92783f
C80 d2s_block_0.d2s_rhigh_f2_0.sa_B d2s_block_0.d2s_casc_n_f2_0.vbnc 0.29163f
C81 Clamp_P_M1_wiring_0.dabp d2s_cma_0.a 0.77652f
C82 DCNDiode_0.guard d2s_block_0.d2s_casc_n_f2_0.y 7.85214f
C83 a_10462_29666# d2s_block_0.d2s_rhigh_f2_0.sa_C2 0.01669f
C84 d2s_block_0.d2s_casc_n_f2_0.x d2s_block_0.d2s_rhigh_f2_0.sa_B 0.62706f
C85 d2s_block_0.vref d2s_block_0.d2s_rhigh_f2_0.sa_C2 2.69046f
C86 d2s_block_0.vinn pad 0.18905f
C87 a_9374_29666# d2s_block_0.d2s_casc_n_f2_0.vbnc 0.10381f
C88 d2s_block_0.vref d2s_block_0.bias_tree_n_f2_0.vbp 0.41746f
C89 d2s_block_0.vref d2s_block_0.bias_tree_n_f2_0.vbpc 0.01701f
C90 d2s_block_0.d2s_ab_n_f2_0.vabn d2s_block_0.d2s_rhigh_f2_0.sa_C1 0.86633f
C91 d2s_block_0.en_3v3 d2s_block_0.d2s_casc_n_f2_0.y 0.02575f
C92 pad d2s_block_0.d2s_rhigh_f2_0.sb_C2 2.70034f
C93 TopLayersTo4_0.vdd Clamp_N_M1_wiring_0.b 0.01417f
C94 a_9510_29666# d2s_block_0.d2s_rhigh_f2_0.sa_B 0.04789f
C95 d2s_block_0.bias_tree_n_f2_0.vabp d2s_block_0.d2s_ab_n_f2_0.vabn 0.03145f
C96 a_10054_29666# a_9918_29666# 0.63642f
C97 d2s_block_0.en_3v3_b d2s_block_0.d2s_rhigh_f2_0.sa_C2 0.0705f
C98 d2s_block_0.d2s_sp2k_f2_0.core d2s_block_0.sinks_6x6_f2_0.vbn 0.0411f
C99 a_11142_29666# a_11006_32196# 0.02746f
C100 pad a_15058_18030# 0.0581f
C101 d2s_block_0.en_3v3_b d2s_block_0.bias_tree_n_f2_0.vbp 0.04303f
C102 d2s_block_0.en_3v3_b d2s_block_0.bias_tree_n_f2_0.vbpc 0.01576f
C103 a_11550_29666# d2s_block_0.d2s_ab_n_f2_0.vabn 0.07188f
C104 a_11142_29666# d2s_block_0.d2s_rhigh_f2_0.sb_C1 0.03293f
C105 a_9510_29666# a_9374_29666# 0.63642f
C106 a_10326_29666# a_10462_29666# 0.63642f
C107 a_10870_29666# d2s_block_0.d2s_ab_n_f2_0.vabn 0.01435f
C108 d2s_block_0.d2s_ab_n_f2_0.l2 d2s_block_0.bias_tree_n_f2_0.vbpc 2.03019f
C109 d2s_block_0.d2s_sp2k_f2_0.core a_15058_18030# 0.1618f
C110 d2s_block_0.iref d2s_block_0.sinks_6x6_f2_0.vbn 0.56722f
C111 a_10598_29666# d2s_block_0.d2s_rhigh_f2_0.sb_B 0.04323f
C112 a_10054_29666# d2s_block_0.d2s_rhigh_f2_0.sb_C1 0.02561f
C113 pad d2s_block_0.d2s_rhigh_f2_0.sa_A 0.01838f
C114 d2s_block_0.vref d2s_block_0.d2s_casc_n_f2_0.y 2.38694f
C115 a_10054_29580# d2s_block_0.d2s_rhigh_f2_0.sa_C2 0.19848f
C116 pad DCNDiode_0.guard 0.13637p
C117 d2s_block_0.d2s_casc_p_c2_0.pl d2s_cma_0.a 0.88462f
C118 d2s_block_0.d2s_rhigh_f2_0.sa_B d2s_block_0.d2s_rhigh_f2_0.sb_C1 0.29986f
C119 d2s_block_0.d2s_sp2k_f2_0.core DCNDiode_0.guard 6.32776f
C120 TopLayersTo4_0.vdd a_10598_29666# 0.01326f
C121 d2s_block_0.en_3v3_b d2s_block_0.d2s_casc_n_f2_0.y 1.29065f
C122 d2s_block_0.vinn d2s_block_0.d2s_casc_n_f2_0.x 0.73094f
C123 TopLayersTo4_0.vdd a_9782_32196# 0.18987f
C124 a_9374_29666# d2s_block_0.d2s_rhigh_f2_0.sb_C1 0.02846f
C125 d2s_block_0.sinks_6x6_f2_0.vbn d2s_block_0.d2s_casc_n_f2_0.vbnc 0.20964f
C126 d2s_block_0.d2s_casc_n_f2_0.vbnc d2s_block_0.d2s_rhigh_f2_0.sb_C2 0.04184f
C127 d2s_block_0.d2s_rhigh_f2_0.sa_C2 d2s_block_0.d2s_rhigh_f2_0.sb_B 0.03789f
C128 d2s_block_0.iref DCNDiode_0.guard 0.17627f
C129 d2s_block_0.bias_tree_n_f2_0.vbp d2s_block_0.d2s_rhigh_f2_0.sb_B 0.39285f
C130 d2s_block_0.bias_tree_n_f2_0.vbpc d2s_block_0.d2s_rhigh_f2_0.sb_B 0.02864f
C131 d2s_block_0.d2s_casc_n_f2_0.x d2s_block_0.sinks_6x6_f2_0.vbn 9.06373f
C132 d2s_block_0.d2s_casc_n_f2_0.x d2s_block_0.d2s_rhigh_f2_0.sb_C2 1.16026f
C133 a_9646_29666# d2s_block_0.d2s_rhigh_f2_0.sa_C2 0.04605f
C134 a_10598_32196# a_10734_32196# 0.78325f
C135 TopLayersTo4_0.vdd d2s_block_0.d2s_rhigh_f2_0.sa_C2 1.26576f
C136 d2s_block_0.iref d2s_block_0.en_3v3 0.11463f
C137 a_9782_29666# d2s_block_0.d2s_rhigh_f2_0.sb_C2 0.0209f
C138 TopLayersTo4_0.vdd d2s_block_0.bias_tree_n_f2_0.vbp 6.85536f
C139 d2s_block_0.d2s_casc_n_f2_0.vbnc d2s_block_0.d2s_rhigh_f2_0.sa_A 0.46192f
C140 d2s_block_0.vref pad 0.28667f
C141 TopLayersTo4_0.vdd d2s_block_0.bias_tree_n_f2_0.vbpc 0.74307f
C142 a_11006_29666# d2s_block_0.d2s_ab_n_f2_0.vabn 0.01922f
C143 d2s_block_0.d2s_ab_n_f2_0.vabn a_11278_29666# 0.0373f
C144 a_9510_29666# d2s_block_0.d2s_rhigh_f2_0.sb_C2 0.02089f
C145 a_11006_29666# a_10870_29666# 0.63642f
C146 d2s_block_0.d2s_casc_n_f2_0.vbnc DCNDiode_0.guard 3.30292f
C147 d2s_block_0.d2s_casc_n_f2_0.x d2s_block_0.d2s_rhigh_f2_0.sa_A 0.41947f
C148 a_10326_29666# d2s_block_0.d2s_rhigh_f2_0.sb_B 0.04316f
C149 d2s_block_0.d2s_casc_n_f2_0.x DCNDiode_0.guard 9.44335f
C150 d2s_block_0.d2s_rhigh_f2_0.sb_B d2s_block_0.d2s_casc_n_f2_0.y 0.52521f
C151 a_9918_29666# d2s_block_0.d2s_rhigh_f2_0.sb_C2 0.0209f
C152 d2s_block_0.en_3v3 d2s_block_0.d2s_casc_n_f2_0.vbnc 0.27478f
C153 a_10054_29666# a_10190_29666# 0.63642f
C154 a_10734_29666# d2s_block_0.d2s_rhigh_f2_0.sb_B 0.04331f
C155 a_9510_29666# d2s_block_0.d2s_rhigh_f2_0.sa_A 0.03839f
C156 a_10326_29666# TopLayersTo4_0.vdd 0.01326f
C157 d2s_block_0.d2s_casc_n_f2_0.x d2s_block_0.en_3v3 0.17638f
C158 TopLayersTo4_0.vdd d2s_block_0.d2s_casc_n_f2_0.y 0.14981f
C159 TopLayersTo4_0.vdd a_10870_32196# 0.18862f
C160 d2s_block_0.d2s_rhigh_f2_0.sb_A d2s_block_0.d2s_rhigh_f2_0.sa_C1 3.00544f
C161 d2s_block_0.d2s_rhigh_f2_0.sb_C1 d2s_block_0.d2s_rhigh_f2_0.sb_C2 2.96153f
C162 DCNDiode_0.guard d2s_block_0.d2s_casc_p_c2_0.pr 15.2407f
C163 d2s_block_0.d2s_ab_n_f2_0.l1 d2s_block_0.bias_tree_n_f2_0.vabp 0.69917f
C164 TopLayersTo4_0.vdd a_10734_29666# 0.01326f
C165 d2s_block_0.en_3v3_b d2s_block_0.iref 2.27275f
C166 Clamp_P_M1_wiring_0.dabp DCNDiode_0.guard 6.67031f
C167 d2s_block_0.d2s_ab_n_f2_0.l1 d2s_block_0.d2s_ab_n_f2_0.vabn 0.56759f
C168 d2s_block_0.d2s_ab_n_f2_0.vabn d2s_block_0.d2s_rhigh_f2_0.sb_A 0.93711f
C169 a_11550_29666# d2s_block_0.d2s_rhigh_f2_0.sb_A 0.02699f
C170 d2s_block_0.d2s_casc_n_f2_0.x d2s_block_0.vref 0.70768f
C171 d2s_block_0.d2s_rhigh_f2_0.sb_C1 d2s_block_0.d2s_rhigh_f2_0.sa_A 0.06509f
C172 Clamp_N_M1_wiring_0.dabn d2s_block_0.d2s_ab_n_f2_0.vabn 0.2642f
C173 d2s_block_0.d2s_rhigh_f2_0.sb_C1 DCNDiode_0.guard 0.31213f
C174 pad d2s_block_0.d2s_rhigh_f2_0.sb_B 0.6063f
C175 d2s_cma_0.a d2s_block_0.bias_tree_n_f2_0.vabp 0.31599f
C176 d2s_block_0.en_3v3_b d2s_block_0.d2s_casc_n_f2_0.vbnc 0.06336f
C177 d2s_cma_0.a d2s_block_0.d2s_ab_n_f2_0.vabn 0.21121f
C178 d2s_block_0.d2s_casc_n_f2_0.x d2s_block_0.en_3v3_b 0.03622f
C179 TopLayersTo4_0.vdd pad 0.0791f
C180 d2s_block_0.d2s_casc_n_f2_0.x d2s_block_0.d2s_ab_n_f2_0.l2 0.04055f
C181 a_10598_29666# d2s_block_0.d2s_rhigh_f2_0.sa_C2 0.01215f
C182 Clamp_N_M1_wiring_0.b d2s_block_0.d2s_casc_n_f2_0.y 0.30126f
C183 a_9510_32196# d2s_block_0.d2s_casc_n_f2_0.vbnc 0.21011f
C184 d2s_block_0.d2s_rhigh_f2_0.sa_B d2s_block_0.d2s_rhigh_f2_0.sa_C1 1.67372f
C185 a_11142_29666# d2s_block_0.d2s_ab_n_f2_0.vabn 0.02664f
C186 d2s_block_0.d2s_casc_p_c2_0.pl DCNDiode_0.guard 18.3468f
C187 TopLayersTo4_0.vdd d2s_block_0.iref 0.97468f
C188 a_10462_29666# d2s_block_0.d2s_rhigh_f2_0.sb_C1 0.02569f
C189 d2s_block_0.vref d2s_block_0.d2s_rhigh_f2_0.sb_C1 0.01473f
C190 d2s_block_0.d2s_rhigh_f2_0.sb_C2 a_10190_29666# 0.02091f
C191 d2s_block_0.d2s_ab_n_f2_0.l2 d2s_block_0.d2s_casc_p_c2_0.pr 5.91836f
C192 a_9374_29666# d2s_block_0.d2s_rhigh_f2_0.sa_C1 0.05763f
C193 d2s_block_0.d2s_casc_n_f2_0.vbnc d2s_block_0.d2s_rhigh_f2_0.sb_B 0.03816f
C194 a_9510_29666# a_9510_32196# 0.02514f
C195 d2s_block_0.bias_tree_n_f2_0.vbp d2s_block_0.d2s_rhigh_f2_0.sa_C2 0.27689f
C196 d2s_block_0.bias_tree_n_f2_0.vbpc d2s_block_0.d2s_rhigh_f2_0.sa_C2 2.5437f
C197 d2s_block_0.d2s_casc_n_f2_0.x d2s_block_0.d2s_rhigh_f2_0.sb_B 0.88986f
C198 a_812_18030# d2s_block_0.d2s_sp2k_f2_1.core 0.16662f
C199 a_9646_29666# d2s_block_0.d2s_casc_n_f2_0.vbnc 0.04482f
C200 a_10598_32196# a_9510_32196# 0.21179f
C201 d2s_block_0.bias_tree_n_f2_0.vabp d2s_block_0.bias_tree_n_f2_0.ni 0.55657f
C202 d2s_block_0.bias_tree_n_f2_0.vbp d2s_block_0.bias_tree_n_f2_0.vbpc 0.53763f
C203 TopLayersTo4_0.vdd d2s_block_0.d2s_casc_n_f2_0.vbnc 1.23326f
C204 d2s_block_0.vinp d2s_block_0.d2s_rhigh_f2_0.sa_B 0.14038f
C205 a_9782_29666# d2s_block_0.d2s_rhigh_f2_0.sb_B 0.04292f
C206 a_10598_29666# a_10734_29666# 0.63642f
C207 Clamp_N_M1_wiring_0.b pad 38.277f
C208 TopLayersTo4_0.vdd d2s_block_0.d2s_casc_n_f2_0.x 0.11766f
C209 a_9510_29666# d2s_block_0.d2s_rhigh_f2_0.sb_B 0.02749f
C210 a_9782_29666# a_9646_29666# 0.63642f
C211 d2s_block_0.d2s_sp2k_f2_0.core Clamp_N_M1_wiring_0.b 29.3545f
C212 a_10326_29666# d2s_block_0.d2s_rhigh_f2_0.sa_C2 0.02354f
C213 TopLayersTo4_0.vdd a_9782_29666# 0.01326f
C214 a_9510_29666# a_9646_29666# 0.63642f
C215 d2s_block_0.d2s_rhigh_f2_0.sa_C2 d2s_block_0.d2s_casc_n_f2_0.y 1.84957f
C216 d2s_block_0.bias_tree_n_f2_0.vbp d2s_block_0.d2s_casc_n_f2_0.y 0.09483f
C217 d2s_block_0.bias_tree_n_f2_0.vbpc d2s_block_0.d2s_casc_n_f2_0.y 0.35504f
C218 TopLayersTo4_0.vdd a_9510_29666# 0.01324f
C219 a_9918_29666# d2s_block_0.d2s_rhigh_f2_0.sb_B 0.04304f
C220 d2s_block_0.vinn d2s_block_0.d2s_rhigh_f2_0.sa_C1 0.11198f
C221 a_11142_29666# a_11006_29666# 0.63642f
C222 a_11142_29666# a_11278_29666# 0.63642f
C223 a_10598_32196# TopLayersTo4_0.vdd 0.29675f
C224 d2s_block_0.d2s_casc_p_c2_0.pl d2s_block_0.d2s_ab_n_f2_0.l2 2.28979f
C225 d2s_block_0.sinks_6x6_f2_0.vbn d2s_block_0.d2s_rhigh_f2_0.sa_C1 0.9803f
C226 d2s_block_0.d2s_rhigh_f2_0.sb_C1 d2s_block_0.d2s_rhigh_f2_0.sb_B 1.47487f
C227 d2s_block_0.d2s_rhigh_f2_0.sa_C1 d2s_block_0.d2s_rhigh_f2_0.sb_C2 0.09016f
C228 d2s_block_0.d2s_ab_n_f2_0.l1 Clamp_N_M1_wiring_0.dabn 0.8559f
C229 TopLayersTo4_0.vdd a_9918_29666# 0.01326f
C230 a_9646_29666# d2s_block_0.d2s_rhigh_f2_0.sb_C1 0.02555f
C231 d2s_block_0.bias_tree_n_f2_0.vabp d2s_block_0.sinks_6x6_f2_0.vbn 1.11797f
C232 a_11006_32196# TopLayersTo4_0.vdd 0.11929f
C233 Clamp_N_M1_wiring_0.dabn d2s_block_0.d2s_sp2k_f2_1.core 0.08675f
C234 Clamp_N_M1_wiring_0.b d2s_block_0.d2s_casc_n_f2_0.vbnc 6.87883f
C235 d2s_block_0.d2s_ab_n_f2_0.l1 d2s_cma_0.a 0.81303f
C236 TopLayersTo4_0.vdd d2s_block_0.d2s_rhigh_f2_0.sb_C1 0.08379f
C237 d2s_block_0.vinn d2s_block_0.vinp 2.28356f
C238 d2s_block_0.d2s_ab_n_f2_0.vabn d2s_block_0.sinks_6x6_f2_0.vbn 0.36408f
C239 d2s_block_0.d2s_casc_n_f2_0.x Clamp_N_M1_wiring_0.b 0.25852f
C240 Clamp_N_M1_wiring_0.dabn d2s_cma_0.a 0.65752f
C241 a_10870_29666# d2s_block_0.d2s_rhigh_f2_0.sb_C2 0.02119f
C242 d2s_block_0.d2s_rhigh_f2_0.sa_C1 DCNDiode_0.guard 0.89579f
C243 d2s_cma_0.a d2s_block_0.d2s_sp2k_f2_1.core 33.6393f
C244 d2s_block_0.vinp d2s_block_0.d2s_rhigh_f2_0.sb_C2 0.11199f
C245 d2s_block_0.bias_tree_n_f2_0.vbpc pad 0.0203f
C246 d2s_block_0.bias_tree_n_f2_0.vabp DCNDiode_0.guard 4.69218f
C247 d2s_block_0.d2s_ab_n_f2_0.vabn DCNDiode_0.guard 2.84271f
C248 d2s_block_0.iref d2s_block_0.d2s_rhigh_f2_0.sa_C2 0.0852f
C249 d2s_block_0.vinp d2s_block_0.d2s_rhigh_f2_0.sa_A 2.79506f
C250 d2s_block_0.iref d2s_block_0.bias_tree_n_f2_0.vbp 0.14242f
C251 d2s_block_0.bias_tree_n_f2_0.vabp d2s_block_0.en_3v3 0.25697f
C252 d2s_block_0.iref d2s_block_0.bias_tree_n_f2_0.vbpc 0.25785f
C253 d2s_block_0.vinp DCNDiode_0.guard 1.06556f
C254 Clamp_P_M1_wiring_0.dabp Clamp_N_M1_wiring_0.b 0.07973f
C255 a_9918_32196# a_10054_29666# 0.02746f
C256 a_10462_29580# d2s_block_0.d2s_rhigh_f2_0.sb_C2 0.12162f
C257 d2s_block_0.d2s_rhigh_f2_0.sa_B d2s_block_0.d2s_rhigh_f2_0.sb_A 2.00823f
C258 pad d2s_block_0.d2s_casc_n_f2_0.y 0.08525f
C259 d2s_block_0.en_3v3 d2s_block_0.d2s_ab_n_f2_0.vabn 7.29654f
C260 d2s_block_0.vref d2s_block_0.d2s_rhigh_f2_0.sa_C1 2.69676f
C261 d2s_block_0.d2s_rhigh_f2_0.sb_B a_10190_29666# 0.04314f
C262 a_9374_29666# d2s_block_0.d2s_rhigh_f2_0.sb_A 0.0128f
C263 d2s_block_0.d2s_casc_n_f2_0.vbnc d2s_block_0.d2s_rhigh_f2_0.sa_C2 0.39817f
C264 a_9782_29666# a_9782_32196# 0.02438f
C265 a_11006_29666# d2s_block_0.d2s_rhigh_f2_0.sb_C2 0.02172f
C266 d2s_block_0.bias_tree_n_f2_0.vbp d2s_block_0.d2s_casc_n_f2_0.vbnc 0.26597f
C267 a_10598_32196# a_10598_29666# 0.02713f
C268 d2s_block_0.bias_tree_n_f2_0.vbpc d2s_block_0.d2s_casc_n_f2_0.vbnc 0.39211f
C269 d2s_block_0.d2s_casc_n_f2_0.x d2s_block_0.d2s_rhigh_f2_0.sa_C2 0.28003f
C270 TopLayersTo4_0.vdd a_10190_29666# 0.01326f
C271 d2s_block_0.d2s_casc_n_f2_0.x d2s_block_0.bias_tree_n_f2_0.vbpc 0.35066f
C272 a_9782_29666# d2s_block_0.d2s_rhigh_f2_0.sa_C2 0.06949f
C273 a_9510_29666# d2s_block_0.d2s_rhigh_f2_0.sa_C2 0.04592f
C274 d2s_block_0.vinp d2s_block_0.vref 0.24444f
C275 d2s_block_0.en_3v3_b d2s_block_0.bias_tree_n_f2_0.vabp 1.09664f
C276 a_812_18030# DCNDiode_0.guard 0.16159f
C277 a_11686_29666# d2s_block_0.d2s_ab_n_f2_0.vabn 0.12626f
C278 a_11686_29666# a_11550_29666# 0.63642f
C279 d2s_block_0.d2s_casc_p_c2_0.pl Clamp_N_M1_wiring_0.b 0.1393f
C280 a_10598_29666# d2s_block_0.d2s_rhigh_f2_0.sb_C1 0.02576f
C281 d2s_block_0.d2s_ab_n_f2_0.l2 d2s_block_0.bias_tree_n_f2_0.vabp 0.60794f
C282 d2s_block_0.d2s_casc_n_f2_0.vbnc d2s_block_0.d2s_casc_n_f2_0.y 2.6787f
C283 d2s_block_0.d2s_rhigh_f2_0.sa_C2 d2s_block_0.d2s_casc_p_c2_0.pr 0.03033f
C284 d2s_block_0.en_3v3_b d2s_block_0.d2s_ab_n_f2_0.vabn 0.35174f
C285 d2s_block_0.d2s_ab_n_f2_0.l2 d2s_block_0.d2s_ab_n_f2_0.vabn 0.24918f
C286 a_10190_29580# d2s_block_0.d2s_rhigh_f2_0.sb_C2 0.12128f
C287 d2s_block_0.bias_tree_n_f2_0.vbpc d2s_block_0.d2s_casc_p_c2_0.pr 2.95522f
C288 a_9918_29666# d2s_block_0.d2s_rhigh_f2_0.sa_C2 0.11376f
C289 d2s_block_0.d2s_casc_n_f2_0.x d2s_block_0.d2s_casc_n_f2_0.y 14.9543f
C290 d2s_block_0.d2s_sp2k_f2_0.core pad 7.04262f
C291 d2s_block_0.vinn d2s_block_0.d2s_rhigh_f2_0.sb_A 0.10431f
C292 d2s_block_0.d2s_rhigh_f2_0.sa_C1 d2s_block_0.d2s_rhigh_f2_0.sb_B 0.16445f
C293 d2s_block_0.d2s_rhigh_f2_0.sb_C1 d2s_block_0.d2s_rhigh_f2_0.sa_C2 0.05219f
C294 d2s_block_0.d2s_rhigh_f2_0.sb_A d2s_block_0.d2s_rhigh_f2_0.sb_C2 0.02061f
C295 a_9374_29666# d2s_block_0.d2s_rhigh_f2_0.sa_B 0.0463f
C296 d2s_block_0.bias_tree_n_f2_0.vbp d2s_block_0.d2s_rhigh_f2_0.sb_C1 0.23283f
C297 d2s_block_0.bias_tree_n_f2_0.vbpc d2s_block_0.d2s_rhigh_f2_0.sb_C1 0.03244f
C298 a_10462_29580# a_10326_29580# 0.33426f
C299 a_9646_29666# d2s_block_0.d2s_rhigh_f2_0.sa_C1 0.08627f
C300 d2s_block_0.d2s_casc_p_c2_0.pr d2s_block_0.d2s_casc_n_f2_0.y 0.06645f
C301 TopLayersTo4_0.vdd d2s_block_0.d2s_rhigh_f2_0.sa_C1 1.01092f
C302 a_11414_29666# d2s_block_0.d2s_ab_n_f2_0.vabn 0.0523f
C303 d2s_block_0.d2s_ab_n_f2_0.vabn d2s_block_0.d2s_rhigh_f2_0.sb_B 0.01173f
C304 a_11414_29666# a_11550_29666# 0.63642f
C305 d2s_block_0.d2s_rhigh_f2_0.sb_A d2s_block_0.d2s_rhigh_f2_0.sa_A 0.0301f
C306 d2s_block_0.d2s_ab_n_f2_0.l1 DCNDiode_0.guard 2.75637f
C307 a_11550_29666# d2s_block_0.d2s_rhigh_f2_0.sb_B 0.01861f
C308 a_10870_29666# d2s_block_0.d2s_rhigh_f2_0.sb_B 0.04345f
C309 d2s_block_0.d2s_rhigh_f2_0.sb_A DCNDiode_0.guard 1.35344f
C310 TopLayersTo4_0.vdd d2s_block_0.bias_tree_n_f2_0.vabp 1.03501f
C311 d2s_block_0.vinp d2s_block_0.d2s_rhigh_f2_0.sb_B 0.09952f
C312 Clamp_N_M1_wiring_0.dabn DCNDiode_0.guard 5.84298f
C313 a_10326_29666# d2s_block_0.d2s_rhigh_f2_0.sb_C1 0.02565f
C314 d2s_block_0.d2s_sp2k_f2_1.core DCNDiode_0.guard 4.49638f
C315 a_11006_32196# a_10870_32196# 0.33426f
C316 d2s_block_0.d2s_casc_n_f2_0.x pad 1.52067f
C317 d2s_block_0.d2s_rhigh_f2_0.sb_C1 d2s_block_0.d2s_casc_n_f2_0.y 0.3288f
C318 TopLayersTo4_0.vdd d2s_block_0.d2s_ab_n_f2_0.vabn 1.17406f
C319 d2s_block_0.d2s_ab_n_f2_0.l1 d2s_block_0.en_3v3 0.03629f
C320 TopLayersTo4_0.vdd a_11550_29666# 0.01326f
C321 TopLayersTo4_0.vdd a_10870_29666# 0.01326f
C322 d2s_block_0.d2s_casc_p_c2_0.pl d2s_block_0.bias_tree_n_f2_0.vbpc 3.07095f
C323 a_11142_29666# d2s_block_0.d2s_rhigh_f2_0.sb_C2 0.02652f
C324 d2s_cma_0.a DCNDiode_0.guard 0.12278p
C325 TopLayersTo4_0.vdd d2s_block_0.vinp 1.38278f
C326 a_10734_29666# d2s_block_0.d2s_rhigh_f2_0.sb_C1 0.02589f
C327 a_10054_29666# d2s_block_0.d2s_rhigh_f2_0.sb_C2 0.0209f
C328 d2s_block_0.iref d2s_block_0.d2s_casc_n_f2_0.vbnc 0.12819f
C329 d2s_block_0.vinn d2s_block_0.d2s_rhigh_f2_0.sa_B 0.04693f
C330 a_9782_32196# a_10190_29666# 0.02728f
C331 a_9510_32196# a_9646_32196# 0.78325f
C332 d2s_cma_0.a d2s_block_0.en_3v3 0.05461f
C333 d2s_block_0.d2s_rhigh_f2_0.sa_B d2s_block_0.d2s_rhigh_f2_0.sb_C2 0.0974f
C334 a_10326_29580# a_10190_29580# 0.55763f
C335 d2s_block_0.vref d2s_block_0.d2s_rhigh_f2_0.sb_A 2.68862f
C336 d2s_block_0.d2s_rhigh_f2_0.sa_C2 a_10190_29666# 0.03348f
C337 d2s_block_0.bias_tree_n_f2_0.ni d2s_block_0.sinks_6x6_f2_0.vbn 0.01716f
C338 a_9374_29666# d2s_block_0.d2s_rhigh_f2_0.sb_C2 0.02455f
C339 a_11414_29666# a_11278_29666# 0.63642f
C340 a_11006_29666# d2s_block_0.d2s_rhigh_f2_0.sb_B 0.04376f
C341 d2s_block_0.d2s_rhigh_f2_0.sb_B a_11278_29666# 0.05309f
C342 d2s_block_0.bias_tree_n_f2_0.vabp Clamp_N_M1_wiring_0.b 0.48786f
C343 d2s_block_0.d2s_casc_n_f2_0.x d2s_block_0.d2s_casc_n_f2_0.vbnc 3.02377f
C344 pad d2s_block_0.d2s_rhigh_f2_0.sb_C1 2.68838f
C345 d2s_block_0.d2s_rhigh_f2_0.sa_B d2s_block_0.d2s_rhigh_f2_0.sa_A 1.53969f
C346 a_10054_29580# a_10190_29580# 0.78325f
C347 d2s_block_0.d2s_rhigh_f2_0.sa_B DCNDiode_0.guard 0.8697f
C348 d2s_block_0.d2s_ab_n_f2_0.l1 d2s_block_0.d2s_ab_n_f2_0.l2 0.56925f
C349 Clamp_N_M1_wiring_0.b d2s_block_0.d2s_ab_n_f2_0.vabn 0.32223f
C350 a_9646_29666# a_9646_32196# 0.02519f
C351 a_9782_29666# d2s_block_0.d2s_casc_n_f2_0.vbnc 0.01214f
C352 TopLayersTo4_0.vdd a_11006_29666# 0.01326f
C353 TopLayersTo4_0.vdd a_11278_29666# 0.01326f
C354 TopLayersTo4_0.vdd a_9646_32196# 0.24583f
C355 a_9374_29666# d2s_block_0.d2s_rhigh_f2_0.sa_A 0.0292f
C356 Clamp_N_M1_wiring_0.dabn d2s_block_0.d2s_ab_n_f2_0.l2 0.07862f
C357 a_9510_29666# d2s_block_0.d2s_casc_n_f2_0.vbnc 0.05962f
C358 d2s_block_0.bias_tree_n_f2_0.ni DCNDiode_0.guard 0.16612f
C359 a_10326_29666# a_10190_29666# 0.63642f
C360 d2s_block_0.d2s_ab_n_f2_0.l2 d2s_cma_0.a 1.21313f
C361 d2s_block_0.en_3v3 d2s_block_0.bias_tree_n_f2_0.ni 0.61404f
C362 d2s_block_0.d2s_casc_n_f2_0.x d2s_block_0.d2s_casc_p_c2_0.pr 0.29544f
C363 d2s_block_0.d2s_rhigh_f2_0.sb_C1 d2s_block_0.d2s_casc_n_f2_0.vbnc 0.05487f
C364 d2s_block_0.d2s_rhigh_f2_0.sb_A d2s_block_0.d2s_rhigh_f2_0.sb_B 0.23114f
C365 d2s_block_0.d2s_rhigh_f2_0.sa_C1 d2s_block_0.d2s_rhigh_f2_0.sa_C2 7.08342f
C366 d2s_block_0.vref d2s_block_0.d2s_rhigh_f2_0.sa_B 2.91863f
C367 d2s_block_0.bias_tree_n_f2_0.vbp d2s_block_0.d2s_rhigh_f2_0.sa_C1 0.27516f
C368 a_9782_29666# a_9918_29666# 0.63642f
C369 d2s_block_0.bias_tree_n_f2_0.vbpc d2s_block_0.d2s_rhigh_f2_0.sa_C1 0.04832f
C370 d2s_block_0.d2s_casc_n_f2_0.x d2s_block_0.d2s_rhigh_f2_0.sb_C1 1.16358f
C371 d2s_block_0.d2s_ab_n_f2_0.l1 TopLayersTo4_0.vdd 0.01417f
C372 d2s_block_0.vinn DCNDiode_0.guard 1.13707f
C373 TopLayersTo4_0.vdd d2s_block_0.d2s_rhigh_f2_0.sb_A 0.80516f
C374 a_9782_29666# d2s_block_0.d2s_rhigh_f2_0.sb_C1 0.02558f
C375 d2s_block_0.d2s_ab_n_f2_0.vabn d2s_block_0.d2s_rhigh_f2_0.sa_C2 0.05927f
C376 d2s_block_0.d2s_rhigh_f2_0.sb_C2 d2s_block_0.d2s_rhigh_f2_0.sa_A 1.14606f
C377 a_9510_29666# d2s_block_0.d2s_rhigh_f2_0.sb_C1 0.02554f
C378 TopLayersTo4_0.vdd a_9918_32196# 0.12054f
C379 d2s_block_0.bias_tree_n_f2_0.vbp d2s_block_0.d2s_ab_n_f2_0.vabn 0.29088f
C380 d2s_block_0.sinks_6x6_f2_0.vbn DCNDiode_0.guard 5.1611f
C381 d2s_block_0.bias_tree_n_f2_0.vbpc d2s_block_0.d2s_ab_n_f2_0.vabn 0.03067f
C382 d2s_block_0.d2s_rhigh_f2_0.sb_C2 DCNDiode_0.guard 0.23279f
C383 d2s_block_0.en_3v3_b d2s_block_0.bias_tree_n_f2_0.ni 0.15546f
C384 d2s_block_0.vinp d2s_block_0.bias_tree_n_f2_0.vbpc 0.01581f
C385 d2s_block_0.d2s_rhigh_f2_0.sa_C1 d2s_block_0.d2s_casc_n_f2_0.y 1.24175f
C386 a_15058_18030# DCNDiode_0.guard 0.16084f
C387 a_11142_29666# d2s_block_0.d2s_rhigh_f2_0.sb_B 0.04459f
C388 a_9918_29666# d2s_block_0.d2s_rhigh_f2_0.sb_C1 0.02559f
C389 d2s_block_0.en_3v3 d2s_block_0.sinks_6x6_f2_0.vbn 0.03788f
C390 d2s_block_0.bias_tree_n_f2_0.vabp d2s_block_0.d2s_casc_n_f2_0.y 0.62468f
C391 a_10054_29666# d2s_block_0.d2s_rhigh_f2_0.sb_B 0.04313f
C392 d2s_block_0.d2s_rhigh_f2_0.sa_A DCNDiode_0.guard 0.7643f
C393 d2s_block_0.d2s_ab_n_f2_0.vabn d2s_block_0.d2s_casc_n_f2_0.y 1.2778f
C394 d2s_block_0.vinn d2s_block_0.vref 5.84531f
C395 a_11142_29666# TopLayersTo4_0.vdd 0.01326f
C396 a_10870_32196# a_10870_29666# 0.02728f
C397 d2s_block_0.d2s_rhigh_f2_0.sa_B d2s_block_0.d2s_rhigh_f2_0.sb_B 0.17725f
C398 a_9782_32196# a_9646_32196# 0.55763f
C399 TopLayersTo4_0.vdd a_10054_29666# 0.01326f
C400 d2s_block_0.d2s_ab_n_f2_0.l1 Clamp_N_M1_wiring_0.b 1.58264f
C401 d2s_block_0.vinp d2s_block_0.d2s_casc_n_f2_0.y 0.71522f
C402 a_10462_29666# d2s_block_0.d2s_rhigh_f2_0.sb_C2 0.02093f
C403 a_10734_29666# d2s_block_0.d2s_ab_n_f2_0.vabn 0.01103f
C404 d2s_block_0.en_3v3 DCNDiode_0.guard 2.0011f
C405 a_10870_29666# a_10734_29666# 0.63642f
C406 d2s_block_0.d2s_casc_p_c2_0.pl d2s_block_0.d2s_casc_p_c2_0.pr 10.0355f
C407 a_9646_29666# d2s_block_0.d2s_rhigh_f2_0.sa_B 0.0538f
C408 Clamp_N_M1_wiring_0.dabn Clamp_N_M1_wiring_0.b 0.565f
C409 a_9374_29666# d2s_block_0.d2s_rhigh_f2_0.sb_B 0.0292f
C410 Clamp_N_M1_wiring_0.b d2s_block_0.d2s_sp2k_f2_1.core 0.11039f
C411 TopLayersTo4_0.vdd d2s_block_0.d2s_rhigh_f2_0.sa_B 0.09547f
C412 a_10326_29580# d2s_block_0.d2s_rhigh_f2_0.sb_C2 0.12303f
C413 pad d2s_block_0.d2s_rhigh_f2_0.sa_C1 0.1114f
C414 d2s_cma_0.a Clamp_N_M1_wiring_0.b 5.93786f
C415 TopLayersTo4_0.vdd d2s_block_0.bias_tree_n_f2_0.ni 5.18499f
C416 d2s_block_0.en_3v3_b d2s_block_0.sinks_6x6_f2_0.vbn 0.15339f
C417 TopLayersTo4_0.vdd a_9374_29666# 0.01009f
C418 d2s_block_0.vref d2s_block_0.d2s_rhigh_f2_0.sa_A 0.15231f
C419 d2s_block_0.vref DCNDiode_0.guard 5.59778f
C420 d2s_block_0.iref d2s_block_0.d2s_rhigh_f2_0.sa_C1 0.01252f
C421 a_10054_29580# d2s_block_0.d2s_rhigh_f2_0.sb_C2 0.31811f
C422 a_10326_29666# a_9646_32196# 0.02719f
C423 d2s_block_0.vinp pad 4.87783f
C424 a_11414_29666# a_10734_32196# 0.02719f
C425 d2s_block_0.en_3v3_b DCNDiode_0.guard 1.46452f
C426 a_10870_32196# a_11278_29666# 0.02728f
C427 d2s_block_0.vinn d2s_block_0.d2s_rhigh_f2_0.sb_B 4.63917f
C428 d2s_block_0.d2s_ab_n_f2_0.l2 DCNDiode_0.guard 47.2756f
C429 a_9918_32196# a_9782_32196# 0.33426f
C430 a_11686_29666# d2s_block_0.en_3v3 0.02805f
C431 d2s_block_0.d2s_rhigh_f2_0.sb_C1 a_10190_29666# 0.02562f
C432 d2s_block_0.d2s_rhigh_f2_0.sa_C1 d2s_block_0.d2s_casc_n_f2_0.vbnc 1.11584f
C433 d2s_block_0.d2s_rhigh_f2_0.sb_A d2s_block_0.d2s_rhigh_f2_0.sa_C2 0.44573f
C434 TopLayersTo4_0.vdd a_10734_32196# 0.24464f
C435 d2s_block_0.d2s_rhigh_f2_0.sb_B d2s_block_0.d2s_rhigh_f2_0.sb_C2 0.57959f
C436 d2s_block_0.en_3v3_b d2s_block_0.en_3v3 8.63296f
C437 d2s_block_0.bias_tree_n_f2_0.vbp d2s_block_0.d2s_rhigh_f2_0.sb_A 0.3079f
C438 d2s_block_0.vinn TopLayersTo4_0.vdd 1.10953f
C439 d2s_block_0.d2s_ab_n_f2_0.l2 d2s_block_0.en_3v3 0.35277f
C440 d2s_block_0.bias_tree_n_f2_0.vbpc d2s_block_0.d2s_rhigh_f2_0.sb_A 2.21293f
C441 d2s_block_0.d2s_casc_n_f2_0.x d2s_block_0.d2s_rhigh_f2_0.sa_C1 0.21017f
C442 a_9646_29666# d2s_block_0.d2s_rhigh_f2_0.sb_C2 0.0209f
C443 TopLayersTo4_0.vdd d2s_block_0.sinks_6x6_f2_0.vbn 1.95274f
C444 TopLayersTo4_0.vdd d2s_block_0.d2s_rhigh_f2_0.sb_C2 0.0838f
C445 a_9782_29666# d2s_block_0.d2s_rhigh_f2_0.sa_C1 0.12043f
C446 d2s_block_0.d2s_ab_n_f2_0.vabn d2s_block_0.d2s_casc_n_f2_0.vbnc 0.35232f
C447 d2s_block_0.d2s_casc_n_f2_0.x d2s_block_0.bias_tree_n_f2_0.vabp 0.16626f
C448 d2s_block_0.d2s_rhigh_f2_0.sb_B d2s_block_0.d2s_rhigh_f2_0.sa_A 3.34743f
C449 a_9510_29666# d2s_block_0.d2s_rhigh_f2_0.sa_C1 0.07367f
C450 d2s_cma_0.a d2s_block_0.bias_tree_n_f2_0.vbpc 6.12127f
C451 d2s_block_0.d2s_rhigh_f2_0.sb_B DCNDiode_0.guard 2.31968f
C452 a_812_18030# pad 0.08365f
C453 d2s_block_0.d2s_casc_n_f2_0.x d2s_block_0.d2s_ab_n_f2_0.vabn 0.59568f
C454 d2s_block_0.d2s_ab_n_f2_0.l1 d2s_block_0.d2s_casc_n_f2_0.y 0.08525f
C455 d2s_block_0.d2s_casc_p_c2_0.pl Clamp_N_M1_1.iovss 1.52941f
C456 d2s_block_0.d2s_casc_p_c2_0.pr Clamp_N_M1_1.iovss 5.30357f
C457 d2s_block_0.d2s_ab_n_f2_0.l1 Clamp_N_M1_1.iovss 9.29697f
C458 d2s_block_0.d2s_casc_n_f2_0.x Clamp_N_M1_1.iovss 18.91412f
C459 d2s_block_0.d2s_casc_n_f2_0.y Clamp_N_M1_1.iovss 23.16874f
C460 a_11006_32196# Clamp_N_M1_1.iovss 1.05017f
C461 a_10870_32196# Clamp_N_M1_1.iovss 1.11157f
C462 a_10734_32196# Clamp_N_M1_1.iovss 1.1635f
C463 a_10598_32196# Clamp_N_M1_1.iovss 1.87881f
C464 a_10462_29580# Clamp_N_M1_1.iovss 1.15542f
C465 a_10326_29580# Clamp_N_M1_1.iovss 1.28099f
C466 a_10190_29580# Clamp_N_M1_1.iovss 1.38369f
C467 a_10054_29580# Clamp_N_M1_1.iovss 2.0911f
C468 a_9918_32196# Clamp_N_M1_1.iovss 1.04138f
C469 a_9782_32196# Clamp_N_M1_1.iovss 1.08734f
C470 a_9646_32196# Clamp_N_M1_1.iovss 1.15443f
C471 a_9510_32196# Clamp_N_M1_1.iovss 1.86057f
C472 d2s_block_0.iref Clamp_N_M1_1.iovss 5.2928f
C473 d2s_block_0.d2s_rhigh_f2_0.sb_A Clamp_N_M1_1.iovss 11.3569f
C474 d2s_block_0.d2s_rhigh_f2_0.sa_C2 Clamp_N_M1_1.iovss 8.98262f
C475 d2s_block_0.d2s_rhigh_f2_0.sa_C1 Clamp_N_M1_1.iovss 5.45802f
C476 d2s_block_0.d2s_rhigh_f2_0.sb_B Clamp_N_M1_1.iovss 8.91756f
C477 d2s_block_0.d2s_rhigh_f2_0.sa_B Clamp_N_M1_1.iovss 7.41418f
C478 d2s_block_0.d2s_rhigh_f2_0.sb_C1 Clamp_N_M1_1.iovss 4.20856f
C479 d2s_block_0.d2s_rhigh_f2_0.sb_C2 Clamp_N_M1_1.iovss 4.87602f
C480 d2s_block_0.d2s_rhigh_f2_0.sa_A Clamp_N_M1_1.iovss 6.30954f
C481 TopLayersTo4_0.vdd Clamp_N_M1_1.iovss 0.20725p ; **FLOATING
.ends
