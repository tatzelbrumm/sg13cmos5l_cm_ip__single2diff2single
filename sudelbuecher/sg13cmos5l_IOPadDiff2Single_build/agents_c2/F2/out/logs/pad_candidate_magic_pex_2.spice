* PEX produced on Tue Nov  3 14:23:56 UTC 2026 using /usr/local/bin/sak-pex.sh with m=2 and s=1
* NGSPICE file created from sg13cmos5l_IOPadDiff2Single.ext - technology: ihp-sg13cmos5l

.subckt sg13cmos5l_IOPadDiff2Single pad
X0 DCNDiode_0.guard d2s_block_0.d2s_casc_p_c2_0.vbpc DCNDiode_0.guard DCNDiode_0.guard sg13_hv_pmos ad=0.34p pd=2.68u as=0.90339n ps=3.59803m w=1u l=4u
X1 pad d2s_cma_0.a DCNDiode_0.guard DCNDiode_0.guard sg13_hv_pmos ad=3.9294p pd=7.84u as=2.1312p ps=7.3u w=6.66u l=0.6u
X2 pad Clamp_N_M1_wiring_0.b Clamp_N_M1_1.iovss Clamp_N_M1_1.iovss sg13_hv_nmos ad=2.596p pd=5.58u as=1.408p ps=5.04u w=4.4u l=1u
X3 d2s_block_0.d2s_sp2k_f2_1.core d2s_cma_0.a d2s_block_0.d2s_sp2k_f2_1.core d2s_block_0.d2s_sp2k_f2_1.core sg13_hv_pmos ad=2.7064p pd=16.6u as=40.5004p ps=0.1292m w=7.96u l=32.16u
X4 d2s_block_0.d2s_tgsw_f2_0.ni d2s_block_0.en_3v3_b d2s_block_0.iref DCNDiode_0.guard sg13_hv_pmos ad=0.34p pd=2.68u as=0.34p ps=2.68u w=1u l=0.45u
X5 Clamp_N_M1_1.iovss pad dantenna l=1.26u w=67.6u
X6 pad d2s_cma_0.a DCNDiode_0.guard DCNDiode_0.guard sg13_hv_pmos ad=3.9294p pd=7.84u as=2.1312p ps=7.3u w=6.66u l=0.6u
X7 d2s_block_0.bias_tree_p_f2_0.vbn d2s_block_0.bias_tree_p_f2_0.vbn d2s_block_0.bias_tree_p_f2_0.vbn Clamp_N_M1_1.iovss sg13_hv_nmos ad=0.68p pd=4.68u as=31.08205p ps=0.23533m w=2u l=6u
X8 Clamp_N_M1_1.iovss d2s_block_0.en_3v3_b Clamp_N_M1_wiring_0.b Clamp_N_M1_1.iovss sg13_hv_nmos ad=0.34p pd=2.68u as=0.34p ps=2.68u w=1u l=0.45u
X9 d2s_block_0.d2s_sp2k_f2_0.core pad Clamp_N_M1_1.iovss rppd l=7.435u w=1u
X10 DCNDiode_0.guard d2s_cma_0.a pad DCNDiode_0.guard sg13_hv_pmos ad=2.1312p pd=7.3u as=3.9294p ps=7.84u w=6.66u l=0.6u
X11 Clamp_N_M1_1.iovss Clamp_N_M1_wiring_0.b pad Clamp_N_M1_1.iovss sg13_hv_nmos ad=1.408p pd=5.04u as=2.596p ps=5.58u w=4.4u l=1u
X12 Clamp_N_M1_1.iovss d2s_block_0.bias_tree_p_f2_0.vbn d2s_block_0.d2s_inputs_c2_0.y Clamp_N_M1_1.iovss sg13_hv_nmos ad=2.04p pd=12.68u as=2.04p ps=12.68u w=6u l=6u
X13 d2s_block_0.d2s_ab_p_f2_0.l1 d2s_block_0.d2s_ab_p_f2_0.vabp d2s_block_0.d2s_loads_c2_0.l2 DCNDiode_0.guard sg13_hv_pmos ad=2.2644p pd=14u as=2.2644p ps=14u w=6.66u l=0.6u
X14 d2s_block_0.d2s_ab_p_f2_0.l1 d2s_block_0.bias_tree_p_f2_0.vabn d2s_block_0.d2s_loads_c2_0.l2 Clamp_N_M1_1.iovss sg13_hv_nmos ad=1.496p pd=9.48u as=1.496p ps=9.48u w=4.4u l=1u
X15 pad d2s_cma_0.a DCNDiode_0.guard DCNDiode_0.guard sg13_hv_pmos ad=3.9294p pd=7.84u as=2.1312p ps=7.3u w=6.66u l=0.6u
X16 pad Clamp_N_M1_wiring_0.b Clamp_N_M1_1.iovss Clamp_N_M1_1.iovss sg13_hv_nmos ad=2.596p pd=5.58u as=1.408p ps=5.04u w=4.4u l=1u
X17 d2s_block_0.d2s_inputs_c2_0.y d2s_block_0.vref d2s_block_0.d2s_inputs_c2_0.sa_C2 d2s_block_0.d2s_inputs_c2_0.sa_C2 sg13_hv_pmos ad=1.9p pd=10.38u as=3.4p ps=20.68u w=10u l=1u
X18 Clamp_N_M1_1.iovss d2s_block_0.bias_tree_p_f2_0.vbn d2s_block_0.d2s_inputs_c2_0.x Clamp_N_M1_1.iovss sg13_hv_nmos ad=2.04p pd=12.68u as=2.04p ps=12.68u w=6u l=6u
X19 DCNDiode_0.guard d2s_block_0.d2s_loads_c2_0.l2 d2s_block_0.d2s_loads_c2_0.pr DCNDiode_0.guard sg13_hv_pmos ad=2.04p pd=12.68u as=2.04p ps=12.68u w=6u l=4u
X20 pad d2s_cma_0.a DCNDiode_0.guard DCNDiode_0.guard sg13_hv_pmos ad=3.9294p pd=7.84u as=2.1312p ps=7.3u w=6.66u l=0.6u
X21 pad DCNDiode_0.guard dpantenna l=1.26u w=65.8u
X22 Clamp_N_M1_1.iovss d2s_block_0.bias_tree_p_f2_0.vbnc d2s_block_0.bias_tree_p_f2_0.vbnc Clamp_N_M1_1.iovss sg13_hv_nmos ad=0.34p pd=2.68u as=0.34p ps=2.68u w=1u l=8u
X23 pad d2s_cma_0.a DCNDiode_0.guard DCNDiode_0.guard sg13_hv_pmos ad=4.9284p pd=14.8u as=2.1312p ps=7.3u w=6.66u l=0.6u
X24 d2s_block_0.d2s_inputs_c2_0.x pad d2s_block_0.d2s_inputs_c2_0.sb_C2 d2s_block_0.d2s_inputs_c2_0.sb_C2 sg13_hv_pmos ad=1.9p pd=10.38u as=3.4p ps=20.68u w=10u l=1u
X25 Clamp_N_M1_1.iovss Clamp_N_M1_wiring_0.b pad Clamp_N_M1_1.iovss sg13_hv_nmos ad=1.408p pd=5.04u as=2.596p ps=5.58u w=4.4u l=1u
X26 pad d2s_cma_0.a DCNDiode_0.guard DCNDiode_0.guard sg13_hv_pmos ad=3.9294p pd=7.84u as=2.1312p ps=7.3u w=6.66u l=0.6u
X27 pad Clamp_N_M1_wiring_0.b Clamp_N_M1_1.iovss Clamp_N_M1_1.iovss sg13_hv_nmos ad=2.596p pd=5.58u as=1.408p ps=5.04u w=4.4u l=1u
X28 pad Clamp_N_M1_wiring_0.b Clamp_N_M1_1.iovss Clamp_N_M1_1.iovss sg13_hv_nmos ad=2.596p pd=5.58u as=1.408p ps=5.04u w=4.4u l=1u
X29 DCNDiode_0.guard d2s_cma_0.a pad DCNDiode_0.guard sg13_hv_pmos ad=2.1312p pd=7.3u as=3.9294p ps=7.84u w=6.66u l=0.6u
X30 DCNDiode_0.guard d2s_cma_0.a pad DCNDiode_0.guard sg13_hv_pmos ad=2.1312p pd=7.3u as=3.9294p ps=7.84u w=6.66u l=0.6u
X31 d2s_block_0.d2s_loads_c2_0.pr d2s_block_0.d2s_casc_p_c2_0.vbpc d2s_cma_0.a DCNDiode_0.guard sg13_hv_pmos ad=5.1p pd=30.68u as=5.1p ps=30.68u w=15u l=3u
X32 d2s_block_0.d2s_loads_c2_0.pl d2s_block_0.d2s_loads_c2_0.l2 DCNDiode_0.guard DCNDiode_0.guard sg13_hv_pmos ad=2.04p pd=12.68u as=2.04p ps=12.68u w=6u l=4u
X33 DCNDiode_0.guard d2s_cma_0.a pad DCNDiode_0.guard sg13_hv_pmos ad=2.1312p pd=7.3u as=3.9294p ps=7.84u w=6.66u l=0.6u
X34 Clamp_N_M1_1.iovss Clamp_N_M1_wiring_0.b pad Clamp_N_M1_1.iovss sg13_hv_nmos ad=1.408p pd=5.04u as=2.596p ps=5.58u w=4.4u l=1u
X35 Clamp_N_M1_1.iovss Clamp_N_M1_wiring_0.b pad Clamp_N_M1_1.iovss sg13_hv_nmos ad=1.408p pd=5.04u as=2.596p ps=5.58u w=4.4u l=1u
X36 Clamp_N_M1_1.iovss Clamp_N_M1_wiring_0.b pad Clamp_N_M1_1.iovss sg13_hv_nmos ad=1.408p pd=5.04u as=2.596p ps=5.58u w=4.4u l=1u
X37 DCNDiode_0.guard d2s_cma_0.a pad DCNDiode_0.guard sg13_hv_pmos ad=2.1312p pd=7.3u as=3.9294p ps=7.84u w=6.66u l=0.6u
X38 pad d2s_cma_0.a DCNDiode_0.guard DCNDiode_0.guard sg13_hv_pmos ad=3.9294p pd=7.84u as=2.1312p ps=7.3u w=6.66u l=0.6u
X39 pad d2s_cma_0.a DCNDiode_0.guard DCNDiode_0.guard sg13_hv_pmos ad=3.9294p pd=7.84u as=2.1312p ps=7.3u w=6.66u l=0.6u
X40 pad Clamp_N_M1_wiring_0.b Clamp_N_M1_1.iovss Clamp_N_M1_1.iovss sg13_hv_nmos ad=2.596p pd=5.58u as=1.408p ps=5.04u w=4.4u l=1u
X41 DCNDiode_0.guard d2s_block_0.d2s_loads_c2_0.l2 d2s_block_0.d2s_loads_c2_0.pr DCNDiode_0.guard sg13_hv_pmos ad=2.04p pd=12.68u as=2.04p ps=12.68u w=6u l=4u
X42 pad Clamp_N_M1_wiring_0.b Clamp_N_M1_1.iovss Clamp_N_M1_1.iovss sg13_hv_nmos ad=2.596p pd=5.58u as=1.408p ps=5.04u w=4.4u l=1u
X43 DCNDiode_0.guard d2s_cma_0.a pad DCNDiode_0.guard sg13_hv_pmos ad=2.1312p pd=7.3u as=3.9294p ps=7.84u w=6.66u l=0.6u
X44 DCNDiode_0.guard d2s_block_0.d2s_tails_c2_0.vbp d2s_block_0.bias_tree_p_f2_0.vabn DCNDiode_0.guard sg13_hv_pmos ad=1.7p pd=10.68u as=1.7p ps=10.68u w=5u l=6u
X45 a_10598_32196# a_10462_29580# Clamp_N_M1_1.iovss rhigh l=12.65u w=0.5u
X46 DCNDiode_0.guard d2s_block_0.d2s_casc_p_c2_0.vbpc d2s_block_0.d2s_casc_p_c2_0.vbpc DCNDiode_0.guard sg13_hv_pmos ad=0.34p pd=2.68u as=0.34p ps=2.68u w=1u l=4u
X47 pad d2s_cma_0.a DCNDiode_0.guard DCNDiode_0.guard sg13_hv_pmos ad=3.9294p pd=7.84u as=2.1312p ps=7.3u w=6.66u l=0.6u
X48 Clamp_N_M1_1.iovss Clamp_N_M1_wiring_0.b pad Clamp_N_M1_1.iovss sg13_hv_nmos ad=1.408p pd=5.04u as=2.596p ps=5.58u w=4.4u l=1u
X49 Clamp_N_M1_1.iovss d2s_block_0.d2s_tgsw_f2_0.ni d2s_block_0.d2s_tails_c2_0.vbp Clamp_N_M1_1.iovss sg13_hv_nmos ad=2.04p pd=12.68u as=2.04p ps=12.68u w=6u l=6u
X50 Clamp_N_M1_1.iovss d2s_block_0.d2s_tgsw_f2_0.ni d2s_block_0.d2s_tgsw_f2_0.ni Clamp_N_M1_1.iovss sg13_hv_nmos ad=2.04p pd=12.68u as=2.04p ps=12.68u w=6u l=6u
X51 pad Clamp_N_M1_wiring_0.b Clamp_N_M1_1.iovss Clamp_N_M1_1.iovss sg13_hv_nmos ad=2.596p pd=5.58u as=1.408p ps=5.04u w=4.4u l=1u
X52 Clamp_N_M1_wiring_0.b d2s_block_0.d2s_sp2k_f2_0.core Clamp_N_M1_wiring_0.b Clamp_N_M1_wiring_0.b sg13_hv_pmos ad=2.7064p pd=16.6u as=0.35189n ps=1.20463m w=7.96u l=32.16u
X53 d2s_block_0.bias_tree_p_f2_0.vbn d2s_block_0.bias_tree_p_f2_0.vbn d2s_block_0.bias_tree_p_f2_0.vbn Clamp_N_M1_1.iovss sg13_hv_nmos ad=0.68p pd=4.68u as=0 ps=0 w=2u l=6u
X54 d2s_block_0.d2s_loads_c2_0.pl d2s_block_0.d2s_loads_c2_0.l2 DCNDiode_0.guard DCNDiode_0.guard sg13_hv_pmos ad=2.04p pd=12.68u as=2.04p ps=12.68u w=6u l=4u
X55 DCNDiode_0.guard d2s_cma_0.a pad DCNDiode_0.guard sg13_hv_pmos ad=2.1312p pd=7.3u as=3.9294p ps=7.84u w=6.66u l=0.6u
X56 pad Clamp_N_M1_wiring_0.b Clamp_N_M1_1.iovss Clamp_N_M1_1.iovss sg13_hv_nmos ad=2.596p pd=5.58u as=1.408p ps=5.04u w=4.4u l=1u
X57 pad d2s_cma_0.a DCNDiode_0.guard DCNDiode_0.guard sg13_hv_pmos ad=3.9294p pd=7.84u as=2.1312p ps=7.3u w=6.66u l=0.6u
X58 DCNDiode_0.guard d2s_cma_0.a pad DCNDiode_0.guard sg13_hv_pmos ad=2.1312p pd=7.3u as=3.9294p ps=7.84u w=6.66u l=0.6u
X59 Clamp_N_M1_1.iovss Clamp_N_M1_wiring_0.b pad Clamp_N_M1_1.iovss sg13_hv_nmos ad=1.408p pd=5.04u as=2.596p ps=5.58u w=4.4u l=1u
X60 Clamp_N_M1_1.iovss d2s_block_0.d2s_sp2k_f2_1.core dantenna l=3.1u w=0.64u
X61 d2s_block_0.d2s_inputs_c2_0.sb_A d2s_block_0.d2s_tails_c2_0.vbp DCNDiode_0.guard DCNDiode_0.guard sg13_hv_pmos ad=1.7p pd=10.68u as=1.7p ps=10.68u w=5u l=6u
X62 Clamp_N_M1_1.iovss d2s_block_0.bias_tree_p_f2_0.vbn d2s_block_0.d2s_inputs_c2_0.y Clamp_N_M1_1.iovss sg13_hv_nmos ad=2.04p pd=12.68u as=2.04p ps=12.68u w=6u l=6u
X63 d2s_block_0.d2s_inputs_c2_0.sa_B d2s_block_0.vref d2s_block_0.d2s_inputs_c2_0.y d2s_block_0.d2s_inputs_c2_0.sa_B sg13_hv_pmos ad=3.4p pd=20.68u as=1.9p ps=10.38u w=10u l=1u
X64 d2s_block_0.d2s_inputs_c2_0.y d2s_block_0.vref d2s_block_0.d2s_inputs_c2_0.sa_C1 d2s_block_0.d2s_inputs_c2_0.sa_C1 sg13_hv_pmos ad=1.9p pd=10.38u as=3.4p ps=20.68u w=10u l=1u
X65 d2s_block_0.d2s_inputs_c2_0.y d2s_block_0.bias_tree_p_f2_0.vbn Clamp_N_M1_1.iovss Clamp_N_M1_1.iovss sg13_hv_nmos ad=2.04p pd=12.68u as=2.04p ps=12.68u w=6u l=6u
X66 DCNDiode_0.guard d2s_cma_0.a pad DCNDiode_0.guard sg13_hv_pmos ad=2.1312p pd=7.3u as=3.9294p ps=7.84u w=6.66u l=0.6u
X67 pad d2s_cma_0.a DCNDiode_0.guard DCNDiode_0.guard sg13_hv_pmos ad=3.9294p pd=7.84u as=2.1312p ps=7.3u w=6.66u l=0.6u
X68 DCNDiode_0.guard d2s_block_0.d2s_tails_c2_0.vbp DCNDiode_0.guard DCNDiode_0.guard sg13_hv_pmos ad=0.68p pd=4.68u as=0 ps=0 w=2u l=6u
X69 d2s_block_0.d2s_tgsw_f2_0.ni d2s_block_0.en_3v3 d2s_block_0.iref Clamp_N_M1_1.iovss sg13_hv_nmos ad=0.34p pd=2.68u as=0.34p ps=2.68u w=1u l=0.45u
X70 pad Clamp_N_M1_wiring_0.b Clamp_N_M1_1.iovss Clamp_N_M1_1.iovss sg13_hv_nmos ad=2.596p pd=5.58u as=1.408p ps=5.04u w=4.4u l=1u
X71 DCNDiode_0.guard d2s_block_0.en_3v3 d2s_cma_0.a DCNDiode_0.guard sg13_hv_pmos ad=0.34p pd=2.68u as=0.34p ps=2.68u w=1u l=0.45u
X72 pad DCNDiode_0.guard dpantenna l=1.26u w=65.8u
X73 d2s_block_0.d2s_tgsw_f2_0.ni d2s_block_0.en_3v3_b Clamp_N_M1_1.iovss Clamp_N_M1_1.iovss sg13_hv_nmos ad=0.34p pd=2.68u as=0.34p ps=2.68u w=1u l=0.45u
X74 d2s_block_0.d2s_sp2k_f2_1.core pad Clamp_N_M1_1.iovss rppd l=7.435u w=1u
X75 DCNDiode_0.guard d2s_cma_0.a pad DCNDiode_0.guard sg13_hv_pmos ad=2.1312p pd=7.3u as=3.9294p ps=7.84u w=6.66u l=0.6u
X76 Clamp_N_M1_1.iovss Clamp_N_M1_wiring_0.b pad Clamp_N_M1_1.iovss sg13_hv_nmos ad=1.408p pd=5.04u as=2.596p ps=5.58u w=4.4u l=1u
X77 Clamp_N_M1_1.iovss Clamp_N_M1_wiring_0.b pad Clamp_N_M1_1.iovss sg13_hv_nmos ad=1.408p pd=5.04u as=2.596p ps=5.58u w=4.4u l=1u
X78 DCNDiode_0.guard d2s_cma_0.a pad DCNDiode_0.guard sg13_hv_pmos ad=2.1312p pd=7.3u as=3.9294p ps=7.84u w=6.66u l=0.6u
X79 d2s_block_0.d2s_inputs_c2_0.sb_C1 pad d2s_block_0.d2s_inputs_c2_0.x d2s_block_0.d2s_inputs_c2_0.sb_C1 sg13_hv_pmos ad=3.4p pd=20.68u as=1.9p ps=10.38u w=10u l=1u
X80 a_9510_32196# d2s_block_0.d2s_inputs_c2_0.sa_A Clamp_N_M1_1.iovss rhigh l=12.65u w=0.5u
X81 DCNDiode_0.guard DCNDiode_0.guard DCNDiode_0.guard DCNDiode_0.guard sg13_hv_pmos ad=3.4p pd=20.68u as=0 ps=0 w=10u l=1u
X82 DCNDiode_0.guard d2s_block_0.d2s_tails_c2_0.vbp DCNDiode_0.guard DCNDiode_0.guard sg13_hv_pmos ad=1.7p pd=10.68u as=0 ps=0 w=5u l=6u
X83 Clamp_N_M1_1.iovss Clamp_N_M1_wiring_0.b pad Clamp_N_M1_1.iovss sg13_hv_nmos ad=1.408p pd=5.04u as=2.596p ps=5.58u w=4.4u l=1u
X84 d2s_block_0.d2s_loads_c2_0.l2 d2s_block_0.d2s_casc_p_c2_0.vbpc d2s_block_0.d2s_loads_c2_0.pl DCNDiode_0.guard sg13_hv_pmos ad=5.1p pd=30.68u as=5.1p ps=30.68u w=15u l=3u
X85 pad d2s_cma_0.a DCNDiode_0.guard DCNDiode_0.guard sg13_hv_pmos ad=3.9294p pd=7.84u as=2.1312p ps=7.3u w=6.66u l=0.6u
X86 DCNDiode_0.guard d2s_cma_0.a pad DCNDiode_0.guard sg13_hv_pmos ad=2.1312p pd=7.3u as=3.9294p ps=7.84u w=6.66u l=0.6u
X87 DCNDiode_0.guard DCNDiode_0.guard DCNDiode_0.guard DCNDiode_0.guard sg13_hv_pmos ad=2.2644p pd=14u as=0 ps=0 w=6.66u l=0.6u
X88 Clamp_N_M1_1.iovss Clamp_N_M1_wiring_0.b pad Clamp_N_M1_1.iovss sg13_hv_nmos ad=1.408p pd=5.04u as=2.596p ps=5.58u w=4.4u l=1u
X89 pad Clamp_N_M1_wiring_0.b Clamp_N_M1_1.iovss Clamp_N_M1_1.iovss sg13_hv_nmos ad=2.596p pd=5.58u as=2.068p ps=9.74u w=4.4u l=1u
X90 pad Clamp_N_M1_wiring_0.b Clamp_N_M1_1.iovss Clamp_N_M1_1.iovss sg13_hv_nmos ad=2.596p pd=5.58u as=1.408p ps=5.04u w=4.4u l=1u
X91 Clamp_N_M1_1.iovss d2s_block_0.d2s_tgsw_f2_0.ni d2s_block_0.d2s_casc_p_c2_0.vbpc Clamp_N_M1_1.iovss sg13_hv_nmos ad=0.816p pd=5.48u as=0.816p ps=5.48u w=2.4u l=6u
X92 a_10734_32196# d2s_block_0.d2s_inputs_c2_0.sb_B Clamp_N_M1_1.iovss rhigh l=12.65u w=0.5u
X93 Clamp_P_M1_wiring_0.dabp d2s_block_0.d2s_ab_p_f2_0.vabp d2s_block_0.d2s_ab_p_f2_0.vabp DCNDiode_0.guard sg13_hv_pmos ad=2.2644p pd=14u as=2.2644p ps=14u w=6.66u l=0.6u
X94 pad d2s_cma_0.a DCNDiode_0.guard DCNDiode_0.guard sg13_hv_pmos ad=3.9294p pd=7.84u as=2.1312p ps=7.3u w=6.66u l=0.6u
X95 d2s_block_0.d2s_inputs_c2_0.sa_C1 d2s_block_0.d2s_tails_c2_0.vbp DCNDiode_0.guard DCNDiode_0.guard sg13_hv_pmos ad=1.7p pd=10.68u as=1.7p ps=10.68u w=5u l=6u
X96 a_11006_32196# a_10054_29580# Clamp_N_M1_1.iovss rhigh l=12.65u w=0.5u
X97 pad d2s_cma_0.a DCNDiode_0.guard DCNDiode_0.guard sg13_hv_pmos ad=3.9294p pd=7.84u as=2.1312p ps=7.3u w=6.66u l=0.6u
X98 Clamp_N_M1_1.iovss Clamp_N_M1_wiring_0.b pad Clamp_N_M1_1.iovss sg13_hv_nmos ad=1.408p pd=5.04u as=2.596p ps=5.58u w=4.4u l=1u
X99 Clamp_N_M1_1.iovss Clamp_N_M1_wiring_0.b pad Clamp_N_M1_1.iovss sg13_hv_nmos ad=1.408p pd=5.04u as=2.596p ps=5.58u w=4.4u l=1u
X100 DCNDiode_0.guard d2s_cma_0.a pad DCNDiode_0.guard sg13_hv_pmos ad=2.1312p pd=7.3u as=3.9294p ps=7.84u w=6.66u l=0.6u
X101 DCNDiode_0.guard d2s_block_0.d2s_tails_c2_0.vbp d2s_block_0.bias_tree_p_f2_0.vbn DCNDiode_0.guard sg13_hv_pmos ad=1.7p pd=10.68u as=1.7p ps=10.68u w=5u l=6u
X102 d2s_block_0.d2s_inputs_c2_0.sb_A d2s_block_0.vref d2s_block_0.d2s_inputs_c2_0.x d2s_block_0.d2s_inputs_c2_0.sb_A sg13_hv_pmos ad=3.4p pd=20.68u as=1.9p ps=10.38u w=10u l=1u
X103 Clamp_N_M1_wiring_0.b d2s_block_0.bias_tree_p_f2_0.vabn d2s_cma_0.a Clamp_N_M1_1.iovss sg13_hv_nmos ad=1.496p pd=9.48u as=1.496p ps=9.48u w=4.4u l=1u
X104 pad Clamp_N_M1_wiring_0.b Clamp_N_M1_1.iovss Clamp_N_M1_1.iovss sg13_hv_nmos ad=3.256p pd=10.28u as=1.408p ps=5.04u w=4.4u l=1u
X105 d2s_block_0.d2s_inputs_c2_0.y d2s_block_0.vinp d2s_block_0.d2s_inputs_c2_0.sa_A d2s_block_0.d2s_inputs_c2_0.sa_A sg13_hv_pmos ad=1.9p pd=10.38u as=3.4p ps=20.68u w=10u l=1u
X106 pad Clamp_N_M1_wiring_0.b Clamp_N_M1_1.iovss Clamp_N_M1_1.iovss sg13_hv_nmos ad=2.596p pd=5.58u as=1.408p ps=5.04u w=4.4u l=1u
X107 d2s_block_0.d2s_inputs_c2_0.y d2s_block_0.bias_tree_p_f2_0.vbn Clamp_N_M1_1.iovss Clamp_N_M1_1.iovss sg13_hv_nmos ad=2.04p pd=12.68u as=2.04p ps=12.68u w=6u l=6u
X108 DCNDiode_0.guard d2s_cma_0.a pad DCNDiode_0.guard sg13_hv_pmos ad=2.1312p pd=7.3u as=3.9294p ps=7.84u w=6.66u l=0.6u
X109 d2s_block_0.bias_tree_p_f2_0.vbn d2s_block_0.bias_tree_p_f2_0.vbn d2s_block_0.bias_tree_p_f2_0.vbn Clamp_N_M1_1.iovss sg13_hv_nmos ad=2.04p pd=12.68u as=0 ps=0 w=6u l=6u
X110 d2s_block_0.bias_tree_p_f2_0.vbn d2s_block_0.bias_tree_p_f2_0.vbn d2s_block_0.bias_tree_p_f2_0.vbn Clamp_N_M1_1.iovss sg13_hv_nmos ad=0.68p pd=4.68u as=0 ps=0 w=2u l=6u
X111 Clamp_N_M1_1.iovss Clamp_N_M1_wiring_0.b pad Clamp_N_M1_1.iovss sg13_hv_nmos ad=1.408p pd=5.04u as=2.596p ps=5.58u w=4.4u l=1u
X112 d2s_block_0.bias_tree_p_f2_0.vbnc d2s_block_0.bias_tree_p_f2_0.vbnc d2s_block_0.bias_tree_p_f2_0.vbnc Clamp_N_M1_1.iovss sg13_hv_nmos ad=0.68p pd=4.68u as=19.07282p ps=0.15628m w=2u l=3u
X113 Clamp_N_M1_1.iovss Clamp_N_M1_1.iovss Clamp_N_M1_1.iovss Clamp_N_M1_1.iovss sg13_hv_nmos ad=1.496p pd=9.48u as=0.8943n ps=3.44684m w=4.4u l=1u
X114 d2s_block_0.d2s_sp2k_f2_0.core DCNDiode_0.guard dpantenna l=0.64u w=4.98u
X115 DCNDiode_0.guard d2s_cma_0.a pad DCNDiode_0.guard sg13_hv_pmos ad=2.1312p pd=7.3u as=3.9294p ps=7.84u w=6.66u l=0.6u
X116 DCNDiode_0.guard Clamp_P_M1_wiring_0.dabp Clamp_P_M1_wiring_0.dabp DCNDiode_0.guard sg13_hv_pmos ad=2.1312p pd=7.3u as=3.9294p ps=7.84u w=6.66u l=0.6u
X117 DCNDiode_0.guard d2s_block_0.d2s_loads_c2_0.l2 DCNDiode_0.guard DCNDiode_0.guard sg13_hv_pmos ad=0.34p pd=2.68u as=0 ps=0 w=1u l=4u
X118 pad d2s_cma_0.a DCNDiode_0.guard DCNDiode_0.guard sg13_hv_pmos ad=3.9294p pd=7.84u as=2.1312p ps=7.3u w=6.66u l=0.6u
X119 DCNDiode_0.guard d2s_cma_0.a pad DCNDiode_0.guard sg13_hv_pmos ad=2.1312p pd=7.3u as=3.9294p ps=7.84u w=6.66u l=0.6u
X120 d2s_block_0.d2s_inputs_c2_0.sa_C2 d2s_block_0.vref d2s_block_0.d2s_inputs_c2_0.y d2s_block_0.d2s_inputs_c2_0.sa_C2 sg13_hv_pmos ad=3.4p pd=20.68u as=1.9p ps=10.38u w=10u l=1u
X121 d2s_block_0.d2s_inputs_c2_0.sa_C2 d2s_block_0.d2s_tails_c2_0.vbp DCNDiode_0.guard DCNDiode_0.guard sg13_hv_pmos ad=1.7p pd=10.68u as=1.7p ps=10.68u w=5u l=6u
X122 d2s_block_0.d2s_inputs_c2_0.sa_A d2s_block_0.vinp d2s_block_0.d2s_inputs_c2_0.y d2s_block_0.d2s_inputs_c2_0.sa_A sg13_hv_pmos ad=3.4p pd=20.68u as=1.9p ps=10.38u w=10u l=1u
X123 Clamp_N_M1_wiring_0.b d2s_block_0.bias_tree_p_f2_0.vbnc d2s_block_0.d2s_inputs_c2_0.y Clamp_N_M1_1.iovss sg13_hv_nmos ad=5.1p pd=30.68u as=5.1p ps=30.68u w=15u l=3u
X124 Clamp_N_M1_1.iovss Clamp_N_M1_wiring_0.b pad Clamp_N_M1_1.iovss sg13_hv_nmos ad=1.408p pd=5.04u as=2.596p ps=5.58u w=4.4u l=1u
X125 DCNDiode_0.guard DCNDiode_0.guard DCNDiode_0.guard DCNDiode_0.guard sg13_hv_pmos ad=3.4p pd=20.68u as=0 ps=0 w=10u l=1u
X126 Clamp_N_M1_1.iovss d2s_block_0.bias_tree_p_f2_0.vbn d2s_block_0.d2s_inputs_c2_0.x Clamp_N_M1_1.iovss sg13_hv_nmos ad=2.04p pd=12.68u as=2.04p ps=12.68u w=6u l=6u
X127 pad d2s_cma_0.a DCNDiode_0.guard DCNDiode_0.guard sg13_hv_pmos ad=3.9294p pd=7.84u as=2.1312p ps=7.3u w=6.66u l=0.6u
X128 pad Clamp_N_M1_wiring_0.b Clamp_N_M1_1.iovss Clamp_N_M1_1.iovss sg13_hv_nmos ad=2.596p pd=5.58u as=1.408p ps=5.04u w=4.4u l=1u
X129 pad Clamp_N_M1_wiring_0.b Clamp_N_M1_1.iovss Clamp_N_M1_1.iovss sg13_hv_nmos ad=2.596p pd=5.58u as=1.408p ps=5.04u w=4.4u l=1u
X130 DCNDiode_0.guard d2s_cma_0.a pad DCNDiode_0.guard sg13_hv_pmos ad=2.1312p pd=7.3u as=3.9294p ps=7.84u w=6.66u l=0.6u
X131 pad d2s_cma_0.a DCNDiode_0.guard DCNDiode_0.guard sg13_hv_pmos ad=3.9294p pd=7.84u as=2.1312p ps=7.3u w=6.66u l=0.6u
X132 pad Clamp_N_M1_wiring_0.b Clamp_N_M1_1.iovss Clamp_N_M1_1.iovss sg13_hv_nmos ad=2.596p pd=5.58u as=1.408p ps=5.04u w=4.4u l=1u
X133 a_10598_32196# d2s_block_0.d2s_inputs_c2_0.sb_A Clamp_N_M1_1.iovss rhigh l=12.65u w=0.5u
X134 DCNDiode_0.guard d2s_block_0.d2s_loads_c2_0.l2 DCNDiode_0.guard DCNDiode_0.guard sg13_hv_pmos ad=0.34p pd=2.68u as=0 ps=0 w=1u l=4u
X135 DCNDiode_0.guard d2s_cma_0.a pad DCNDiode_0.guard sg13_hv_pmos ad=2.1312p pd=7.3u as=3.9294p ps=7.84u w=6.66u l=0.6u
X136 pad d2s_cma_0.a DCNDiode_0.guard DCNDiode_0.guard sg13_hv_pmos ad=3.9294p pd=7.84u as=3.1302p ps=14.26u w=6.66u l=0.6u
X137 DCNDiode_0.guard d2s_block_0.d2s_tails_c2_0.vbp DCNDiode_0.guard DCNDiode_0.guard sg13_hv_pmos ad=1.7p pd=10.68u as=0 ps=0 w=5u l=6u
X138 a_11006_32196# d2s_block_0.d2s_inputs_c2_0.sb_C2 Clamp_N_M1_1.iovss rhigh l=12.65u w=0.5u
X139 Clamp_N_M1_1.iovss Clamp_N_M1_wiring_0.b pad Clamp_N_M1_1.iovss sg13_hv_nmos ad=1.408p pd=5.04u as=2.596p ps=5.58u w=4.4u l=1u
X140 Clamp_N_M1_1.iovss Clamp_N_M1_wiring_0.b pad Clamp_N_M1_1.iovss sg13_hv_nmos ad=1.408p pd=5.04u as=2.596p ps=5.58u w=4.4u l=1u
X141 Clamp_N_M1_1.iovss Clamp_N_M1_wiring_0.b pad Clamp_N_M1_1.iovss sg13_hv_nmos ad=1.408p pd=5.04u as=2.596p ps=5.58u w=4.4u l=1u
X142 pad d2s_cma_0.a DCNDiode_0.guard DCNDiode_0.guard sg13_hv_pmos ad=3.9294p pd=7.84u as=2.1312p ps=7.3u w=6.66u l=0.6u
X143 pad Clamp_N_M1_wiring_0.b Clamp_N_M1_1.iovss Clamp_N_M1_1.iovss sg13_hv_nmos ad=2.596p pd=5.58u as=1.408p ps=5.04u w=4.4u l=1u
X144 d2s_block_0.bias_tree_p_f2_0.vbnc d2s_block_0.bias_tree_p_f2_0.vbnc d2s_block_0.bias_tree_p_f2_0.vbnc Clamp_N_M1_1.iovss sg13_hv_nmos ad=0.68p pd=4.68u as=0 ps=0 w=2u l=3u
X145 pad Clamp_N_M1_wiring_0.b Clamp_N_M1_1.iovss Clamp_N_M1_1.iovss sg13_hv_nmos ad=2.596p pd=5.58u as=1.408p ps=5.04u w=4.4u l=1u
X146 DCNDiode_0.guard DCNDiode_0.guard DCNDiode_0.guard DCNDiode_0.guard sg13_hv_pmos ad=1.9p pd=10.38u as=0 ps=0 w=10u l=1u
X147 DCNDiode_0.guard d2s_cma_0.a pad DCNDiode_0.guard sg13_hv_pmos ad=2.1312p pd=7.3u as=3.9294p ps=7.84u w=6.66u l=0.6u
X148 d2s_block_0.d2s_inputs_c2_0.x d2s_block_0.vinn d2s_block_0.d2s_inputs_c2_0.sb_B d2s_block_0.d2s_inputs_c2_0.sb_B sg13_hv_pmos ad=1.9p pd=10.38u as=3.4p ps=20.68u w=10u l=1u
X149 DCNDiode_0.guard d2s_block_0.d2s_loads_c2_0.l2 d2s_block_0.d2s_loads_c2_0.pl DCNDiode_0.guard sg13_hv_pmos ad=2.04p pd=12.68u as=2.04p ps=12.68u w=6u l=4u
X150 DCNDiode_0.guard d2s_cma_0.a pad DCNDiode_0.guard sg13_hv_pmos ad=2.1312p pd=7.3u as=3.9294p ps=7.84u w=6.66u l=0.6u
X151 DCNDiode_0.guard Clamp_P_M1_wiring_0.dabp Clamp_P_M1_wiring_0.dabp DCNDiode_0.guard sg13_hv_pmos ad=2.1312p pd=7.3u as=3.9294p ps=7.84u w=6.66u l=0.6u
X152 Clamp_N_M1_1.iovss Clamp_N_M1_wiring_0.b pad Clamp_N_M1_1.iovss sg13_hv_nmos ad=1.408p pd=5.04u as=2.596p ps=5.58u w=4.4u l=1u
X153 DCNDiode_0.guard d2s_block_0.d2s_tails_c2_0.vbp d2s_block_0.d2s_inputs_c2_0.sa_B DCNDiode_0.guard sg13_hv_pmos ad=1.7p pd=10.68u as=1.7p ps=10.68u w=5u l=6u
X154 a_9918_32196# d2s_block_0.d2s_inputs_c2_0.sa_C2 Clamp_N_M1_1.iovss rhigh l=12.65u w=0.5u
X155 d2s_block_0.d2s_inputs_c2_0.x d2s_block_0.bias_tree_p_f2_0.vbnc d2s_block_0.d2s_ab_p_f2_0.l1 Clamp_N_M1_1.iovss sg13_hv_nmos ad=5.1p pd=30.68u as=5.1p ps=30.68u w=15u l=3u
X156 pad d2s_cma_0.a DCNDiode_0.guard DCNDiode_0.guard sg13_hv_pmos ad=3.9294p pd=7.84u as=2.1312p ps=7.3u w=6.66u l=0.6u
X157 pad Clamp_N_M1_wiring_0.b Clamp_N_M1_1.iovss Clamp_N_M1_1.iovss sg13_hv_nmos ad=2.596p pd=5.58u as=1.408p ps=5.04u w=4.4u l=1u
X158 pad Clamp_N_M1_wiring_0.b Clamp_N_M1_1.iovss Clamp_N_M1_1.iovss sg13_hv_nmos ad=2.596p pd=5.58u as=1.408p ps=5.04u w=4.4u l=1u
X159 d2s_block_0.d2s_inputs_c2_0.y d2s_block_0.vref d2s_block_0.d2s_inputs_c2_0.sa_B d2s_block_0.d2s_inputs_c2_0.sa_B sg13_hv_pmos ad=1.9p pd=10.38u as=3.4p ps=20.68u w=10u l=1u
X160 d2s_block_0.d2s_sp2k_f2_1.core DCNDiode_0.guard dpantenna l=0.64u w=4.98u
X161 DCNDiode_0.guard d2s_cma_0.a pad DCNDiode_0.guard sg13_hv_pmos ad=2.1312p pd=7.3u as=3.9294p ps=7.84u w=6.66u l=0.6u
X162 d2s_block_0.d2s_ab_p_f2_0.l1 d2s_block_0.bias_tree_p_f2_0.vbnc d2s_block_0.d2s_inputs_c2_0.x Clamp_N_M1_1.iovss sg13_hv_nmos ad=5.1p pd=30.68u as=5.1p ps=30.68u w=15u l=3u
X163 DCNDiode_0.guard d2s_cma_0.a pad DCNDiode_0.guard sg13_hv_pmos ad=2.1312p pd=7.3u as=3.9294p ps=7.84u w=6.66u l=0.6u
X164 Clamp_N_M1_1.iovss Clamp_N_M1_wiring_0.b pad Clamp_N_M1_1.iovss sg13_hv_nmos ad=1.408p pd=5.04u as=2.596p ps=5.58u w=4.4u l=1u
X165 d2s_block_0.d2s_inputs_c2_0.sb_B d2s_block_0.d2s_tails_c2_0.vbp DCNDiode_0.guard DCNDiode_0.guard sg13_hv_pmos ad=1.7p pd=10.68u as=1.7p ps=10.68u w=5u l=6u
X166 d2s_block_0.d2s_loads_c2_0.pr d2s_block_0.d2s_loads_c2_0.l2 DCNDiode_0.guard DCNDiode_0.guard sg13_hv_pmos ad=2.04p pd=12.68u as=2.04p ps=12.68u w=6u l=4u
X167 Clamp_N_M1_1.iovss Clamp_N_M1_wiring_0.b pad Clamp_N_M1_1.iovss sg13_hv_nmos ad=1.408p pd=5.04u as=2.596p ps=5.58u w=4.4u l=1u
X168 pad d2s_cma_0.a DCNDiode_0.guard DCNDiode_0.guard sg13_hv_pmos ad=3.9294p pd=7.84u as=3.1302p ps=14.26u w=6.66u l=0.6u
X169 Clamp_N_M1_wiring_0.dabn Clamp_N_M1_wiring_0.dabn Clamp_N_M1_1.iovss Clamp_N_M1_1.iovss sg13_hv_nmos ad=2.596p pd=5.58u as=1.408p ps=5.04u w=4.4u l=1u
X170 DCNDiode_0.guard d2s_cma_0.a pad DCNDiode_0.guard sg13_hv_pmos ad=2.1312p pd=7.3u as=3.9294p ps=7.84u w=6.66u l=0.6u
X171 d2s_block_0.d2s_inputs_c2_0.x d2s_block_0.bias_tree_p_f2_0.vbn Clamp_N_M1_1.iovss Clamp_N_M1_1.iovss sg13_hv_nmos ad=2.04p pd=12.68u as=2.04p ps=12.68u w=6u l=6u
X172 a_10734_32196# a_10326_29580# Clamp_N_M1_1.iovss rhigh l=12.65u w=0.5u
X173 d2s_block_0.d2s_inputs_c2_0.sb_B d2s_block_0.vinn d2s_block_0.d2s_inputs_c2_0.x d2s_block_0.d2s_inputs_c2_0.sb_B sg13_hv_pmos ad=3.4p pd=20.68u as=1.9p ps=10.38u w=10u l=1u
X174 pad d2s_cma_0.a DCNDiode_0.guard DCNDiode_0.guard sg13_hv_pmos ad=3.9294p pd=7.84u as=2.1312p ps=7.3u w=6.66u l=0.6u
X175 DCNDiode_0.guard d2s_block_0.d2s_tails_c2_0.vbp d2s_block_0.bias_tree_p_f2_0.vbnc DCNDiode_0.guard sg13_hv_pmos ad=0.68p pd=4.68u as=0.68p ps=4.68u w=2u l=6u
X176 a_9646_32196# a_10326_29580# Clamp_N_M1_1.iovss rhigh l=12.65u w=0.5u
X177 pad d2s_cma_0.a DCNDiode_0.guard DCNDiode_0.guard sg13_hv_pmos ad=3.9294p pd=7.84u as=2.1312p ps=7.3u w=6.66u l=0.6u
X178 DCNDiode_0.guard d2s_block_0.d2s_loads_c2_0.l2 d2s_block_0.d2s_loads_c2_0.pl DCNDiode_0.guard sg13_hv_pmos ad=2.04p pd=12.68u as=2.04p ps=12.68u w=6u l=4u
X179 d2s_block_0.d2s_loads_c2_0.pl d2s_block_0.d2s_casc_p_c2_0.vbpc d2s_block_0.d2s_loads_c2_0.l2 DCNDiode_0.guard sg13_hv_pmos ad=5.1p pd=30.68u as=5.1p ps=30.68u w=15u l=3u
X180 Clamp_N_M1_1.iovss d2s_block_0.bias_tree_p_f2_0.vbn d2s_block_0.d2s_inputs_c2_0.x Clamp_N_M1_1.iovss sg13_hv_nmos ad=2.04p pd=12.68u as=2.04p ps=12.68u w=6u l=6u
X181 pad Clamp_N_M1_wiring_0.b Clamp_N_M1_1.iovss Clamp_N_M1_1.iovss sg13_hv_nmos ad=2.596p pd=5.58u as=1.408p ps=5.04u w=4.4u l=1u
X182 DCNDiode_0.guard d2s_block_0.d2s_tails_c2_0.vbp DCNDiode_0.guard DCNDiode_0.guard sg13_hv_pmos ad=1.7p pd=10.68u as=0 ps=0 w=5u l=6u
X183 Clamp_N_M1_1.iovss d2s_block_0.bias_tree_p_f2_0.vbn d2s_block_0.bias_tree_p_f2_0.vbn Clamp_N_M1_1.iovss sg13_hv_nmos ad=2.04p pd=12.68u as=2.04p ps=12.68u w=6u l=6u
X184 d2s_block_0.bias_tree_p_f2_0.vabn d2s_block_0.en_3v3_b Clamp_N_M1_1.iovss Clamp_N_M1_1.iovss sg13_hv_nmos ad=0.34p pd=2.68u as=0.34p ps=2.68u w=1u l=0.45u
X185 DCNDiode_0.guard d2s_cma_0.a pad DCNDiode_0.guard sg13_hv_pmos ad=2.1312p pd=7.3u as=3.9294p ps=7.84u w=6.66u l=0.6u
X186 pad d2s_cma_0.a DCNDiode_0.guard DCNDiode_0.guard sg13_hv_pmos ad=3.9294p pd=7.84u as=2.1312p ps=7.3u w=6.66u l=0.6u
X187 d2s_block_0.d2s_tgsw_f2_0.ni d2s_block_0.d2s_tgsw_f2_0.ni d2s_block_0.d2s_tgsw_f2_0.ni Clamp_N_M1_1.iovss sg13_hv_nmos ad=0.816p pd=5.48u as=8.86665p ps=64.93u w=2.4u l=6u
X188 d2s_block_0.d2s_loads_c2_0.pr d2s_block_0.d2s_loads_c2_0.l2 DCNDiode_0.guard DCNDiode_0.guard sg13_hv_pmos ad=2.04p pd=12.68u as=2.04p ps=12.68u w=6u l=4u
X189 Clamp_N_M1_1.iovss Clamp_N_M1_wiring_0.b pad Clamp_N_M1_1.iovss sg13_hv_nmos ad=1.408p pd=5.04u as=2.596p ps=5.58u w=4.4u l=1u
X190 pad d2s_cma_0.a DCNDiode_0.guard DCNDiode_0.guard sg13_hv_pmos ad=3.9294p pd=7.84u as=2.1312p ps=7.3u w=6.66u l=0.6u
X191 DCNDiode_0.guard DCNDiode_0.guard DCNDiode_0.guard DCNDiode_0.guard sg13_hv_pmos ad=1.9p pd=10.38u as=0 ps=0 w=10u l=1u
X192 d2s_block_0.d2s_inputs_c2_0.y d2s_block_0.bias_tree_p_f2_0.vbnc Clamp_N_M1_wiring_0.b Clamp_N_M1_1.iovss sg13_hv_nmos ad=5.1p pd=30.68u as=5.1p ps=30.68u w=15u l=3u
X193 pad Clamp_N_M1_wiring_0.b Clamp_N_M1_1.iovss Clamp_N_M1_1.iovss sg13_hv_nmos ad=2.596p pd=5.58u as=1.408p ps=5.04u w=4.4u l=1u
X194 DCNDiode_0.guard d2s_block_0.d2s_tails_c2_0.vbp d2s_block_0.d2s_inputs_c2_0.sb_C2 DCNDiode_0.guard sg13_hv_pmos ad=1.7p pd=10.68u as=1.7p ps=10.68u w=5u l=6u
X195 a_9646_32196# d2s_block_0.d2s_inputs_c2_0.sa_B Clamp_N_M1_1.iovss rhigh l=12.65u w=0.5u
X196 DCNDiode_0.guard d2s_cma_0.a pad DCNDiode_0.guard sg13_hv_pmos ad=2.1312p pd=7.3u as=3.9294p ps=7.84u w=6.66u l=0.6u
X197 pad d2s_cma_0.a DCNDiode_0.guard DCNDiode_0.guard sg13_hv_pmos ad=3.9294p pd=7.84u as=2.1312p ps=7.3u w=6.66u l=0.6u
X198 Clamp_N_M1_1.iovss Clamp_N_M1_wiring_0.b pad Clamp_N_M1_1.iovss sg13_hv_nmos ad=1.408p pd=5.04u as=2.596p ps=5.58u w=4.4u l=1u
X199 DCNDiode_0.guard d2s_block_0.d2s_loads_c2_0.l2 DCNDiode_0.guard DCNDiode_0.guard sg13_hv_pmos ad=0.34p pd=2.68u as=0 ps=0 w=1u l=4u
X200 DCNDiode_0.guard d2s_cma_0.a pad DCNDiode_0.guard sg13_hv_pmos ad=2.1312p pd=7.3u as=3.9294p ps=7.84u w=6.66u l=0.6u
X201 Clamp_P_M1_wiring_0.dabp DCNDiode_0.guard DCNDiode_0.guard DCNDiode_0.guard sg13_hv_pmos ad=3.9294p pd=7.84u as=2.1312p ps=7.3u w=6.66u l=0.6u
X202 Clamp_N_M1_1.iovss Clamp_N_M1_wiring_0.b pad Clamp_N_M1_1.iovss sg13_hv_nmos ad=1.408p pd=5.04u as=2.596p ps=5.58u w=4.4u l=1u
X203 d2s_block_0.d2s_inputs_c2_0.x d2s_block_0.vref d2s_block_0.d2s_inputs_c2_0.sb_A d2s_block_0.d2s_inputs_c2_0.sb_A sg13_hv_pmos ad=1.9p pd=10.38u as=3.4p ps=20.68u w=10u l=1u
X204 DCNDiode_0.guard d2s_cma_0.a pad DCNDiode_0.guard sg13_hv_pmos ad=2.1312p pd=7.3u as=3.9294p ps=7.84u w=6.66u l=0.6u
X205 DCNDiode_0.guard d2s_cma_0.a pad DCNDiode_0.guard sg13_hv_pmos ad=2.1312p pd=7.3u as=3.9294p ps=7.84u w=6.66u l=0.6u
X206 d2s_block_0.d2s_inputs_c2_0.sb_C2 pad d2s_block_0.d2s_inputs_c2_0.x d2s_block_0.d2s_inputs_c2_0.sb_C2 sg13_hv_pmos ad=3.4p pd=20.68u as=1.9p ps=10.38u w=10u l=1u
X207 pad Clamp_N_M1_wiring_0.b Clamp_N_M1_1.iovss Clamp_N_M1_1.iovss sg13_hv_nmos ad=2.596p pd=5.58u as=1.408p ps=5.04u w=4.4u l=1u
X208 Clamp_N_M1_1.iovss pad dantenna l=1.26u w=67.6u
X209 Clamp_N_M1_1.iovss d2s_block_0.d2s_sp2k_f2_0.core dantenna l=3.1u w=0.64u
X210 pad d2s_cma_0.a DCNDiode_0.guard DCNDiode_0.guard sg13_hv_pmos ad=3.9294p pd=7.84u as=2.1312p ps=7.3u w=6.66u l=0.6u
X211 pad Clamp_N_M1_wiring_0.b Clamp_N_M1_1.iovss Clamp_N_M1_1.iovss sg13_hv_nmos ad=2.596p pd=5.58u as=1.408p ps=5.04u w=4.4u l=1u
X212 Clamp_N_M1_1.iovss d2s_block_0.d2s_tgsw_f2_0.ni d2s_block_0.d2s_ab_p_f2_0.vabp Clamp_N_M1_1.iovss sg13_hv_nmos ad=2.04p pd=12.68u as=2.04p ps=12.68u w=6u l=6u
X213 a_10870_32196# a_10190_29580# Clamp_N_M1_1.iovss rhigh l=12.65u w=0.5u
X214 d2s_block_0.bias_tree_p_f2_0.vbnc d2s_block_0.bias_tree_p_f2_0.vbnc d2s_block_0.bias_tree_p_f2_0.vbnc Clamp_N_M1_1.iovss sg13_hv_nmos ad=0.68p pd=4.68u as=0 ps=0 w=2u l=3u
X215 Clamp_N_M1_wiring_0.dabn d2s_block_0.bias_tree_p_f2_0.vabn d2s_block_0.bias_tree_p_f2_0.vabn Clamp_N_M1_1.iovss sg13_hv_nmos ad=1.496p pd=9.48u as=1.496p ps=9.48u w=4.4u l=1u
X216 DCNDiode_0.guard d2s_cma_0.a pad DCNDiode_0.guard sg13_hv_pmos ad=2.1312p pd=7.3u as=3.9294p ps=7.84u w=6.66u l=0.6u
X217 a_9510_32196# a_10462_29580# Clamp_N_M1_1.iovss rhigh l=12.65u w=0.5u
X218 Clamp_N_M1_1.iovss Clamp_N_M1_wiring_0.b pad Clamp_N_M1_1.iovss sg13_hv_nmos ad=1.408p pd=5.04u as=2.596p ps=5.58u w=4.4u l=1u
X219 pad d2s_cma_0.a DCNDiode_0.guard DCNDiode_0.guard sg13_hv_pmos ad=3.9294p pd=7.84u as=2.1312p ps=7.3u w=6.66u l=0.6u
X220 a_9918_32196# a_10054_29580# Clamp_N_M1_1.iovss rhigh l=12.65u w=0.5u
X221 d2s_block_0.bias_tree_p_f2_0.vbn d2s_block_0.bias_tree_p_f2_0.vbn d2s_block_0.bias_tree_p_f2_0.vbn Clamp_N_M1_1.iovss sg13_hv_nmos ad=0.68p pd=4.68u as=0 ps=0 w=2u l=6u
X222 DCNDiode_0.guard d2s_block_0.d2s_loads_c2_0.l2 DCNDiode_0.guard DCNDiode_0.guard sg13_hv_pmos ad=0.34p pd=2.68u as=0 ps=0 w=1u l=4u
X223 Clamp_N_M1_1.iovss Clamp_N_M1_wiring_0.b pad Clamp_N_M1_1.iovss sg13_hv_nmos ad=1.408p pd=5.04u as=2.596p ps=5.58u w=4.4u l=1u
X224 pad d2s_cma_0.a DCNDiode_0.guard DCNDiode_0.guard sg13_hv_pmos ad=3.9294p pd=7.84u as=2.1312p ps=7.3u w=6.66u l=0.6u
X225 pad Clamp_N_M1_wiring_0.b Clamp_N_M1_1.iovss Clamp_N_M1_1.iovss sg13_hv_nmos ad=3.256p pd=10.28u as=1.408p ps=5.04u w=4.4u l=1u
X226 pad Clamp_N_M1_wiring_0.b Clamp_N_M1_1.iovss Clamp_N_M1_1.iovss sg13_hv_nmos ad=2.596p pd=5.58u as=1.408p ps=5.04u w=4.4u l=1u
X227 pad d2s_cma_0.a DCNDiode_0.guard DCNDiode_0.guard sg13_hv_pmos ad=3.9294p pd=7.84u as=2.1312p ps=7.3u w=6.66u l=0.6u
X228 d2s_block_0.d2s_inputs_c2_0.x d2s_block_0.bias_tree_p_f2_0.vbn Clamp_N_M1_1.iovss Clamp_N_M1_1.iovss sg13_hv_nmos ad=2.04p pd=12.68u as=2.04p ps=12.68u w=6u l=6u
X229 DCNDiode_0.guard d2s_block_0.d2s_tails_c2_0.vbp d2s_block_0.d2s_inputs_c2_0.sb_C1 DCNDiode_0.guard sg13_hv_pmos ad=1.7p pd=10.68u as=1.7p ps=10.68u w=5u l=6u
X230 DCNDiode_0.guard DCNDiode_0.guard DCNDiode_0.guard DCNDiode_0.guard sg13_hv_pmos ad=1.9p pd=10.38u as=0 ps=0 w=10u l=1u
X231 d2s_block_0.d2s_inputs_c2_0.y d2s_block_0.bias_tree_p_f2_0.vbn Clamp_N_M1_1.iovss Clamp_N_M1_1.iovss sg13_hv_nmos ad=2.04p pd=12.68u as=2.04p ps=12.68u w=6u l=6u
X232 pad d2s_cma_0.a DCNDiode_0.guard DCNDiode_0.guard sg13_hv_pmos ad=3.9294p pd=7.84u as=2.1312p ps=7.3u w=6.66u l=0.6u
X233 pad d2s_cma_0.a DCNDiode_0.guard DCNDiode_0.guard sg13_hv_pmos ad=3.9294p pd=7.84u as=2.1312p ps=7.3u w=6.66u l=0.6u
X234 DCNDiode_0.guard DCNDiode_0.guard DCNDiode_0.guard DCNDiode_0.guard sg13_hv_pmos ad=2.2644p pd=14u as=0 ps=0 w=6.66u l=0.6u
X235 DCNDiode_0.guard d2s_cma_0.a pad DCNDiode_0.guard sg13_hv_pmos ad=2.1312p pd=7.3u as=3.9294p ps=7.84u w=6.66u l=0.6u
X236 DCNDiode_0.guard d2s_block_0.d2s_tails_c2_0.vbp d2s_block_0.d2s_tails_c2_0.vbp DCNDiode_0.guard sg13_hv_pmos ad=1.7p pd=10.68u as=1.7p ps=10.68u w=5u l=6u
X237 a_9782_32196# d2s_block_0.d2s_inputs_c2_0.sa_C1 Clamp_N_M1_1.iovss rhigh l=12.65u w=0.5u
X238 pad d2s_cma_0.a DCNDiode_0.guard DCNDiode_0.guard sg13_hv_pmos ad=3.9294p pd=7.84u as=2.1312p ps=7.3u w=6.66u l=0.6u
X239 Clamp_P_M1_wiring_0.dabp DCNDiode_0.guard DCNDiode_0.guard DCNDiode_0.guard sg13_hv_pmos ad=3.9294p pd=7.84u as=2.1312p ps=7.3u w=6.66u l=0.6u
X240 Clamp_N_M1_1.iovss Clamp_N_M1_1.iovss Clamp_N_M1_1.iovss rhigh l=12.65u w=0.5u
X241 DCNDiode_0.guard DCNDiode_0.guard DCNDiode_0.guard DCNDiode_0.guard sg13_hv_pmos ad=3.4p pd=20.68u as=0 ps=0 w=10u l=1u
X242 DCNDiode_0.guard d2s_cma_0.a pad DCNDiode_0.guard sg13_hv_pmos ad=2.1312p pd=7.3u as=3.9294p ps=7.84u w=6.66u l=0.6u
X243 DCNDiode_0.guard d2s_cma_0.a pad DCNDiode_0.guard sg13_hv_pmos ad=2.1312p pd=7.3u as=3.9294p ps=7.84u w=6.66u l=0.6u
X244 DCNDiode_0.guard d2s_cma_0.a pad DCNDiode_0.guard sg13_hv_pmos ad=2.1312p pd=7.3u as=3.9294p ps=7.84u w=6.66u l=0.6u
X245 d2s_block_0.bias_tree_p_f2_0.vbnc d2s_block_0.bias_tree_p_f2_0.vbnc d2s_block_0.bias_tree_p_f2_0.vbnc Clamp_N_M1_1.iovss sg13_hv_nmos ad=0.68p pd=4.68u as=0 ps=0 w=2u l=3u
X246 Clamp_N_M1_1.iovss d2s_block_0.bias_tree_p_f2_0.vbn d2s_block_0.d2s_inputs_c2_0.y Clamp_N_M1_1.iovss sg13_hv_nmos ad=2.04p pd=12.68u as=2.04p ps=12.68u w=6u l=6u
X247 pad d2s_cma_0.a DCNDiode_0.guard DCNDiode_0.guard sg13_hv_pmos ad=3.9294p pd=7.84u as=2.1312p ps=7.3u w=6.66u l=0.6u
X248 pad Clamp_N_M1_wiring_0.b Clamp_N_M1_1.iovss Clamp_N_M1_1.iovss sg13_hv_nmos ad=2.596p pd=5.58u as=1.408p ps=5.04u w=4.4u l=1u
X249 pad Clamp_N_M1_wiring_0.b Clamp_N_M1_1.iovss Clamp_N_M1_1.iovss sg13_hv_nmos ad=2.596p pd=5.58u as=1.408p ps=5.04u w=4.4u l=1u
X250 DCNDiode_0.guard d2s_cma_0.a pad DCNDiode_0.guard sg13_hv_pmos ad=2.1312p pd=7.3u as=3.9294p ps=7.84u w=6.66u l=0.6u
X251 pad Clamp_N_M1_wiring_0.b Clamp_N_M1_1.iovss Clamp_N_M1_1.iovss sg13_hv_nmos ad=2.596p pd=5.58u as=1.408p ps=5.04u w=4.4u l=1u
X252 Clamp_N_M1_1.iovss Clamp_N_M1_1.iovss Clamp_N_M1_1.iovss rhigh l=12.65u w=0.5u
X253 d2s_cma_0.a d2s_block_0.d2s_casc_p_c2_0.vbpc d2s_block_0.d2s_loads_c2_0.pr DCNDiode_0.guard sg13_hv_pmos ad=5.1p pd=30.68u as=5.1p ps=30.68u w=15u l=3u
X254 pad d2s_cma_0.a DCNDiode_0.guard DCNDiode_0.guard sg13_hv_pmos ad=3.9294p pd=7.84u as=2.1312p ps=7.3u w=6.66u l=0.6u
X255 a_10870_32196# d2s_block_0.d2s_inputs_c2_0.sb_C1 Clamp_N_M1_1.iovss rhigh l=12.65u w=0.5u
X256 pad d2s_cma_0.a DCNDiode_0.guard DCNDiode_0.guard sg13_hv_pmos ad=3.9294p pd=7.84u as=2.1312p ps=7.3u w=6.66u l=0.6u
X257 DCNDiode_0.guard d2s_cma_0.a pad DCNDiode_0.guard sg13_hv_pmos ad=2.1312p pd=7.3u as=3.9294p ps=7.84u w=6.66u l=0.6u
X258 d2s_block_0.d2s_inputs_c2_0.x pad d2s_block_0.d2s_inputs_c2_0.sb_C1 d2s_block_0.d2s_inputs_c2_0.sb_C1 sg13_hv_pmos ad=1.9p pd=10.38u as=3.4p ps=20.68u w=10u l=1u
X259 d2s_block_0.d2s_inputs_c2_0.sa_C1 d2s_block_0.vref d2s_block_0.d2s_inputs_c2_0.y d2s_block_0.d2s_inputs_c2_0.sa_C1 sg13_hv_pmos ad=3.4p pd=20.68u as=1.9p ps=10.38u w=10u l=1u
X260 Clamp_N_M1_1.iovss Clamp_N_M1_wiring_0.b pad Clamp_N_M1_1.iovss sg13_hv_nmos ad=1.408p pd=5.04u as=2.596p ps=5.58u w=4.4u l=1u
X261 Clamp_N_M1_1.iovss Clamp_N_M1_wiring_0.b pad Clamp_N_M1_1.iovss sg13_hv_nmos ad=1.408p pd=5.04u as=2.596p ps=5.58u w=4.4u l=1u
X262 Clamp_N_M1_1.iovss Clamp_N_M1_wiring_0.b pad Clamp_N_M1_1.iovss sg13_hv_nmos ad=1.408p pd=5.04u as=2.596p ps=5.58u w=4.4u l=1u
X263 a_9782_32196# a_10190_29580# Clamp_N_M1_1.iovss rhigh l=12.65u w=0.5u
X264 pad d2s_cma_0.a DCNDiode_0.guard DCNDiode_0.guard sg13_hv_pmos ad=3.9294p pd=7.84u as=2.1312p ps=7.3u w=6.66u l=0.6u
X265 pad Clamp_N_M1_wiring_0.b Clamp_N_M1_1.iovss Clamp_N_M1_1.iovss sg13_hv_nmos ad=2.596p pd=5.58u as=1.408p ps=5.04u w=4.4u l=1u
X266 d2s_block_0.d2s_ab_p_f2_0.vabp d2s_block_0.en_3v3 DCNDiode_0.guard DCNDiode_0.guard sg13_hv_pmos ad=0.34p pd=2.68u as=0.34p ps=2.68u w=1u l=0.45u
X267 pad d2s_cma_0.a DCNDiode_0.guard DCNDiode_0.guard sg13_hv_pmos ad=3.9294p pd=7.84u as=2.1312p ps=7.3u w=6.66u l=0.6u
X268 pad Clamp_N_M1_wiring_0.b Clamp_N_M1_1.iovss Clamp_N_M1_1.iovss sg13_hv_nmos ad=2.596p pd=5.58u as=1.408p ps=5.04u w=4.4u l=1u
X269 pad d2s_cma_0.a DCNDiode_0.guard DCNDiode_0.guard sg13_hv_pmos ad=3.9294p pd=7.84u as=2.1312p ps=7.3u w=6.66u l=0.6u
X270 DCNDiode_0.guard d2s_block_0.d2s_tails_c2_0.vbp d2s_block_0.d2s_inputs_c2_0.sa_A DCNDiode_0.guard sg13_hv_pmos ad=1.7p pd=10.68u as=1.7p ps=10.68u w=5u l=6u
X271 Clamp_N_M1_wiring_0.b d2s_block_0.d2s_ab_p_f2_0.vabp d2s_cma_0.a DCNDiode_0.guard sg13_hv_pmos ad=2.2644p pd=14u as=2.2644p ps=14u w=6.66u l=0.6u
X272 pad d2s_cma_0.a DCNDiode_0.guard DCNDiode_0.guard sg13_hv_pmos ad=3.9294p pd=7.84u as=2.1312p ps=7.3u w=6.66u l=0.6u
X273 Clamp_N_M1_1.iovss Clamp_N_M1_wiring_0.b pad Clamp_N_M1_1.iovss sg13_hv_nmos ad=1.408p pd=5.04u as=2.596p ps=5.58u w=4.4u l=1u
X274 DCNDiode_0.guard d2s_cma_0.a pad DCNDiode_0.guard sg13_hv_pmos ad=2.1312p pd=7.3u as=3.9294p ps=7.84u w=6.66u l=0.6u
X275 Clamp_N_M1_1.iovss Clamp_N_M1_wiring_0.b pad Clamp_N_M1_1.iovss sg13_hv_nmos ad=1.408p pd=5.04u as=2.596p ps=5.58u w=4.4u l=1u
X276 Clamp_N_M1_1.iovss Clamp_N_M1_wiring_0.dabn Clamp_N_M1_wiring_0.dabn Clamp_N_M1_1.iovss sg13_hv_nmos ad=1.408p pd=5.04u as=2.596p ps=5.58u w=4.4u l=1u
X277 pad Clamp_N_M1_wiring_0.b Clamp_N_M1_1.iovss Clamp_N_M1_1.iovss sg13_hv_nmos ad=2.596p pd=5.58u as=2.068p ps=9.74u w=4.4u l=1u
X278 DCNDiode_0.guard DCNDiode_0.guard DCNDiode_0.guard DCNDiode_0.guard sg13_hv_pmos ad=1.9p pd=10.38u as=0 ps=0 w=10u l=1u
X279 DCNDiode_0.guard d2s_cma_0.a pad DCNDiode_0.guard sg13_hv_pmos ad=2.1312p pd=7.3u as=3.9294p ps=7.84u w=6.66u l=0.6u
X280 pad Clamp_N_M1_wiring_0.b Clamp_N_M1_1.iovss Clamp_N_M1_1.iovss sg13_hv_nmos ad=2.596p pd=5.58u as=1.408p ps=5.04u w=4.4u l=1u
X281 pad Clamp_N_M1_wiring_0.b Clamp_N_M1_1.iovss Clamp_N_M1_1.iovss sg13_hv_nmos ad=2.596p pd=5.58u as=1.408p ps=5.04u w=4.4u l=1u
X282 pad d2s_cma_0.a DCNDiode_0.guard DCNDiode_0.guard sg13_hv_pmos ad=4.9284p pd=14.8u as=2.1312p ps=7.3u w=6.66u l=0.6u
X283 DCNDiode_0.guard d2s_cma_0.a pad DCNDiode_0.guard sg13_hv_pmos ad=2.1312p pd=7.3u as=3.9294p ps=7.84u w=6.66u l=0.6u
X284 d2s_block_0.d2s_inputs_c2_0.x d2s_block_0.bias_tree_p_f2_0.vbn Clamp_N_M1_1.iovss Clamp_N_M1_1.iovss sg13_hv_nmos ad=2.04p pd=12.68u as=2.04p ps=12.68u w=6u l=6u
X285 pad d2s_cma_0.a DCNDiode_0.guard DCNDiode_0.guard sg13_hv_pmos ad=3.9294p pd=7.84u as=2.1312p ps=7.3u w=6.66u l=0.6u
X286 Clamp_N_M1_1.iovss Clamp_N_M1_wiring_0.b pad Clamp_N_M1_1.iovss sg13_hv_nmos ad=1.408p pd=5.04u as=2.596p ps=5.58u w=4.4u l=1u
X287 DCNDiode_0.guard d2s_cma_0.a pad DCNDiode_0.guard sg13_hv_pmos ad=2.1312p pd=7.3u as=3.9294p ps=7.84u w=6.66u l=0.6u
X288 Clamp_N_M1_1.iovss Clamp_N_M1_wiring_0.b pad Clamp_N_M1_1.iovss sg13_hv_nmos ad=1.408p pd=5.04u as=2.596p ps=5.58u w=4.4u l=1u
X289 DCNDiode_0.guard DCNDiode_0.guard DCNDiode_0.guard DCNDiode_0.guard sg13_hv_pmos ad=3.4p pd=20.68u as=0 ps=0 w=10u l=1u
X290 Clamp_N_M1_1.iovss Clamp_N_M1_1.iovss Clamp_N_M1_1.iovss Clamp_N_M1_1.iovss sg13_hv_nmos ad=1.496p pd=9.48u as=0 ps=0 w=4.4u l=1u
X291 DCNDiode_0.guard d2s_cma_0.a pad DCNDiode_0.guard sg13_hv_pmos ad=2.1312p pd=7.3u as=3.9294p ps=7.84u w=6.66u l=0.6u
X292 pad Clamp_N_M1_wiring_0.b Clamp_N_M1_1.iovss Clamp_N_M1_1.iovss sg13_hv_nmos ad=2.596p pd=5.58u as=1.408p ps=5.04u w=4.4u l=1u
C0 d2s_block_0.vinn d2s_block_0.d2s_inputs_c2_0.y 0.07839f
C1 d2s_block_0.d2s_inputs_c2_0.sa_A d2s_block_0.d2s_inputs_c2_0.sb_B 3.34743f
C2 a_11006_29666# d2s_block_0.d2s_inputs_c2_0.sb_C1 0.02689f
C3 d2s_block_0.d2s_loads_c2_0.pr d2s_block_0.d2s_inputs_c2_0.y 0.06645f
C4 d2s_block_0.d2s_tails_c2_0.vbp d2s_block_0.d2s_inputs_c2_0.sa_C1 0.27516f
C5 d2s_block_0.d2s_inputs_c2_0.sb_C2 d2s_block_0.d2s_inputs_c2_0.sa_C1 0.09016f
C6 a_10190_29666# d2s_block_0.d2s_inputs_c2_0.sb_C1 0.02562f
C7 a_10598_29666# d2s_block_0.d2s_inputs_c2_0.sb_C2 0.02096f
C8 a_812_18030# d2s_block_0.d2s_sp2k_f2_1.core 0.16662f
C9 a_9918_29666# d2s_block_0.d2s_inputs_c2_0.sa_C2 0.11376f
C10 a_9510_29666# d2s_block_0.d2s_inputs_c2_0.sa_C1 0.07367f
C11 a_10734_32196# TopLayersTo4_0.vdd 0.24464f
C12 a_10734_29666# d2s_block_0.d2s_inputs_c2_0.sb_B 0.04331f
C13 TopLayersTo4_0.vdd a_11414_29666# 0.01326f
C14 d2s_block_0.bias_tree_p_f2_0.vbn d2s_block_0.d2s_tails_c2_0.vbp 0.27681f
C15 a_9374_29666# d2s_block_0.d2s_inputs_c2_0.sa_C1 0.05763f
C16 d2s_block_0.vinn d2s_block_0.d2s_inputs_c2_0.sa_C1 0.11198f
C17 d2s_block_0.d2s_inputs_c2_0.sb_C1 d2s_block_0.bias_tree_p_f2_0.vbnc 0.05487f
C18 TopLayersTo4_0.vdd a_11278_29666# 0.01326f
C19 d2s_block_0.bias_tree_p_f2_0.vabn d2s_block_0.d2s_tails_c2_0.vbp 0.29088f
C20 a_9646_32196# a_9782_32196# 0.55763f
C21 d2s_block_0.d2s_loads_c2_0.pr d2s_block_0.d2s_inputs_c2_0.sa_C1 0.02505f
C22 a_10326_29666# d2s_block_0.d2s_inputs_c2_0.sb_C2 0.02092f
C23 d2s_block_0.d2s_casc_p_c2_0.vbpc d2s_block_0.bias_tree_p_f2_0.vbnc 0.39211f
C24 d2s_block_0.d2s_tails_c2_0.vbp DCNDiode_0.guard 52.5035f
C25 d2s_block_0.d2s_inputs_c2_0.sb_C2 DCNDiode_0.guard 0.23279f
C26 d2s_block_0.d2s_casc_p_c2_0.vbpc d2s_block_0.en_3v3_b 0.01576f
C27 pad d2s_block_0.d2s_inputs_c2_0.sb_C2 2.70034f
C28 d2s_block_0.d2s_loads_c2_0.l2 d2s_block_0.d2s_loads_c2_0.pl 2.28979f
C29 d2s_block_0.vinp d2s_block_0.d2s_inputs_c2_0.y 0.71522f
C30 a_9918_32196# a_9782_32196# 0.33426f
C31 d2s_block_0.d2s_ab_p_f2_0.l1 d2s_block_0.en_3v3 0.03629f
C32 a_11550_29666# d2s_block_0.bias_tree_p_f2_0.vabn 0.07188f
C33 d2s_block_0.vinn DCNDiode_0.guard 1.13707f
C34 d2s_block_0.d2s_loads_c2_0.l2 d2s_block_0.d2s_ab_p_f2_0.l1 0.56925f
C35 pad d2s_block_0.vinn 0.18905f
C36 a_11006_32196# a_10870_32196# 0.33426f
C37 d2s_block_0.vref d2s_block_0.d2s_tails_c2_0.vbp 0.41746f
C38 d2s_block_0.d2s_loads_c2_0.pr DCNDiode_0.guard 15.2407f
C39 d2s_block_0.d2s_inputs_c2_0.x d2s_block_0.d2s_inputs_c2_0.sb_B 0.88986f
C40 d2s_block_0.d2s_tails_c2_0.vbp d2s_block_0.d2s_inputs_c2_0.sa_B 0.44672f
C41 d2s_block_0.d2s_inputs_c2_0.sb_C2 d2s_block_0.d2s_inputs_c2_0.sa_B 0.0974f
C42 a_11278_29666# d2s_block_0.d2s_inputs_c2_0.sb_C1 0.04835f
C43 a_10462_29666# d2s_block_0.d2s_inputs_c2_0.sb_C2 0.02093f
C44 d2s_block_0.d2s_casc_p_c2_0.vbpc d2s_cma_0.a 6.12127f
C45 a_9510_29666# d2s_block_0.d2s_inputs_c2_0.sa_B 0.04789f
C46 d2s_block_0.d2s_inputs_c2_0.sa_C1 d2s_block_0.d2s_inputs_c2_0.y 1.24175f
C47 TopLayersTo4_0.vdd d2s_block_0.d2s_inputs_c2_0.sb_B 0.77713f
C48 d2s_block_0.d2s_ab_p_f2_0.l1 Clamp_N_M1_wiring_0.dabn 0.8559f
C49 d2s_block_0.vref d2s_block_0.vinn 5.84531f
C50 a_9374_29666# d2s_block_0.d2s_inputs_c2_0.sa_B 0.0463f
C51 TopLayersTo4_0.vdd a_9782_32196# 0.18987f
C52 a_10870_29666# d2s_block_0.bias_tree_p_f2_0.vabn 0.01435f
C53 d2s_block_0.vinn d2s_block_0.d2s_inputs_c2_0.sa_B 0.04693f
C54 d2s_block_0.d2s_inputs_c2_0.x d2s_block_0.en_3v3 0.17638f
C55 d2s_block_0.en_3v3 d2s_block_0.d2s_tgsw_f2_0.ni 0.61404f
C56 a_9782_29666# d2s_block_0.d2s_inputs_c2_0.sb_C2 0.0209f
C57 a_9918_29666# a_9918_32196# 0.02634f
C58 d2s_block_0.bias_tree_p_f2_0.vbn d2s_block_0.d2s_inputs_c2_0.y 9.16822f
C59 d2s_block_0.en_3v3_b d2s_block_0.bias_tree_p_f2_0.vbnc 0.06336f
C60 a_9510_32196# d2s_block_0.bias_tree_p_f2_0.vbnc 0.21011f
C61 d2s_block_0.d2s_inputs_c2_0.x d2s_block_0.d2s_loads_c2_0.l2 0.04055f
C62 d2s_block_0.bias_tree_p_f2_0.vabn d2s_block_0.d2s_inputs_c2_0.y 1.2778f
C63 d2s_block_0.vinp DCNDiode_0.guard 1.06556f
C64 TopLayersTo4_0.vdd d2s_block_0.en_3v3 1.73652f
C65 DCNDiode_0.guard d2s_block_0.d2s_inputs_c2_0.y 7.85214f
C66 a_10462_29580# a_10326_29580# 0.33426f
C67 d2s_block_0.vinp pad 4.87783f
C68 pad d2s_block_0.d2s_inputs_c2_0.y 0.08525f
C69 d2s_block_0.d2s_inputs_c2_0.sb_C1 d2s_block_0.d2s_inputs_c2_0.sb_B 1.47487f
C70 d2s_block_0.d2s_loads_c2_0.pr d2s_block_0.d2s_ab_p_f2_0.vabp 0.01103f
C71 a_10190_29580# a_10054_29580# 0.78325f
C72 d2s_block_0.bias_tree_p_f2_0.vbn d2s_block_0.d2s_inputs_c2_0.sa_C1 0.9803f
C73 d2s_block_0.d2s_casc_p_c2_0.vbpc d2s_block_0.d2s_inputs_c2_0.sb_B 0.02864f
C74 TopLayersTo4_0.vdd a_9918_29666# 0.01326f
C75 a_11142_29666# d2s_block_0.d2s_inputs_c2_0.sb_C2 0.02652f
C76 d2s_block_0.bias_tree_p_f2_0.vabn d2s_block_0.d2s_inputs_c2_0.sa_C1 0.86633f
C77 d2s_block_0.vref d2s_block_0.vinp 0.24444f
C78 d2s_block_0.vref d2s_block_0.d2s_inputs_c2_0.y 2.38694f
C79 DCNDiode_0.guard d2s_block_0.d2s_inputs_c2_0.sa_C1 0.89579f
C80 a_11006_32196# TopLayersTo4_0.vdd 0.11929f
C81 d2s_block_0.vinp d2s_block_0.d2s_inputs_c2_0.sa_B 0.14038f
C82 d2s_block_0.d2s_inputs_c2_0.sa_B d2s_block_0.d2s_inputs_c2_0.y 1.99841f
C83 d2s_block_0.d2s_sp2k_f2_0.core d2s_block_0.bias_tree_p_f2_0.vbn 0.0411f
C84 pad d2s_block_0.d2s_inputs_c2_0.sa_C1 0.1114f
C85 d2s_block_0.iref d2s_block_0.d2s_tails_c2_0.vbp 0.14242f
C86 d2s_block_0.d2s_tails_c2_0.vbp d2s_block_0.d2s_inputs_c2_0.sb_A 0.3079f
C87 d2s_block_0.d2s_inputs_c2_0.sb_A d2s_block_0.d2s_inputs_c2_0.sb_C2 0.02061f
C88 d2s_block_0.bias_tree_p_f2_0.vabn d2s_block_0.bias_tree_p_f2_0.vbn 0.36408f
C89 d2s_block_0.d2s_sp2k_f2_0.core DCNDiode_0.guard 6.32776f
C90 Clamp_N_M1_wiring_0.b d2s_block_0.d2s_inputs_c2_0.y 0.30126f
C91 d2s_block_0.bias_tree_p_f2_0.vbn DCNDiode_0.guard 5.1611f
C92 d2s_block_0.d2s_casc_p_c2_0.vbpc d2s_block_0.en_3v3 0.06905f
C93 d2s_block_0.d2s_sp2k_f2_0.core pad 7.04262f
C94 a_10734_32196# a_11414_29666# 0.02719f
C95 a_11006_29666# d2s_block_0.d2s_inputs_c2_0.sb_B 0.04376f
C96 d2s_block_0.bias_tree_p_f2_0.vabn DCNDiode_0.guard 2.84271f
C97 a_9374_29666# d2s_block_0.d2s_inputs_c2_0.sb_A 0.0128f
C98 d2s_block_0.d2s_loads_c2_0.l2 d2s_block_0.d2s_casc_p_c2_0.vbpc 2.03019f
C99 d2s_block_0.d2s_ab_p_f2_0.vabp d2s_block_0.d2s_inputs_c2_0.y 0.62468f
C100 d2s_block_0.vref d2s_block_0.d2s_inputs_c2_0.sa_C1 2.69676f
C101 d2s_block_0.d2s_tails_c2_0.vbp d2s_block_0.d2s_inputs_c2_0.sa_C2 0.27689f
C102 d2s_block_0.vinn d2s_block_0.d2s_inputs_c2_0.sb_A 0.10431f
C103 d2s_block_0.d2s_inputs_c2_0.sb_C2 d2s_block_0.d2s_inputs_c2_0.sa_C2 0.08696f
C104 a_11550_29666# d2s_block_0.d2s_inputs_c2_0.sb_A 0.02699f
C105 d2s_block_0.d2s_inputs_c2_0.sa_B d2s_block_0.d2s_inputs_c2_0.sa_C1 1.67372f
C106 a_9918_29666# d2s_block_0.d2s_inputs_c2_0.sb_C1 0.02559f
C107 a_10190_29666# d2s_block_0.d2s_inputs_c2_0.sb_B 0.04314f
C108 a_11414_29666# a_11278_29666# 0.63642f
C109 pad DCNDiode_0.guard 0.13637p
C110 a_10190_29666# a_9782_32196# 0.02728f
C111 a_10598_29666# a_10462_29666# 0.63642f
C112 a_9510_29666# d2s_block_0.d2s_inputs_c2_0.sa_C2 0.04592f
C113 a_9374_29666# d2s_block_0.d2s_inputs_c2_0.sa_C2 0.05012f
C114 d2s_block_0.vinn d2s_block_0.d2s_inputs_c2_0.sa_C2 0.1108f
C115 a_9646_29666# d2s_block_0.d2s_inputs_c2_0.sb_C2 0.0209f
C116 d2s_block_0.d2s_inputs_c2_0.sb_B d2s_block_0.bias_tree_p_f2_0.vbnc 0.03816f
C117 d2s_block_0.d2s_loads_c2_0.pr d2s_block_0.d2s_inputs_c2_0.sa_C2 0.03033f
C118 a_9782_29666# d2s_block_0.d2s_inputs_c2_0.sa_C1 0.12043f
C119 a_9510_29666# a_9646_29666# 0.63642f
C120 d2s_block_0.vref DCNDiode_0.guard 5.59778f
C121 d2s_block_0.d2s_sp2k_f2_0.core Clamp_N_M1_wiring_0.b 29.3545f
C122 a_10326_29666# a_10462_29666# 0.63642f
C123 d2s_block_0.d2s_tails_c2_0.vbp d2s_block_0.d2s_inputs_c2_0.sa_A 0.25372f
C124 DCNDiode_0.guard d2s_block_0.d2s_inputs_c2_0.sa_B 0.8697f
C125 d2s_block_0.d2s_inputs_c2_0.sa_A d2s_block_0.d2s_inputs_c2_0.sb_C2 1.14606f
C126 d2s_block_0.vref pad 0.28667f
C127 pad d2s_block_0.d2s_inputs_c2_0.sa_B 0.03495f
C128 a_9510_29666# d2s_block_0.d2s_inputs_c2_0.sa_A 0.03839f
C129 d2s_block_0.bias_tree_p_f2_0.vabn Clamp_N_M1_wiring_0.b 0.32223f
C130 d2s_block_0.d2s_ab_p_f2_0.vabp d2s_block_0.bias_tree_p_f2_0.vbn 1.11797f
C131 Clamp_N_M1_wiring_0.b DCNDiode_0.guard 25.88f
C132 d2s_block_0.en_3v3 d2s_block_0.bias_tree_p_f2_0.vbnc 0.27478f
C133 a_9374_29666# d2s_block_0.d2s_inputs_c2_0.sa_A 0.0292f
C134 d2s_block_0.en_3v3_b d2s_block_0.en_3v3 8.63296f
C135 d2s_block_0.d2s_inputs_c2_0.sb_A d2s_block_0.d2s_inputs_c2_0.y 0.69671f
C136 a_11006_32196# a_11006_29666# 0.02746f
C137 pad Clamp_N_M1_wiring_0.b 38.277f
C138 d2s_block_0.bias_tree_p_f2_0.vabn d2s_block_0.d2s_ab_p_f2_0.vabp 0.03145f
C139 a_10734_29666# d2s_block_0.d2s_inputs_c2_0.sb_C2 0.02102f
C140 a_11414_29666# d2s_block_0.d2s_inputs_c2_0.sb_B 0.07713f
C141 d2s_block_0.d2s_ab_p_f2_0.vabp DCNDiode_0.guard 4.69218f
C142 TopLayersTo4_0.vdd a_10598_32196# 0.29675f
C143 d2s_block_0.vref d2s_block_0.d2s_inputs_c2_0.sa_B 2.91863f
C144 Clamp_P_M1_wiring_0.dabp DCNDiode_0.guard 6.67031f
C145 a_11278_29666# d2s_block_0.d2s_inputs_c2_0.sb_B 0.05309f
C146 d2s_block_0.d2s_loads_c2_0.pr d2s_block_0.d2s_loads_c2_0.pl 10.0355f
C147 d2s_block_0.d2s_inputs_c2_0.sa_C2 d2s_block_0.d2s_inputs_c2_0.y 1.84957f
C148 a_10054_29666# d2s_block_0.d2s_inputs_c2_0.sa_C2 0.04588f
C149 a_10462_29580# d2s_block_0.d2s_inputs_c2_0.sb_C2 0.12162f
C150 d2s_block_0.iref d2s_block_0.d2s_inputs_c2_0.sa_C1 0.01252f
C151 d2s_block_0.en_3v3 d2s_cma_0.a 0.05461f
C152 d2s_block_0.d2s_inputs_c2_0.sb_A d2s_block_0.d2s_inputs_c2_0.sa_C1 3.00544f
C153 d2s_block_0.d2s_loads_c2_0.l2 d2s_cma_0.a 1.21313f
C154 a_11142_29666# d2s_block_0.bias_tree_p_f2_0.vabn 0.02664f
C155 a_10870_29666# a_10870_32196# 0.02728f
C156 d2s_block_0.iref d2s_block_0.bias_tree_p_f2_0.vbn 0.56722f
C157 d2s_block_0.d2s_inputs_c2_0.x d2s_block_0.d2s_inputs_c2_0.sb_C2 1.16026f
C158 d2s_block_0.d2s_tails_c2_0.vbp d2s_block_0.d2s_tgsw_f2_0.ni 0.74118f
C159 a_812_18030# DCNDiode_0.guard 0.16159f
C160 d2s_block_0.d2s_inputs_c2_0.sa_C2 d2s_block_0.d2s_inputs_c2_0.sa_C1 7.08342f
C161 d2s_block_0.vinp d2s_block_0.d2s_inputs_c2_0.sa_A 2.79506f
C162 d2s_block_0.d2s_ab_p_f2_0.vabp Clamp_N_M1_wiring_0.b 0.48786f
C163 d2s_block_0.d2s_inputs_c2_0.sa_A d2s_block_0.d2s_inputs_c2_0.y 0.92783f
C164 a_10598_29666# d2s_block_0.d2s_inputs_c2_0.sa_C2 0.01215f
C165 a_812_18030# pad 0.08365f
C166 a_10870_29666# a_10734_29666# 0.63642f
C167 d2s_block_0.bias_tree_p_f2_0.vabn d2s_block_0.d2s_inputs_c2_0.sb_A 0.93711f
C168 Clamp_P_M1_wiring_0.dabp Clamp_N_M1_wiring_0.b 0.07973f
C169 d2s_block_0.iref DCNDiode_0.guard 0.17627f
C170 a_10054_29580# d2s_block_0.d2s_inputs_c2_0.sb_C2 0.31811f
C171 d2s_block_0.d2s_inputs_c2_0.sb_A DCNDiode_0.guard 1.35344f
C172 Clamp_N_M1_wiring_0.dabn d2s_cma_0.a 0.65752f
C173 TopLayersTo4_0.vdd d2s_block_0.d2s_tails_c2_0.vbp 6.85536f
C174 TopLayersTo4_0.vdd d2s_block_0.d2s_inputs_c2_0.sb_C2 0.0838f
C175 d2s_block_0.d2s_inputs_c2_0.x d2s_block_0.vinn 0.73094f
C176 Clamp_P_M1_wiring_0.dabp d2s_block_0.d2s_ab_p_f2_0.vabp 0.37452f
C177 d2s_block_0.bias_tree_p_f2_0.vbn d2s_block_0.d2s_inputs_c2_0.sa_C2 1.24398f
C178 a_9646_29666# d2s_block_0.d2s_inputs_c2_0.sa_C1 0.08627f
C179 d2s_block_0.d2s_inputs_c2_0.x d2s_block_0.d2s_loads_c2_0.pr 0.29544f
C180 TopLayersTo4_0.vdd a_9510_29666# 0.01324f
C181 d2s_block_0.bias_tree_p_f2_0.vabn d2s_block_0.d2s_inputs_c2_0.sa_C2 0.05927f
C182 a_10326_29666# d2s_block_0.d2s_inputs_c2_0.sa_C2 0.02354f
C183 d2s_block_0.d2s_ab_p_f2_0.l1 d2s_block_0.d2s_inputs_c2_0.y 0.08525f
C184 DCNDiode_0.guard d2s_block_0.d2s_inputs_c2_0.sa_C2 0.81272f
C185 d2s_block_0.d2s_sp2k_f2_1.core d2s_cma_0.a 33.6393f
C186 TopLayersTo4_0.vdd a_9374_29666# 0.01009f
C187 TopLayersTo4_0.vdd d2s_block_0.vinn 1.10953f
C188 TopLayersTo4_0.vdd a_11550_29666# 0.01326f
C189 d2s_block_0.vref d2s_block_0.d2s_inputs_c2_0.sb_A 2.68862f
C190 d2s_block_0.d2s_inputs_c2_0.sb_A d2s_block_0.d2s_inputs_c2_0.sa_B 2.00823f
C191 d2s_block_0.d2s_tails_c2_0.vbp d2s_block_0.d2s_inputs_c2_0.sb_C1 0.23283f
C192 a_9918_32196# a_10054_29666# 0.02746f
C193 d2s_block_0.d2s_inputs_c2_0.sb_C1 d2s_block_0.d2s_inputs_c2_0.sb_C2 2.96153f
C194 a_10734_29666# a_10598_29666# 0.63642f
C195 d2s_block_0.vref d2s_block_0.d2s_inputs_c2_0.sa_C2 2.69046f
C196 d2s_block_0.d2s_inputs_c2_0.sa_B d2s_block_0.d2s_inputs_c2_0.sa_C2 0.1563f
C197 a_9510_29666# d2s_block_0.d2s_inputs_c2_0.sb_C1 0.02554f
C198 d2s_block_0.d2s_casc_p_c2_0.vbpc d2s_block_0.d2s_tails_c2_0.vbp 0.53763f
C199 a_10462_29666# d2s_block_0.d2s_inputs_c2_0.sa_C2 0.01669f
C200 d2s_block_0.d2s_inputs_c2_0.sa_A DCNDiode_0.guard 0.7643f
C201 a_9918_29666# d2s_block_0.d2s_inputs_c2_0.sb_B 0.04304f
C202 d2s_block_0.d2s_casc_p_c2_0.vbpc d2s_block_0.d2s_inputs_c2_0.sb_C2 0.02864f
C203 a_10870_29666# TopLayersTo4_0.vdd 0.01326f
C204 pad d2s_block_0.d2s_inputs_c2_0.sa_A 0.01838f
C205 d2s_block_0.d2s_inputs_c2_0.x d2s_block_0.vinp 0.21699f
C206 d2s_block_0.d2s_inputs_c2_0.x d2s_block_0.d2s_inputs_c2_0.y 14.9543f
C207 a_9510_32196# a_10598_32196# 0.21179f
C208 a_9374_29666# d2s_block_0.d2s_inputs_c2_0.sb_C1 0.02846f
C209 d2s_block_0.d2s_loads_c2_0.pl DCNDiode_0.guard 18.3468f
C210 d2s_block_0.d2s_loads_c2_0.l2 d2s_block_0.en_3v3 0.35277f
C211 a_10734_29666# d2s_block_0.bias_tree_p_f2_0.vabn 0.01103f
C212 a_9646_29666# d2s_block_0.d2s_inputs_c2_0.sa_B 0.0538f
C213 d2s_block_0.d2s_ab_p_f2_0.l1 d2s_block_0.bias_tree_p_f2_0.vabn 0.56759f
C214 d2s_block_0.d2s_casc_p_c2_0.vbpc d2s_block_0.vinn 0.01581f
C215 TopLayersTo4_0.vdd d2s_block_0.vinp 1.38278f
C216 TopLayersTo4_0.vdd d2s_block_0.d2s_inputs_c2_0.y 0.14981f
C217 TopLayersTo4_0.vdd a_10054_29666# 0.01326f
C218 d2s_block_0.d2s_ab_p_f2_0.l1 DCNDiode_0.guard 2.75637f
C219 a_9782_29666# d2s_block_0.d2s_inputs_c2_0.sa_C2 0.06949f
C220 d2s_block_0.d2s_loads_c2_0.pr d2s_block_0.d2s_casc_p_c2_0.vbpc 2.95522f
C221 a_10326_29666# a_9646_32196# 0.02719f
C222 d2s_block_0.vref d2s_block_0.d2s_inputs_c2_0.sa_A 0.15231f
C223 d2s_block_0.d2s_inputs_c2_0.sa_A d2s_block_0.d2s_inputs_c2_0.sa_B 1.53969f
C224 a_10734_32196# a_10598_32196# 0.78325f
C225 a_11006_29666# d2s_block_0.d2s_inputs_c2_0.sb_C2 0.02172f
C226 d2s_block_0.d2s_inputs_c2_0.x d2s_block_0.d2s_inputs_c2_0.sa_C1 0.21017f
C227 a_10190_29666# d2s_block_0.d2s_inputs_c2_0.sb_C2 0.02091f
C228 a_10870_29666# d2s_block_0.d2s_inputs_c2_0.sb_C1 0.02617f
C229 a_9782_29666# a_9646_29666# 0.63642f
C230 d2s_block_0.d2s_loads_c2_0.l2 Clamp_N_M1_wiring_0.dabn 0.07862f
C231 a_11686_29666# d2s_block_0.en_3v3 0.02805f
C232 TopLayersTo4_0.vdd d2s_block_0.d2s_inputs_c2_0.sa_C1 1.01092f
C233 d2s_block_0.d2s_inputs_c2_0.x d2s_block_0.bias_tree_p_f2_0.vbn 9.06373f
C234 TopLayersTo4_0.vdd a_10598_29666# 0.01326f
C235 d2s_block_0.d2s_tails_c2_0.vbp d2s_block_0.bias_tree_p_f2_0.vbnc 0.26597f
C236 d2s_block_0.bias_tree_p_f2_0.vbn d2s_block_0.d2s_tgsw_f2_0.ni 0.01716f
C237 d2s_block_0.d2s_loads_c2_0.pl Clamp_N_M1_wiring_0.b 0.1393f
C238 d2s_block_0.bias_tree_p_f2_0.vbnc d2s_block_0.d2s_inputs_c2_0.sb_C2 0.04184f
C239 d2s_block_0.vinp d2s_block_0.d2s_inputs_c2_0.sb_C1 0.10978f
C240 d2s_block_0.d2s_inputs_c2_0.sb_C1 d2s_block_0.d2s_inputs_c2_0.y 0.3288f
C241 d2s_block_0.en_3v3_b d2s_block_0.d2s_tails_c2_0.vbp 0.04303f
C242 a_10190_29580# a_10326_29580# 0.55763f
C243 d2s_block_0.d2s_inputs_c2_0.x d2s_block_0.bias_tree_p_f2_0.vabn 0.59568f
C244 a_10054_29666# d2s_block_0.d2s_inputs_c2_0.sb_C1 0.02561f
C245 d2s_block_0.d2s_inputs_c2_0.x DCNDiode_0.guard 9.44335f
C246 a_9510_29666# d2s_block_0.bias_tree_p_f2_0.vbnc 0.05962f
C247 d2s_block_0.d2s_tgsw_f2_0.ni DCNDiode_0.guard 0.16612f
C248 d2s_block_0.d2s_ab_p_f2_0.l1 Clamp_N_M1_wiring_0.b 1.58264f
C249 d2s_block_0.vinp d2s_block_0.d2s_casc_p_c2_0.vbpc 0.01581f
C250 TopLayersTo4_0.vdd d2s_block_0.bias_tree_p_f2_0.vbn 1.95274f
C251 d2s_block_0.d2s_casc_p_c2_0.vbpc d2s_block_0.d2s_inputs_c2_0.y 0.35504f
C252 a_9510_29666# a_9510_32196# 0.02514f
C253 d2s_block_0.d2s_inputs_c2_0.x pad 1.52067f
C254 a_9374_29666# d2s_block_0.bias_tree_p_f2_0.vbnc 0.10381f
C255 d2s_block_0.iref d2s_block_0.d2s_inputs_c2_0.sa_C2 0.0852f
C256 d2s_block_0.d2s_inputs_c2_0.sb_A d2s_block_0.d2s_inputs_c2_0.sa_C2 0.44573f
C257 TopLayersTo4_0.vdd d2s_block_0.bias_tree_p_f2_0.vabn 1.17406f
C258 TopLayersTo4_0.vdd a_10326_29666# 0.01326f
C259 d2s_block_0.d2s_ab_p_f2_0.l1 d2s_block_0.d2s_ab_p_f2_0.vabp 0.69917f
C260 TopLayersTo4_0.vdd DCNDiode_0.guard 3.87859f
C261 Clamp_P_M1_wiring_0.dabp d2s_block_0.d2s_ab_p_f2_0.l1 0.09453f
C262 a_10870_29666# a_11006_29666# 0.63642f
C263 TopLayersTo4_0.vdd pad 0.0791f
C264 d2s_block_0.d2s_sp2k_f2_1.core Clamp_N_M1_wiring_0.dabn 0.08675f
C265 d2s_block_0.d2s_inputs_c2_0.sb_C1 d2s_block_0.d2s_inputs_c2_0.sa_C1 0.01883f
C266 d2s_block_0.vref d2s_block_0.d2s_inputs_c2_0.x 0.70768f
C267 a_10598_29666# d2s_block_0.d2s_inputs_c2_0.sb_C1 0.02576f
C268 d2s_block_0.d2s_inputs_c2_0.x d2s_block_0.d2s_inputs_c2_0.sa_B 0.62706f
C269 d2s_block_0.d2s_casc_p_c2_0.vbpc d2s_block_0.d2s_inputs_c2_0.sa_C1 0.04832f
C270 d2s_block_0.d2s_inputs_c2_0.sa_A d2s_block_0.d2s_inputs_c2_0.sb_A 0.0301f
C271 d2s_block_0.vref TopLayersTo4_0.vdd 1.49159f
C272 d2s_block_0.d2s_inputs_c2_0.x Clamp_N_M1_wiring_0.b 0.25852f
C273 TopLayersTo4_0.vdd d2s_block_0.d2s_inputs_c2_0.sa_B 0.09547f
C274 a_11414_29666# a_11550_29666# 0.63642f
C275 a_10190_29666# a_10054_29666# 0.63642f
C276 TopLayersTo4_0.vdd a_10462_29666# 0.01326f
C277 d2s_block_0.d2s_loads_c2_0.pr d2s_cma_0.a 0.29884f
C278 a_9646_29666# d2s_block_0.d2s_inputs_c2_0.sa_C2 0.04605f
C279 a_10326_29666# d2s_block_0.d2s_inputs_c2_0.sb_C1 0.02565f
C280 d2s_block_0.d2s_casc_p_c2_0.vbpc d2s_block_0.bias_tree_p_f2_0.vbn 0.03128f
C281 d2s_block_0.d2s_inputs_c2_0.sb_C1 DCNDiode_0.guard 0.31213f
C282 d2s_block_0.d2s_inputs_c2_0.x d2s_block_0.d2s_ab_p_f2_0.vabp 0.16626f
C283 d2s_block_0.d2s_ab_p_f2_0.vabp d2s_block_0.d2s_tgsw_f2_0.ni 0.55657f
C284 pad d2s_block_0.d2s_inputs_c2_0.sb_C1 2.68838f
C285 d2s_block_0.d2s_casc_p_c2_0.vbpc d2s_block_0.bias_tree_p_f2_0.vabn 0.03067f
C286 TopLayersTo4_0.vdd Clamp_N_M1_wiring_0.b 0.01417f
C287 d2s_block_0.bias_tree_p_f2_0.vbnc d2s_block_0.d2s_inputs_c2_0.y 2.6787f
C288 d2s_block_0.d2s_casc_p_c2_0.vbpc DCNDiode_0.guard 28.8714f
C289 d2s_block_0.en_3v3_b d2s_block_0.d2s_inputs_c2_0.y 1.29065f
C290 pad d2s_block_0.d2s_casc_p_c2_0.vbpc 0.0203f
C291 TopLayersTo4_0.vdd d2s_block_0.d2s_ab_p_f2_0.vabp 1.03501f
C292 TopLayersTo4_0.vdd a_9782_29666# 0.01326f
C293 d2s_block_0.vref d2s_block_0.d2s_inputs_c2_0.sb_C1 0.01473f
C294 d2s_block_0.d2s_tails_c2_0.vbp d2s_block_0.d2s_inputs_c2_0.sb_B 0.39285f
C295 d2s_block_0.d2s_inputs_c2_0.sb_C1 d2s_block_0.d2s_inputs_c2_0.sa_B 0.29986f
C296 d2s_block_0.d2s_inputs_c2_0.sb_B d2s_block_0.d2s_inputs_c2_0.sb_C2 0.57959f
C297 a_10462_29666# d2s_block_0.d2s_inputs_c2_0.sb_C1 0.02569f
C298 d2s_block_0.vref d2s_block_0.d2s_casc_p_c2_0.vbpc 0.01701f
C299 d2s_block_0.bias_tree_p_f2_0.vbnc d2s_block_0.d2s_inputs_c2_0.sa_C1 1.11584f
C300 a_11006_29666# d2s_block_0.bias_tree_p_f2_0.vabn 0.01922f
C301 a_9510_29666# d2s_block_0.d2s_inputs_c2_0.sb_B 0.02749f
C302 d2s_block_0.d2s_casc_p_c2_0.vbpc d2s_block_0.d2s_inputs_c2_0.sa_B 0.05519f
C303 a_9374_29666# d2s_block_0.d2s_inputs_c2_0.sb_B 0.0292f
C304 a_10326_29666# a_10190_29666# 0.63642f
C305 d2s_block_0.vinn d2s_block_0.d2s_inputs_c2_0.sb_B 4.63917f
C306 a_11550_29666# d2s_block_0.d2s_inputs_c2_0.sb_B 0.01861f
C307 d2s_block_0.d2s_tails_c2_0.vbp d2s_block_0.en_3v3 0.2049f
C308 a_9782_29666# d2s_block_0.d2s_inputs_c2_0.sb_C1 0.02558f
C309 d2s_block_0.iref d2s_block_0.d2s_tgsw_f2_0.ni 0.10634f
C310 d2s_block_0.d2s_inputs_c2_0.x d2s_block_0.d2s_inputs_c2_0.sb_A 0.97788f
C311 d2s_block_0.bias_tree_p_f2_0.vbn d2s_block_0.bias_tree_p_f2_0.vbnc 0.20964f
C312 TopLayersTo4_0.vdd a_11142_29666# 0.01326f
C313 a_9646_32196# a_9646_29666# 0.02519f
C314 d2s_block_0.en_3v3_b d2s_block_0.bias_tree_p_f2_0.vbn 0.15339f
C315 d2s_block_0.bias_tree_p_f2_0.vabn d2s_block_0.bias_tree_p_f2_0.vbnc 0.35232f
C316 d2s_block_0.en_3v3_b d2s_block_0.bias_tree_p_f2_0.vabn 0.35174f
C317 d2s_block_0.bias_tree_p_f2_0.vbnc DCNDiode_0.guard 3.30292f
C318 TopLayersTo4_0.vdd d2s_block_0.iref 0.97468f
C319 TopLayersTo4_0.vdd d2s_block_0.d2s_inputs_c2_0.sb_A 0.80516f
C320 d2s_block_0.en_3v3_b DCNDiode_0.guard 1.46452f
C321 a_10190_29580# d2s_block_0.d2s_inputs_c2_0.sb_C2 0.12128f
C322 d2s_block_0.d2s_inputs_c2_0.x d2s_block_0.d2s_inputs_c2_0.sa_C2 0.28003f
C323 a_9918_29666# d2s_block_0.d2s_inputs_c2_0.sb_C2 0.0209f
C324 a_10870_29666# d2s_block_0.d2s_inputs_c2_0.sb_B 0.04345f
C325 d2s_block_0.d2s_sp2k_f2_0.core d2s_cma_0.a 0.29723f
C326 a_10054_29580# d2s_block_0.d2s_inputs_c2_0.sa_C2 0.19848f
C327 d2s_block_0.d2s_loads_c2_0.l2 d2s_block_0.d2s_loads_c2_0.pr 5.91836f
C328 TopLayersTo4_0.vdd d2s_block_0.d2s_inputs_c2_0.sa_C2 1.26576f
C329 a_11142_29666# d2s_block_0.d2s_inputs_c2_0.sb_C1 0.03293f
C330 d2s_block_0.bias_tree_p_f2_0.vabn d2s_cma_0.a 0.21121f
C331 a_10326_29580# d2s_block_0.d2s_inputs_c2_0.sb_C2 0.12303f
C332 d2s_block_0.bias_tree_p_f2_0.vbnc d2s_block_0.d2s_inputs_c2_0.sa_B 0.29163f
C333 a_11414_29666# d2s_block_0.bias_tree_p_f2_0.vabn 0.0523f
C334 d2s_block_0.vinp d2s_block_0.d2s_inputs_c2_0.sb_B 0.09952f
C335 DCNDiode_0.guard d2s_cma_0.a 0.12278p
C336 d2s_block_0.d2s_inputs_c2_0.sb_B d2s_block_0.d2s_inputs_c2_0.y 0.52521f
C337 a_10054_29666# d2s_block_0.d2s_inputs_c2_0.sb_B 0.04313f
C338 a_11278_29666# d2s_block_0.bias_tree_p_f2_0.vabn 0.0373f
C339 a_10462_29666# a_9510_32196# 0.02713f
C340 pad d2s_cma_0.a 48.1271f
C341 d2s_block_0.d2s_inputs_c2_0.x d2s_block_0.d2s_inputs_c2_0.sa_A 0.41947f
C342 d2s_block_0.d2s_inputs_c2_0.sb_C1 d2s_block_0.d2s_inputs_c2_0.sb_A 0.1631f
C343 TopLayersTo4_0.vdd a_9646_29666# 0.01326f
C344 Clamp_N_M1_wiring_0.b d2s_block_0.bias_tree_p_f2_0.vbnc 6.87883f
C345 d2s_block_0.en_3v3_b Clamp_N_M1_wiring_0.b 0.44392f
C346 d2s_block_0.d2s_casc_p_c2_0.vbpc d2s_block_0.iref 0.25785f
C347 d2s_block_0.d2s_casc_p_c2_0.vbpc d2s_block_0.d2s_inputs_c2_0.sb_A 2.21293f
C348 a_9782_29666# d2s_block_0.bias_tree_p_f2_0.vbnc 0.01214f
C349 TopLayersTo4_0.vdd d2s_block_0.d2s_inputs_c2_0.sa_A 0.08381f
C350 a_11686_29666# a_11550_29666# 0.63642f
C351 d2s_block_0.en_3v3_b d2s_block_0.d2s_ab_p_f2_0.vabp 1.09664f
C352 d2s_block_0.en_3v3 d2s_block_0.d2s_inputs_c2_0.y 0.02575f
C353 d2s_block_0.d2s_inputs_c2_0.sb_C1 d2s_block_0.d2s_inputs_c2_0.sa_C2 0.05219f
C354 d2s_block_0.d2s_inputs_c2_0.sb_B d2s_block_0.d2s_inputs_c2_0.sa_C1 0.16445f
C355 d2s_block_0.d2s_inputs_c2_0.x d2s_block_0.d2s_ab_p_f2_0.l1 0.35416f
C356 TopLayersTo4_0.vdd a_10870_32196# 0.18862f
C357 a_10598_29666# d2s_block_0.d2s_inputs_c2_0.sb_B 0.04323f
C358 a_11006_29666# a_11142_29666# 0.63642f
C359 d2s_block_0.d2s_casc_p_c2_0.vbpc d2s_block_0.d2s_inputs_c2_0.sa_C2 2.5437f
C360 a_10734_29666# TopLayersTo4_0.vdd 0.01326f
C361 Clamp_N_M1_wiring_0.b d2s_cma_0.a 5.93786f
C362 TopLayersTo4_0.vdd d2s_block_0.d2s_ab_p_f2_0.l1 0.01417f
C363 a_9646_29666# d2s_block_0.d2s_inputs_c2_0.sb_C1 0.02555f
C364 a_9918_29666# a_10054_29666# 0.63642f
C365 TopLayersTo4_0.vdd a_9646_32196# 0.24583f
C366 d2s_block_0.bias_tree_p_f2_0.vabn d2s_block_0.d2s_inputs_c2_0.sb_B 0.01173f
C367 d2s_block_0.d2s_ab_p_f2_0.vabp d2s_cma_0.a 0.31599f
C368 a_10326_29666# d2s_block_0.d2s_inputs_c2_0.sb_B 0.04316f
C369 d2s_block_0.d2s_inputs_c2_0.sb_B DCNDiode_0.guard 2.31968f
C370 Clamp_P_M1_wiring_0.dabp d2s_cma_0.a 0.77652f
C371 d2s_block_0.d2s_inputs_c2_0.sb_C1 d2s_block_0.d2s_inputs_c2_0.sa_A 0.06509f
C372 pad d2s_block_0.d2s_inputs_c2_0.sb_B 0.6063f
C373 TopLayersTo4_0.vdd a_9918_32196# 0.12054f
C374 d2s_block_0.d2s_casc_p_c2_0.vbpc d2s_block_0.d2s_inputs_c2_0.sa_A 0.02582f
C375 d2s_block_0.iref d2s_block_0.bias_tree_p_f2_0.vbnc 0.12819f
C376 d2s_block_0.bias_tree_p_f2_0.vbn d2s_block_0.en_3v3 0.03788f
C377 d2s_block_0.bias_tree_p_f2_0.vbnc d2s_block_0.d2s_inputs_c2_0.sb_A 0.15539f
C378 d2s_block_0.en_3v3_b d2s_block_0.iref 2.27275f
C379 a_10190_29666# d2s_block_0.d2s_inputs_c2_0.sa_C2 0.03348f
C380 a_10734_29666# d2s_block_0.d2s_inputs_c2_0.sb_C1 0.02589f
C381 d2s_block_0.bias_tree_p_f2_0.vabn d2s_block_0.en_3v3 7.29654f
C382 d2s_block_0.d2s_loads_c2_0.pl d2s_block_0.d2s_casc_p_c2_0.vbpc 3.07095f
C383 d2s_block_0.vref d2s_block_0.d2s_inputs_c2_0.sb_B 2.98966f
C384 d2s_block_0.en_3v3 DCNDiode_0.guard 2.0011f
C385 TopLayersTo4_0.vdd d2s_block_0.d2s_inputs_c2_0.x 0.11766f
C386 d2s_block_0.d2s_inputs_c2_0.sb_B d2s_block_0.d2s_inputs_c2_0.sa_B 0.17725f
C387 d2s_block_0.d2s_loads_c2_0.l2 d2s_block_0.bias_tree_p_f2_0.vabn 0.24918f
C388 TopLayersTo4_0.vdd d2s_block_0.d2s_tgsw_f2_0.ni 5.18499f
C389 a_10462_29666# d2s_block_0.d2s_inputs_c2_0.sb_B 0.04319f
C390 a_11550_29666# a_10598_32196# 0.02713f
C391 d2s_block_0.d2s_loads_c2_0.l2 DCNDiode_0.guard 47.2756f
C392 d2s_block_0.bias_tree_p_f2_0.vbnc d2s_block_0.d2s_inputs_c2_0.sa_C2 0.39817f
C393 d2s_block_0.en_3v3_b d2s_block_0.d2s_inputs_c2_0.sa_C2 0.0705f
C394 a_11278_29666# a_11142_29666# 0.63642f
C395 d2s_block_0.bias_tree_p_f2_0.vabn Clamp_N_M1_wiring_0.dabn 0.2642f
C396 a_9646_29666# d2s_block_0.bias_tree_p_f2_0.vbnc 0.04482f
C397 a_9782_29666# d2s_block_0.d2s_inputs_c2_0.sb_B 0.04292f
C398 a_9782_29666# a_9782_32196# 0.02438f
C399 DCNDiode_0.guard Clamp_N_M1_wiring_0.dabn 5.84298f
C400 pad Clamp_N_M1_wiring_0.dabn 2.20295f
C401 d2s_block_0.d2s_inputs_c2_0.x d2s_block_0.d2s_inputs_c2_0.sb_C1 1.16358f
C402 d2s_block_0.d2s_tails_c2_0.vbp d2s_block_0.d2s_inputs_c2_0.sb_C2 0.23417f
C403 d2s_block_0.d2s_inputs_c2_0.sa_A d2s_block_0.bias_tree_p_f2_0.vbnc 0.46192f
C404 a_11686_29666# d2s_block_0.bias_tree_p_f2_0.vabn 0.12626f
C405 Clamp_N_M1_wiring_0.b d2s_block_0.en_3v3 0.04914f
C406 d2s_block_0.d2s_inputs_c2_0.x d2s_block_0.d2s_casc_p_c2_0.vbpc 0.35066f
C407 a_9510_29666# d2s_block_0.d2s_inputs_c2_0.sb_C2 0.02089f
C408 d2s_block_0.d2s_casc_p_c2_0.vbpc d2s_block_0.d2s_tgsw_f2_0.ni 0.24074f
C409 d2s_block_0.d2s_sp2k_f2_1.core DCNDiode_0.guard 4.49638f
C410 d2s_block_0.d2s_loads_c2_0.l2 Clamp_N_M1_wiring_0.b 0.46037f
C411 TopLayersTo4_0.vdd d2s_block_0.d2s_inputs_c2_0.sb_C1 0.08379f
C412 d2s_block_0.d2s_ab_p_f2_0.vabp d2s_block_0.en_3v3 0.25697f
C413 pad d2s_block_0.d2s_sp2k_f2_1.core 6.30962f
C414 a_9374_29666# d2s_block_0.d2s_inputs_c2_0.sb_C2 0.02455f
C415 d2s_block_0.d2s_loads_c2_0.l2 d2s_block_0.d2s_ab_p_f2_0.vabp 0.60794f
C416 d2s_block_0.d2s_ab_p_f2_0.l1 d2s_block_0.bias_tree_p_f2_0.vbnc 6.86969f
C417 a_11142_29666# d2s_block_0.d2s_inputs_c2_0.sb_B 0.04459f
C418 TopLayersTo4_0.vdd d2s_block_0.d2s_casc_p_c2_0.vbpc 0.74307f
C419 a_15058_18030# d2s_block_0.d2s_sp2k_f2_0.core 0.1618f
C420 a_9510_29666# a_9374_29666# 0.63642f
C421 Clamp_N_M1_wiring_0.b Clamp_N_M1_wiring_0.dabn 0.565f
C422 a_9646_32196# a_9510_32196# 0.78325f
C423 a_10734_32196# a_10870_32196# 0.55763f
C424 a_9918_29666# a_9782_29666# 0.63642f
C425 d2s_block_0.d2s_inputs_c2_0.sb_B d2s_block_0.d2s_inputs_c2_0.sb_A 0.23114f
C426 a_15058_18030# DCNDiode_0.guard 0.16084f
C427 d2s_block_0.d2s_loads_c2_0.pl d2s_cma_0.a 0.88462f
C428 a_10598_29666# a_10598_32196# 0.02713f
C429 a_15058_18030# pad 0.0581f
C430 a_10870_32196# a_11278_29666# 0.02728f
C431 a_10734_32196# a_10734_29666# 0.02719f
C432 Clamp_P_M1_wiring_0.dabp Clamp_N_M1_wiring_0.dabn 1.20516f
C433 a_10870_29666# d2s_block_0.d2s_inputs_c2_0.sb_C2 0.02119f
C434 Clamp_N_M1_wiring_0.b d2s_block_0.d2s_sp2k_f2_1.core 0.11039f
C435 d2s_block_0.d2s_ab_p_f2_0.l1 d2s_cma_0.a 0.81303f
C436 TopLayersTo4_0.vdd a_11006_29666# 0.01326f
C437 d2s_block_0.d2s_inputs_c2_0.sb_B d2s_block_0.d2s_inputs_c2_0.sa_C2 0.03789f
C438 d2s_block_0.d2s_casc_p_c2_0.vbpc d2s_block_0.d2s_inputs_c2_0.sb_C1 0.03244f
C439 d2s_block_0.d2s_inputs_c2_0.x d2s_block_0.bias_tree_p_f2_0.vbnc 3.02377f
C440 TopLayersTo4_0.vdd a_10190_29666# 0.01326f
C441 d2s_block_0.iref d2s_block_0.en_3v3 0.11463f
C442 d2s_block_0.d2s_inputs_c2_0.x d2s_block_0.en_3v3_b 0.03622f
C443 d2s_block_0.bias_tree_p_f2_0.vabn a_10598_32196# 0.14858f
C444 d2s_block_0.d2s_tails_c2_0.vbp d2s_block_0.d2s_inputs_c2_0.y 0.09483f
C445 d2s_block_0.vinp d2s_block_0.d2s_inputs_c2_0.sb_C2 0.11199f
C446 d2s_block_0.en_3v3_b d2s_block_0.d2s_tgsw_f2_0.ni 0.15546f
C447 d2s_block_0.d2s_inputs_c2_0.sb_C2 d2s_block_0.d2s_inputs_c2_0.y 0.21505f
C448 a_10054_29666# d2s_block_0.d2s_inputs_c2_0.sb_C2 0.0209f
C449 a_9646_29666# d2s_block_0.d2s_inputs_c2_0.sb_B 0.03847f
C450 a_11006_32196# a_11142_29666# 0.02746f
C451 TopLayersTo4_0.vdd d2s_block_0.bias_tree_p_f2_0.vbnc 1.23326f
C452 TopLayersTo4_0.vdd d2s_block_0.en_3v3_b 1.59368f
C453 TopLayersTo4_0.vdd a_9510_32196# 0.29163f
C454 d2s_block_0.vinp d2s_block_0.vinn 2.28356f
C455 d2s_block_0.d2s_loads_c2_0.pl Clamp_N_M1_1.iovss 1.52941f
C456 d2s_block_0.d2s_loads_c2_0.pr Clamp_N_M1_1.iovss 5.30357f
C457 d2s_block_0.d2s_ab_p_f2_0.l1 Clamp_N_M1_1.iovss 9.29697f
C458 d2s_block_0.d2s_inputs_c2_0.x Clamp_N_M1_1.iovss 18.91412f
C459 d2s_block_0.d2s_inputs_c2_0.y Clamp_N_M1_1.iovss 23.16874f
C460 a_11006_32196# Clamp_N_M1_1.iovss 1.05017f
C461 a_10870_32196# Clamp_N_M1_1.iovss 1.11157f
C462 a_10734_32196# Clamp_N_M1_1.iovss 1.1635f
C463 a_10598_32196# Clamp_N_M1_1.iovss 1.87881f
C464 a_10462_29580# Clamp_N_M1_1.iovss 1.15542f
C465 a_10326_29580# Clamp_N_M1_1.iovss 1.28099f
C466 a_10190_29580# Clamp_N_M1_1.iovss 1.38369f
C467 a_10054_29580# Clamp_N_M1_1.iovss 2.0911f
C468 a_9918_32196# Clamp_N_M1_1.iovss 1.04138f
C469 a_9782_32196# Clamp_N_M1_1.iovss 1.08734f
C470 a_9646_32196# Clamp_N_M1_1.iovss 1.15443f
C471 a_9510_32196# Clamp_N_M1_1.iovss 1.86057f
C472 d2s_block_0.iref Clamp_N_M1_1.iovss 5.2928f
C473 d2s_block_0.d2s_inputs_c2_0.sb_A Clamp_N_M1_1.iovss 11.3569f
C474 d2s_block_0.d2s_inputs_c2_0.sa_C2 Clamp_N_M1_1.iovss 8.98262f
C475 d2s_block_0.d2s_inputs_c2_0.sa_C1 Clamp_N_M1_1.iovss 5.45802f
C476 d2s_block_0.d2s_inputs_c2_0.sb_B Clamp_N_M1_1.iovss 8.91756f
C477 d2s_block_0.d2s_inputs_c2_0.sa_B Clamp_N_M1_1.iovss 7.41418f
C478 d2s_block_0.d2s_inputs_c2_0.sb_C1 Clamp_N_M1_1.iovss 4.20856f
C479 d2s_block_0.d2s_inputs_c2_0.sb_C2 Clamp_N_M1_1.iovss 4.87602f
C480 d2s_block_0.d2s_inputs_c2_0.sa_A Clamp_N_M1_1.iovss 6.30954f
C481 TopLayersTo4_0.vdd Clamp_N_M1_1.iovss 0.20725p ; **FLOATING
.ends
