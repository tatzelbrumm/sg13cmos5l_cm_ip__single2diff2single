* Extracted by KLayout with SG13CMOS5L LVS runset on : 03/11/2026 12:49

.SUBCKT d2s_ab_n_f2 a b dabn l1 l2 vabn vss
M$1 vss vss vss vss sg13_hv_nmos L=1u W=8.8u AS=2.992p AD=2.992p PS=18.96u
+ PD=18.96u rfmode=0
M$2 l2 vabn l1 vss sg13_hv_nmos L=1u W=4.4u AS=1.496p AD=1.496p PS=9.48u
+ PD=9.48u rfmode=0
M$3 vabn vabn dabn vss sg13_hv_nmos L=1u W=4.4u AS=1.496p AD=1.496p PS=9.48u
+ PD=9.48u rfmode=0
M$4 a vabn b vss sg13_hv_nmos L=1u W=4.4u AS=1.496p AD=1.496p PS=9.48u PD=9.48u
+ rfmode=0
.ENDS d2s_ab_n_f2
