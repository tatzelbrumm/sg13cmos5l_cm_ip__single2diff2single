* Extracted by KLayout with SG13CMOS5L LVS runset on : 31/10/2026 19:18

.SUBCKT bias_tree_n_c2 en_3v3 en_3v3_b iref ni vabp vbp vbpc vss
M$1 vss ni vbpc vss sg13_hv_nmos L=6u W=2.4u AS=0.816p AD=0.816p PS=5.48u
+ PD=5.48u rfmode=0
M$2 vss ni vbp vss sg13_hv_nmos L=6u W=6u AS=2.04p AD=2.04p PS=12.68u PD=12.68u
+ rfmode=0
M$3 vss ni ni vss sg13_hv_nmos L=6u W=6u AS=2.04p AD=2.04p PS=12.68u PD=12.68u
+ rfmode=0
M$4 vss ni vabp vss sg13_hv_nmos L=6u W=6u AS=2.04p AD=2.04p PS=12.68u
+ PD=12.68u rfmode=0
M$5 ni ni ni vss sg13_hv_nmos L=6u W=2.4u AS=0.816p AD=0.816p PS=5.48u PD=5.48u
+ rfmode=0
M$6 ni en_3v3 iref vss sg13_hv_nmos L=0.45u W=1u AS=0.34p AD=0.34p PS=2.68u
+ PD=2.68u rfmode=0
M$7 vss en_3v3_b ni vss sg13_hv_nmos L=0.45u W=1u AS=0.34p AD=0.34p PS=2.68u
+ PD=2.68u rfmode=0
.ENDS bias_tree_n_c2
