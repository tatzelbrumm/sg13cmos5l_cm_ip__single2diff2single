* K deck 17: THD at the linear-swing amplitude, 1 kOhm || 100 pF; setup and measurement of the CACE template
* sg13cmos5l_IOPadDiff2Single_tb_thd.sch (harmonics 2-7, 6 periods, first 2 skipped), vd amplitude 1.3 V (pad 1.0 ... 2.3 V);
* the frequency is the run parameter 1e6 (10e3 / 100e3 / 1e6 Hz).
.lib cornerMOShv.lib mos_tt
.lib cornerRES.lib res_typ
.lib cornerCAP.lib cap_typ
.lib cornerPNP.lib typ
.lib cornerDIO.lib dio_tt
.include /home/user/c2/K/out/decks/dut_variants.spice
.include /home/user/c2/K/work/variant.inc
.include /home/user/c2/K/work/nodeset.inc
Vdd vdd 0 3.3
Vs0 s0 0 0
Vs1 s1 0 0
Vext vext 0 3.3
Iext xg 0 5e-06
XKEd xg xg vext vext sg13_hv_pmos w=5u l=6u
XKEm ibias xg vext vext sg13_hv_pmos w=5u l=6u
Vref vref 0 1.65
Vic vic 0 1.65
Ep vinp vic dp 0 0.5
En vinn vic dp 0 -0.5
RL vout vterm 1000
Vterm vterm 0 1.65
CL vout 0 1e-10

Vd dp 0 sin(0 1.3 1e6)
x1 vdd 0 vdd 0 vinp vinn vref vout vout ibias vdd s0 s1 0 fix_sel
.temp 27
* no klu: KLU + the mosvar OSDI (S-Varicap) aborts with 'doAnalyses: out of memory'; rshunt 10 GOhm on every node
* and source stepping are needed for a valid op with S-Varicaps (else Transient op into a latched state, pad 3.28 V)
.options method=gear reltol=1e-4 abstol=1e-12 gmin=1e-12
.option warn=1 rshunt=1e10 itl1=500 gminsteps=50

.control
save v(vout)
let fin = 1e6
let tstep = 4/(1024*fin)
let tstop = 6/fin
let tstart = 2/fin
tran $&tstep $&tstop $&tstart
linearize v(vout)
let vv = v(vout)[0,1023]
let ph = 2*pi*1e6*(time[0,1023] - time[0])
let h1 = 2*sqrt(mean(vv*cos(ph))^2 + mean(vv*sin(ph))^2)
let hs = 0
let k = 2
while k <= 7
  let hk = 2*sqrt(mean(vv*cos(k*ph))^2 + mean(vv*sin(k*ph))^2)
  let hs = hs + hk^2
  let k = k + 1
end
let THD = 20*log10(sqrt(hs)/h1)
let amp = h1
let vmin = vecmin(vv)
let vmax = vecmax(vv)
echo v9 1e6 $&THD $&amp $&vmin $&vmax >> /home/user/c2/K/out/logs/thd17.dat
.endc
.end
