.SUBCKT oa_pmir_c c2 c8 co vdd vpg
Moa_pmir_c_r1_dummyn_0 vdd vpg vdd nw sg13_hv_pmos w=0.3u l=8u ng=1 m=1
Moa_pmir_c_r1_PO_1 co vpg vdd nw sg13_hv_pmos w=2u l=8u ng=1 m=1
Moa_pmir_c_r1_PO_2 co vpg vdd nw sg13_hv_pmos w=2u l=8u ng=1 m=1
Moa_pmir_c_r1_PO_3 co vpg vdd nw sg13_hv_pmos w=2u l=8u ng=1 m=1
Moa_pmir_c_r1_P8_4 c8 vpg vdd nw sg13_hv_pmos w=2u l=8u ng=1 m=1
Moa_pmir_c_r1_PO_5 co vpg vdd nw sg13_hv_pmos w=2u l=8u ng=1 m=1
Moa_pmir_c_r1_PO_6 co vpg vdd nw sg13_hv_pmos w=2u l=8u ng=1 m=1
Moa_pmir_c_r1_P8_7 c8 vpg vdd nw sg13_hv_pmos w=2u l=8u ng=1 m=1
Moa_pmir_c_r1_PO_8 co vpg vdd nw sg13_hv_pmos w=2u l=8u ng=1 m=1
Moa_pmir_c_r1_dummyn_9 vdd vpg vdd nw sg13_hv_pmos w=0.3u l=8u ng=1 m=1
Moa_pmir_c_r2_dummyn_0 vdd vpg vdd nw sg13_hv_pmos w=0.3u l=8u ng=1 m=1
Moa_pmir_c_r2_PO_1 co vpg vdd nw sg13_hv_pmos w=2u l=8u ng=1 m=1
Moa_pmir_c_r2_P8_2 c8 vpg vdd nw sg13_hv_pmos w=2u l=8u ng=1 m=1
Moa_pmir_c_r2_PO_3 co vpg vdd nw sg13_hv_pmos w=2u l=8u ng=1 m=1
Moa_pmir_c_r2_P0_4 vpg vpg vdd nw sg13_hv_pmos w=2u l=8u ng=1 m=1
Moa_pmir_c_r2_P2_5 c2 vpg vdd nw sg13_hv_pmos w=2u l=8u ng=1 m=1
Moa_pmir_c_r2_P8_6 c8 vpg vdd nw sg13_hv_pmos w=2u l=8u ng=1 m=1
Moa_pmir_c_r2_PO_7 co vpg vdd nw sg13_hv_pmos w=2u l=8u ng=1 m=1
Moa_pmir_c_r2_PO_8 co vpg vdd nw sg13_hv_pmos w=2u l=8u ng=1 m=1
Moa_pmir_c_r2_dummyn_9 vdd vpg vdd nw sg13_hv_pmos w=0.3u l=8u ng=1 m=1
Moa_pmir_c_r3_dummyn_0 vdd vpg vdd nw sg13_hv_pmos w=0.3u l=8u ng=1 m=1
Moa_pmir_c_r3_PO_1 co vpg vdd nw sg13_hv_pmos w=2u l=8u ng=1 m=1
Moa_pmir_c_r3_PO_2 co vpg vdd nw sg13_hv_pmos w=2u l=8u ng=1 m=1
Moa_pmir_c_r3_P8_3 c8 vpg vdd nw sg13_hv_pmos w=2u l=8u ng=1 m=1
Moa_pmir_c_r3_P2_4 c2 vpg vdd nw sg13_hv_pmos w=2u l=8u ng=1 m=1
Moa_pmir_c_r3_dummy_5 vdd vpg vdd nw sg13_hv_pmos w=2u l=8u ng=1 m=1
Moa_pmir_c_r3_PO_6 co vpg vdd nw sg13_hv_pmos w=2u l=8u ng=1 m=1
Moa_pmir_c_r3_P8_7 c8 vpg vdd nw sg13_hv_pmos w=2u l=8u ng=1 m=1
Moa_pmir_c_r3_PO_8 co vpg vdd nw sg13_hv_pmos w=2u l=8u ng=1 m=1
Moa_pmir_c_r3_dummyn_9 vdd vpg vdd nw sg13_hv_pmos w=0.3u l=8u ng=1 m=1
Moa_pmir_c_r4_dummyn_0 vdd vpg vdd nw sg13_hv_pmos w=0.3u l=8u ng=1 m=1
Moa_pmir_c_r4_PO_1 co vpg vdd nw sg13_hv_pmos w=2u l=8u ng=1 m=1
Moa_pmir_c_r4_P8_2 c8 vpg vdd nw sg13_hv_pmos w=2u l=8u ng=1 m=1
Moa_pmir_c_r4_PO_3 co vpg vdd nw sg13_hv_pmos w=2u l=8u ng=1 m=1
Moa_pmir_c_r4_PO_4 co vpg vdd nw sg13_hv_pmos w=2u l=8u ng=1 m=1
Moa_pmir_c_r4_P8_5 c8 vpg vdd nw sg13_hv_pmos w=2u l=8u ng=1 m=1
Moa_pmir_c_r4_PO_6 co vpg vdd nw sg13_hv_pmos w=2u l=8u ng=1 m=1
Moa_pmir_c_r4_PO_7 co vpg vdd nw sg13_hv_pmos w=2u l=8u ng=1 m=1
Moa_pmir_c_r4_PO_8 co vpg vdd nw sg13_hv_pmos w=2u l=8u ng=1 m=1
Moa_pmir_c_r4_dummyn_9 vdd vpg vdd nw sg13_hv_pmos w=0.3u l=8u ng=1 m=1
.ENDS oa_pmir_c

.SUBCKT oa_ms1 en_3v3_b ks vdd
Moa_ms1_MS1_0 ms1 en_3v3_b vdd nw sg13_hv_pmos w=0.5u l=12.5u ng=1 m=1
Moa_ms1_MS1_1 ms2 en_3v3_b ms1 nw sg13_hv_pmos w=0.5u l=12.5u ng=1 m=1
Moa_ms1_MS1_2 ms3 en_3v3_b ms2 nw sg13_hv_pmos w=0.5u l=12.5u ng=1 m=1
Moa_ms1_MS1_3 ms4 en_3v3_b ms3 nw sg13_hv_pmos w=0.5u l=12.5u ng=1 m=1
Moa_ms1_MS1_4 ms5 en_3v3_b ms4 nw sg13_hv_pmos w=0.5u l=12.5u ng=1 m=1
Moa_ms1_MS1_5 ms6 en_3v3_b ms5 nw sg13_hv_pmos w=0.5u l=12.5u ng=1 m=1
Moa_ms1_MS1_6 ms7 en_3v3_b ms6 nw sg13_hv_pmos w=0.5u l=12.5u ng=1 m=1
Moa_ms1_MS1_7 ks en_3v3_b ms7 nw sg13_hv_pmos w=0.5u l=12.5u ng=1 m=1
.ENDS oa_ms1

.SUBCKT oa_svpg en_3v3 vdd vpg
Moa_svpg_SVPG vpg en_3v3 vdd nw sg13_hv_pmos w=1u l=0.45u ng=1 m=1
.ENDS oa_svpg

.SUBCKT bg_pmir_pcas_c ca co g iout vdd vpc vpg
Mbg_pmir_pcas_c_r1_dummyn_0 vdd vpg vdd nw sg13_hv_pmos w=0.3u l=1u ng=1 m=1
Mbg_pmir_pcas_c_r1_PO_1 co vpg vdd nw sg13_hv_pmos w=10u l=1u ng=1 m=1
Mbg_pmir_pcas_c_r1_PB_2 vpg vpg vdd nw sg13_hv_pmos w=10u l=1u ng=1 m=1
Mbg_pmir_pcas_c_r1_PA_3 ca vpg vdd nw sg13_hv_pmos w=10u l=1u ng=1 m=1
Mbg_pmir_pcas_c_r1_PO_4 co vpg vdd nw sg13_hv_pmos w=10u l=1u ng=1 m=1
Mbg_pmir_pcas_c_r1_dummyn_5 vdd vpg vdd nw sg13_hv_pmos w=0.3u l=1u ng=1 m=1
Mbg_pmir_pcas_c_r2_dummyn_0 vdd vpc vdd nw sg13_hv_pmos w=0.3u l=1u ng=1 m=1
Mbg_pmir_pcas_c_r2_POC_1 iout vpc co nw sg13_hv_pmos w=10u l=1u ng=1 m=1
Mbg_pmir_pcas_c_r2_PBC_2 vpc vpc vpg nw sg13_hv_pmos w=10u l=1u ng=1 m=1
Mbg_pmir_pcas_c_r2_PAC_3 g vpc ca nw sg13_hv_pmos w=10u l=1u ng=1 m=1
Mbg_pmir_pcas_c_r2_POC_4 iout vpc co nw sg13_hv_pmos w=10u l=1u ng=1 m=1
Mbg_pmir_pcas_c_r2_dummyn_5 vdd vpc vdd nw sg13_hv_pmos w=0.3u l=1u ng=1 m=1
Mbg_pmir_pcas_c_r3_dummyn_0 vdd vpc vdd nw sg13_hv_pmos w=0.3u l=1u ng=1 m=1
Mbg_pmir_pcas_c_r3_PAC_1 g vpc ca nw sg13_hv_pmos w=10u l=1u ng=1 m=1
Mbg_pmir_pcas_c_r3_POC_2 iout vpc co nw sg13_hv_pmos w=10u l=1u ng=1 m=1
Mbg_pmir_pcas_c_r3_POC_3 iout vpc co nw sg13_hv_pmos w=10u l=1u ng=1 m=1
Mbg_pmir_pcas_c_r3_PBC_4 vpc vpc vpg nw sg13_hv_pmos w=10u l=1u ng=1 m=1
Mbg_pmir_pcas_c_r3_dummyn_5 vdd vpc vdd nw sg13_hv_pmos w=0.3u l=1u ng=1 m=1
Mbg_pmir_pcas_c_r4_dummyn_0 vdd vpg vdd nw sg13_hv_pmos w=0.3u l=1u ng=1 m=1
Mbg_pmir_pcas_c_r4_PA_1 ca vpg vdd nw sg13_hv_pmos w=10u l=1u ng=1 m=1
Mbg_pmir_pcas_c_r4_PO_2 co vpg vdd nw sg13_hv_pmos w=10u l=1u ng=1 m=1
Mbg_pmir_pcas_c_r4_PO_3 co vpg vdd nw sg13_hv_pmos w=10u l=1u ng=1 m=1
Mbg_pmir_pcas_c_r4_PB_4 vpg vpg vdd nw sg13_hv_pmos w=10u l=1u ng=1 m=1
Mbg_pmir_pcas_c_r4_dummyn_5 vdd vpg vdd nw sg13_hv_pmos w=0.3u l=1u ng=1 m=1
Mbg_pmir_pcas_c_r5_dummyn_0 vdd vpg vdd nw sg13_hv_pmos w=0.3u l=1u ng=1 m=1
Mbg_pmir_pcas_c_r5_PB_1 vpg vpg vdd nw sg13_hv_pmos w=10u l=1u ng=1 m=1
Mbg_pmir_pcas_c_r5_PO_2 co vpg vdd nw sg13_hv_pmos w=10u l=1u ng=1 m=1
Mbg_pmir_pcas_c_r5_PO_3 co vpg vdd nw sg13_hv_pmos w=10u l=1u ng=1 m=1
Mbg_pmir_pcas_c_r5_PA_4 ca vpg vdd nw sg13_hv_pmos w=10u l=1u ng=1 m=1
Mbg_pmir_pcas_c_r5_dummyn_5 vdd vpg vdd nw sg13_hv_pmos w=0.3u l=1u ng=1 m=1
Mbg_pmir_pcas_c_r6_dummyn_0 vdd vpc vdd nw sg13_hv_pmos w=0.3u l=1u ng=1 m=1
Mbg_pmir_pcas_c_r6_PBC_1 vpc vpc vpg nw sg13_hv_pmos w=10u l=1u ng=1 m=1
Mbg_pmir_pcas_c_r6_POC_2 iout vpc co nw sg13_hv_pmos w=10u l=1u ng=1 m=1
Mbg_pmir_pcas_c_r6_POC_3 iout vpc co nw sg13_hv_pmos w=10u l=1u ng=1 m=1
Mbg_pmir_pcas_c_r6_PAC_4 g vpc ca nw sg13_hv_pmos w=10u l=1u ng=1 m=1
Mbg_pmir_pcas_c_r6_dummyn_5 vdd vpc vdd nw sg13_hv_pmos w=0.3u l=1u ng=1 m=1
Mbg_pmir_pcas_c_r7_dummyn_0 vdd vpc vdd nw sg13_hv_pmos w=0.3u l=1u ng=1 m=1
Mbg_pmir_pcas_c_r7_POC_1 iout vpc co nw sg13_hv_pmos w=10u l=1u ng=1 m=1
Mbg_pmir_pcas_c_r7_PAC_2 g vpc ca nw sg13_hv_pmos w=10u l=1u ng=1 m=1
Mbg_pmir_pcas_c_r7_PBC_3 vpc vpc vpg nw sg13_hv_pmos w=10u l=1u ng=1 m=1
Mbg_pmir_pcas_c_r7_POC_4 iout vpc co nw sg13_hv_pmos w=10u l=1u ng=1 m=1
Mbg_pmir_pcas_c_r7_dummyn_5 vdd vpc vdd nw sg13_hv_pmos w=0.3u l=1u ng=1 m=1
Mbg_pmir_pcas_c_r8_dummyn_0 vdd vpg vdd nw sg13_hv_pmos w=0.3u l=1u ng=1 m=1
Mbg_pmir_pcas_c_r8_PO_1 co vpg vdd nw sg13_hv_pmos w=10u l=1u ng=1 m=1
Mbg_pmir_pcas_c_r8_PA_2 ca vpg vdd nw sg13_hv_pmos w=10u l=1u ng=1 m=1
Mbg_pmir_pcas_c_r8_PB_3 vpg vpg vdd nw sg13_hv_pmos w=10u l=1u ng=1 m=1
Mbg_pmir_pcas_c_r8_PO_4 co vpg vdd nw sg13_hv_pmos w=10u l=1u ng=1 m=1
Mbg_pmir_pcas_c_r8_dummyn_5 vdd vpg vdd nw sg13_hv_pmos w=0.3u l=1u ng=1 m=1
.ENDS bg_pmir_pcas_c

.SUBCKT bg_ms1 en_3v3_b ks vdd
Mbg_ms1_MS1_0 ms1 en_3v3_b vdd nw sg13_hv_pmos w=0.5u l=12.5u ng=1 m=1
Mbg_ms1_MS1_1 ms2 en_3v3_b ms1 nw sg13_hv_pmos w=0.5u l=12.5u ng=1 m=1
Mbg_ms1_MS1_2 ms3 en_3v3_b ms2 nw sg13_hv_pmos w=0.5u l=12.5u ng=1 m=1
Mbg_ms1_MS1_3 ms4 en_3v3_b ms3 nw sg13_hv_pmos w=0.5u l=12.5u ng=1 m=1
Mbg_ms1_MS1_4 ms5 en_3v3_b ms4 nw sg13_hv_pmos w=0.5u l=12.5u ng=1 m=1
Mbg_ms1_MS1_5 ms6 en_3v3_b ms5 nw sg13_hv_pmos w=0.5u l=12.5u ng=1 m=1
Mbg_ms1_MS1_6 ms7 en_3v3_b ms6 nw sg13_hv_pmos w=0.5u l=12.5u ng=1 m=1
Mbg_ms1_MS1_7 ks en_3v3_b ms7 nw sg13_hv_pmos w=0.5u l=12.5u ng=1 m=1
.ENDS bg_ms1

.SUBCKT bg_svpg en_3v3 vdd vpg
Mbg_svpg_SVPG vpg en_3v3 vdd nw sg13_hv_pmos w=1u l=0.45u ng=1 m=1
.ENDS bg_svpg
