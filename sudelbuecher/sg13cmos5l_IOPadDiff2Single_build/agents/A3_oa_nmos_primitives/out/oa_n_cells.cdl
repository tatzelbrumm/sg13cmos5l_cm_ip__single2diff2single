* SPDX-FileCopyrightText: 2026 Christoph Maier
* SPDX-License-Identifier: Apache-2.0
* oa_n_cells.cdl: reference netlists of oa_n_cells.gds, devices as drawn (one line per finger,
* dummies included), generated by build_oa_n.py 2026-10-28 (Claude, Opus 5.5).
* Internal net of oa_n10: d10 (M10 drain = MC10 source).

.SUBCKT oa_n10 vss vnc vres vbr vpc ks en_3v3_b
Mdummy_X0_0 vss vnc vss vss sg13_hv_nmos w=2u l=1u ng=1 m=1
MM10_X0_1 d10 vnc vres vss sg13_hv_nmos w=10u l=1u ng=1 m=1
MM10_X0_2 d10 vnc vres vss sg13_hv_nmos w=10u l=1u ng=1 m=1
MM10_X0_3 d10 vnc vres vss sg13_hv_nmos w=10u l=1u ng=1 m=1
Mdummy_X0_4 vss vnc vss vss sg13_hv_nmos w=2u l=1u ng=1 m=1
Mdummy_X1_0 vss vnc vss vss sg13_hv_nmos w=2u l=1u ng=1 m=1
MM11_X1_1 vnc vnc vss vss sg13_hv_nmos w=10u l=1u ng=1 m=1
MM11_X1_2 vnc vnc vss vss sg13_hv_nmos w=10u l=1u ng=1 m=1
MM11_X1_3 vnc vnc vss vss sg13_hv_nmos w=10u l=1u ng=1 m=1
Mdummy_X1_4 vss vnc vss vss sg13_hv_nmos w=2u l=1u ng=1 m=1
Mdummy_X2_0 vss vnc vss vss sg13_hv_nmos w=2u l=1u ng=1 m=1
MM10_X2_1 d10 vnc vres vss sg13_hv_nmos w=10u l=1u ng=1 m=1
MM10_X2_2 d10 vnc vres vss sg13_hv_nmos w=10u l=1u ng=1 m=1
MM10_X2_3 d10 vnc vres vss sg13_hv_nmos w=10u l=1u ng=1 m=1
Mdummy_X2_4 vss vnc vss vss sg13_hv_nmos w=2u l=1u ng=1 m=1
Mdummy_X3_0 vss vnc vss vss sg13_hv_nmos w=2u l=1u ng=1 m=1
MM10_X3_1 d10 vnc vres vss sg13_hv_nmos w=10u l=1u ng=1 m=1
MM10_X3_2 d10 vnc vres vss sg13_hv_nmos w=10u l=1u ng=1 m=1
MM10_X3_3 d10 vnc vres vss sg13_hv_nmos w=10u l=1u ng=1 m=1
Mdummy_X3_4 vss vnc vss vss sg13_hv_nmos w=2u l=1u ng=1 m=1
Mdummy_X4_0 vss vnc vss vss sg13_hv_nmos w=2u l=1u ng=1 m=1
MM11_X4_1 vnc vnc vss vss sg13_hv_nmos w=10u l=1u ng=1 m=1
MM11_X4_2 vnc vnc vss vss sg13_hv_nmos w=10u l=1u ng=1 m=1
MM11_X4_3 vnc vnc vss vss sg13_hv_nmos w=10u l=1u ng=1 m=1
Mdummy_X4_4 vss vnc vss vss sg13_hv_nmos w=2u l=1u ng=1 m=1
Mdummy_X5_0 vss vnc vss vss sg13_hv_nmos w=2u l=1u ng=1 m=1
MM10_X5_1 d10 vnc vres vss sg13_hv_nmos w=10u l=1u ng=1 m=1
MM10_X5_2 d10 vnc vres vss sg13_hv_nmos w=10u l=1u ng=1 m=1
MM10_X5_3 d10 vnc vres vss sg13_hv_nmos w=10u l=1u ng=1 m=1
Mdummy_X5_4 vss vnc vss vss sg13_hv_nmos w=2u l=1u ng=1 m=1
Mdummy_X6_0 vss vnc vss vss sg13_hv_nmos w=2u l=1u ng=1 m=1
MM10_X6_1 d10 vnc vres vss sg13_hv_nmos w=10u l=1u ng=1 m=1
MM10_X6_2 d10 vnc vres vss sg13_hv_nmos w=10u l=1u ng=1 m=1
MM10_X6_3 d10 vnc vres vss sg13_hv_nmos w=10u l=1u ng=1 m=1
Mdummy_X6_4 vss vnc vss vss sg13_hv_nmos w=2u l=1u ng=1 m=1
Mdummy_X7_0 vss vnc vss vss sg13_hv_nmos w=2u l=1u ng=1 m=1
MM11_X7_1 vnc vnc vss vss sg13_hv_nmos w=10u l=1u ng=1 m=1
MM11_X7_2 vnc vnc vss vss sg13_hv_nmos w=10u l=1u ng=1 m=1
MM11_X7_3 vnc vnc vss vss sg13_hv_nmos w=10u l=1u ng=1 m=1
Mdummy_X7_4 vss vnc vss vss sg13_hv_nmos w=2u l=1u ng=1 m=1
Mdummy_X8_0 vss vnc vss vss sg13_hv_nmos w=2u l=1u ng=1 m=1
MM10_X8_1 d10 vnc vres vss sg13_hv_nmos w=10u l=1u ng=1 m=1
MM10_X8_2 d10 vnc vres vss sg13_hv_nmos w=10u l=1u ng=1 m=1
MM10_X8_3 d10 vnc vres vss sg13_hv_nmos w=10u l=1u ng=1 m=1
Mdummy_X8_4 vss vnc vss vss sg13_hv_nmos w=2u l=1u ng=1 m=1
Mdummy_Y_0 vss vbr vss vss sg13_hv_nmos w=2u l=1u ng=1 m=1
MMC10_Y_1 vpc vbr d10 vss sg13_hv_nmos w=10u l=1u ng=1 m=1
MMS2_Y_2 ks vbr vss vss sg13_hv_nmos w=10u l=1u ng=1 m=1
Mdummy_Y_3 vss vbr vss vss sg13_hv_nmos w=2u l=1u ng=1 m=1
MMS3 vpc ks vss vss sg13_hv_nmos w=0.5u l=2u ng=1 m=1
MSKS ks en_3v3_b vss vss sg13_hv_nmos w=1u l=0.45u ng=1 m=1
.ENDS oa_n10

.SUBCKT oa_mcs_c vss vbr vres
MMCS vbr vbr vss vss sg13_hv_nmos w=3.4u l=30u ng=1 m=1
MMCL vres vbr vss vss sg13_hv_nmos w=3.4u l=30u ng=1 m=1
.ENDS oa_mcs_c
