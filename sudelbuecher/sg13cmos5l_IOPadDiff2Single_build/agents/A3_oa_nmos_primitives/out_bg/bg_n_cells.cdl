* SPDX-FileCopyrightText: 2026 Christoph Maier
* SPDX-License-Identifier: Apache-2.0
* bg_n_cells.cdl: reference netlist of bg_n_cells.gds, devices as drawn (one line per finger, dummies
* included), generated by build_bg_n.py 2026-10-28 (Claude, Opus 5.5).

.SUBCKT bg_n4 vss g vpc ea eb ks en_3v3_b
Mdummy_R0_0 g g g vss sg13_hv_nmos w=2u l=4u ng=1 m=1
MNA_R0_1 g g ea vss sg13_hv_nmos w=10u l=4u ng=1 m=1
Mdummy_R0_2 g g g vss sg13_hv_nmos w=2u l=4u ng=1 m=1
Mdummy_R1_0 g g g vss sg13_hv_nmos w=2u l=4u ng=1 m=1
MNB_R1_1 vpc g eb vss sg13_hv_nmos w=10u l=4u ng=1 m=1
Mdummy_R1_2 g g g vss sg13_hv_nmos w=2u l=4u ng=1 m=1
Mdummy_R2_0 g g g vss sg13_hv_nmos w=2u l=4u ng=1 m=1
MNB_R2_1 vpc g eb vss sg13_hv_nmos w=10u l=4u ng=1 m=1
Mdummy_R2_2 g g g vss sg13_hv_nmos w=2u l=4u ng=1 m=1
Mdummy_R3_0 g g g vss sg13_hv_nmos w=2u l=4u ng=1 m=1
MNA_R3_1 g g ea vss sg13_hv_nmos w=10u l=4u ng=1 m=1
Mdummy_R3_2 g g g vss sg13_hv_nmos w=2u l=4u ng=1 m=1
Mdummy_Y_0 g g g vss sg13_hv_nmos w=2u l=1u ng=1 m=1
MMS2_Y_1 ks g vss vss sg13_hv_nmos w=10u l=1u ng=1 m=1
MMS3 vpc ks vss vss sg13_hv_nmos w=0.5u l=2u ng=1 m=1
MSKS ks en_3v3_b vss vss sg13_hv_nmos w=1u l=0.45u ng=1 m=1
.ENDS bg_n4
