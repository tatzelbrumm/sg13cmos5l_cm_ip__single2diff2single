.SUBCKT oa_pcas c2 c8 co iout vbr vdd vnc vpc vpg
Moa_pcas_POC_0 iout vpc co vdd sg13_hv_pmos w=2u l=2u ng=1 m=1
Moa_pcas_POC_1 iout vpc co vdd sg13_hv_pmos w=2u l=2u ng=1 m=1
Moa_pcas_P8C_2 vnc vpc c8 vdd sg13_hv_pmos w=2u l=2u ng=1 m=1
Moa_pcas_POC_3 iout vpc co vdd sg13_hv_pmos w=2u l=2u ng=1 m=1
Moa_pcas_P0C_4 vpc vpc vpg vdd sg13_hv_pmos w=0.5u l=2u ng=1 m=1
Moa_pcas_P2C_5 vbr vpc c2 vdd sg13_hv_pmos w=1u l=2u ng=1 m=1
Moa_pcas_POC_6 iout vpc co vdd sg13_hv_pmos w=2u l=2u ng=1 m=1
Moa_pcas_P8C_7 vnc vpc c8 vdd sg13_hv_pmos w=2u l=2u ng=1 m=1
Moa_pcas_POC_8 iout vpc co vdd sg13_hv_pmos w=2u l=2u ng=1 m=1
.ENDS oa_pcas
