.SUBCKT oa_misc_n d10 en_3v3_b ks vbr vpc vss
Moa_misc_n_MC10_0 vpc vbr d10 vss sg13_hv_nmos w=10u l=1u ng=1 m=1
Moa_misc_n_MS2_1 ks vbr vss vss sg13_hv_nmos w=10u l=1u ng=1 m=1
Moa_misc_n_MS3_2 vpc ks vss vss sg13_hv_nmos w=0.5u l=2u ng=1 m=1
Moa_misc_n_SKS_3 ks en_3v3_b vss vss sg13_hv_nmos w=1u l=0.45u ng=1 m=1
.ENDS oa_misc_n
