** sch_path: /foss/designs/sg13cmos5l_cm_ip__single2diff2single_sudelbuecher/sudelbuecher/JanteStroemSpejl/runs/RUN_2026-10-16_00-47-41/parameters/mirror_rout/run_1/run_42/JanteStroemSpejl_cace_mismatch.sch
**.subckt JanteStroemSpejl_cace_mismatch
XJANTE IREF 0 0 OUT01 OUT02 OUT03 OUT04 OUT05 OUT06 OUT07 OUT08 OUT09 OUT10 JanteStroemSpejl
VDD net1 0 1.2
IREFSRC net1 IREF 3u
VDUMMY CACE_ITERATION 0 43.0
**** begin user architecture code

.lib cornerMOSlv.lib mos_tt_mismatch
.lib cornerMOShv.lib mos_tt_mismatch

VDVDS DREF IREF 0
ECL01 CL01 0 DREF 0 1
VMON01 CL01 OUT01 0
ECL02 CL02 0 DREF 0 1
VMON02 CL02 OUT02 0
ECL03 CL03 0 DREF 0 1
VMON03 CL03 OUT03 0
ECL04 CL04 0 DREF 0 1
VMON04 CL04 OUT04 0
ECL05 CL05 0 DREF 0 1
VMON05 CL05 OUT05 0
ECL06 CL06 0 DREF 0 1
VMON06 CL06 OUT06 0
ECL07 CL07 0 DREF 0 1
VMON07 CL07 OUT07 0
ECL08 CL08 0 DREF 0 1
VMON08 CL08 OUT08 0
ECL09 CL09 0 DREF 0 1
VMON09 CL09 OUT09 0
ECL10 CL10 0 DREF 0 1
VMON10 CL10 OUT10 0

.include /foss/designs/sg13cmos5l_cm_ip__single2diff2single_sudelbuecher/sudelbuecher/JanteStroemSpejl/netlist/schematic/JanteStroemSpejl.spice
.temp 27
.option SEED=12388.0
.control
  set num_threads=1
  op
  let e01 = (i(VMON01)/3u)-1
  let e02 = (i(VMON02)/3u)-1
  let e03 = (i(VMON03)/3u)-1
  let e04 = (i(VMON04)/3u)-1
  let e05 = (i(VMON05)/3u)-1
  let e06 = (i(VMON06)/3u)-1
  let e07 = (i(VMON07)/3u)-1
  let e08 = (i(VMON08)/3u)-1
  let e09 = (i(VMON09)/3u)-1
  let e10 = (i(VMON10)/3u)-1
  echo $&e01 $&e02 $&e03 $&e04 $&e05 $&e06 $&e07 $&e08 $&e09 $&e10 > /foss/designs/sg13cmos5l_cm_ip__single2diff2single_sudelbuecher/sudelbuecher/JanteStroemSpejl/runs/RUN_2026-10-16_00-47-41/parameters/mirror_rout/run_1/run_42/JanteStroemSpejl_cace_mismatch_1.data
  quit
.endc

**** end user architecture code
**.ends
.end

** sch_path: /foss/designs/sg13cmos5l_cm_ip__single2diff2single_sudelbuecher/sudelbuecher/JanteStroemSpejl/JanteStroemSpejl.sch
.subckt JanteStroemSpejl IREF S B OUT01 OUT02 OUT03 OUT04 OUT05 OUT06 OUT07 OUT08 OUT09 OUT10
*.PININFO IREF:B S:B B:B OUT01:B OUT02:B OUT03:B OUT04:B OUT05:B OUT06:B OUT07:B OUT08:B OUT09:B OUT10:B
XM_L01 OUT01 IREF S B sg13_lv_nmos w=WJ l=LJ ng=1 m=1 mm_ok=1
XM_R01 OUT01 IREF S B sg13_lv_nmos w=WJ l=LJ ng=1 m=1 mm_ok=1
XM_L02 OUT02 IREF S B sg13_lv_nmos w=WJ l=LJ ng=1 m=1 mm_ok=1
XM_R02 OUT02 IREF S B sg13_lv_nmos w=WJ l=LJ ng=1 m=1 mm_ok=1
XM_L03 OUT03 IREF S B sg13_lv_nmos w=WJ l=LJ ng=1 m=1 mm_ok=1
XM_R03 OUT03 IREF S B sg13_lv_nmos w=WJ l=LJ ng=1 m=1 mm_ok=1
XM_L04 OUT04 IREF S B sg13_lv_nmos w=WJ l=LJ ng=1 m=1 mm_ok=1
XM_R04 OUT04 IREF S B sg13_lv_nmos w=WJ l=LJ ng=1 m=1 mm_ok=1
XM_L05 OUT05 IREF S B sg13_lv_nmos w=WJ l=LJ ng=1 m=1 mm_ok=1
XM_R05 OUT05 IREF S B sg13_lv_nmos w=WJ l=LJ ng=1 m=1 mm_ok=1
XM_L06 IREF IREF S B sg13_lv_nmos w=WJ l=LJ ng=1 m=1 mm_ok=1
XM_R06 IREF IREF S B sg13_lv_nmos w=WJ l=LJ ng=1 m=1 mm_ok=1
XM_L07 OUT06 IREF S B sg13_lv_nmos w=WJ l=LJ ng=1 m=1 mm_ok=1
XM_R07 OUT06 IREF S B sg13_lv_nmos w=WJ l=LJ ng=1 m=1 mm_ok=1
XM_L08 OUT07 IREF S B sg13_lv_nmos w=WJ l=LJ ng=1 m=1 mm_ok=1
XM_R08 OUT07 IREF S B sg13_lv_nmos w=WJ l=LJ ng=1 m=1 mm_ok=1
XM_L09 OUT08 IREF S B sg13_lv_nmos w=WJ l=LJ ng=1 m=1 mm_ok=1
XM_R09 OUT08 IREF S B sg13_lv_nmos w=WJ l=LJ ng=1 m=1 mm_ok=1
XM_L10 OUT09 IREF S B sg13_lv_nmos w=WJ l=LJ ng=1 m=1 mm_ok=1
XM_R10 OUT09 IREF S B sg13_lv_nmos w=WJ l=LJ ng=1 m=1 mm_ok=1
XM_L11 OUT10 IREF S B sg13_lv_nmos w=WJ l=LJ ng=1 m=1 mm_ok=1
XM_R11 OUT10 IREF S B sg13_lv_nmos w=WJ l=LJ ng=1 m=1 mm_ok=1
**** begin user architecture code

.param lambda=0.08u
.param WJ='4*lambda'
.param LJ='64*lambda'

**** end user architecture code
.ends
