* sg13cmos5l_IOPadInOut30mA
* Exact hierarchical subcircuits extracted from the official IHP
* libs.ref/sg13cmos5l_io/spice/sg13cmos5l_io.spi
*
* This contains the complete local hierarchy for the pad cell.
* Primitive/process-device definitions are external PDK dependencies:
*   sg13_lv_nmos, sg13_lv_pmos, sg13_hv_nmos, sg13_hv_pmos,
*   dantenna, dpantenna, rppd
*
* ----------------------------------------------------------------------
* Core logic used by GateDecode
* ----------------------------------------------------------------------

* sg13cmos5l_io_tie
.subckt sg13cmos5l_io_tie vdd vss

.ends sg13cmos5l_io_tie

* sg13cmos5l_io_inv_x1
.subckt sg13cmos5l_io_inv_x1 vdd vss i nq
Xnmos vss i nq vss sg13_lv_nmos l=0.13um w=3.93um
Xpmos vdd i nq vdd sg13_lv_pmos l=0.13um w=4.41um
.ends sg13cmos5l_io_inv_x1

* sg13cmos5l_io_nor2_x1
.subckt sg13cmos5l_io_nor2_x1 vdd vss nq i0 i1
Xi0_nmos vss i0 nq vss sg13_lv_nmos l=0.13um w=3.93um
Xi0_pmos vdd i0 _net0 vdd sg13_lv_pmos l=0.13um w=4.41um
Xi1_nmos nq i1 vss vss sg13_lv_nmos l=0.13um w=3.93um
Xi1_pmos _net0 i1 nq vdd sg13_lv_pmos l=0.13um w=4.41um
.ends sg13cmos5l_io_nor2_x1

* sg13cmos5l_LevelUp
.subckt sg13cmos5l_LevelUp vdd iovdd vss i o
Xn_i_inv i_n i vss vss sg13_lv_nmos l=0.13um w=2.75um
Xp_i_inv i_n i vdd vdd sg13_lv_pmos l=0.13um w=4.75um
Xn_lvld_n vss i lvld_n vss sg13_hv_nmos l=0.45um w=1.9um
Xn_lvld lvld i_n vss vss sg13_hv_nmos l=0.45um w=1.9um
Xp_lvld_n iovdd lvld lvld_n iovdd sg13_hv_pmos l=0.45um w=0.3um
Xp_lvld lvld lvld_n iovdd iovdd sg13_hv_pmos l=0.45um w=0.3um
Xn_lvld_n_inv vss lvld_n o vss sg13_hv_nmos l=0.45um w=1.9um
Xp_lvld_n_inv iovdd lvld_n o iovdd sg13_hv_pmos l=0.45um w=3.9um
.ends sg13cmos5l_LevelUp

* sg13cmos5l_io_nand2_x1
.subckt sg13cmos5l_io_nand2_x1 vdd vss nq i0 i1
Xi0_nmos vss i0 _net0 vss sg13_lv_nmos l=0.13um w=3.93um
Xi0_pmos vdd i0 nq vdd sg13_lv_pmos l=0.13um w=4.41um
Xi1_nmos _net0 i1 nq vss sg13_lv_nmos l=0.13um w=3.93um
Xi1_pmos nq i1 vdd vdd sg13_lv_pmos l=0.13um w=4.41um
.ends sg13cmos5l_io_nand2_x1

* sg13cmos5l_GateDecode
.subckt sg13cmos5l_GateDecode vdd vss iovdd core en ngate pgate
Xtieinst vdd vss sg13cmos5l_io_tie
Xen_inv vdd vss en en_n sg13cmos5l_io_inv_x1
Xngate_nor vdd vss ngate_core core en_n sg13cmos5l_io_nor2_x1
Xngate_levelup vdd iovdd vss ngate_core ngate sg13cmos5l_LevelUp
Xpgate_nand vdd vss pgate_core core en sg13cmos5l_io_nand2_x1
Xpgate_levelup vdd iovdd vss pgate_core pgate sg13cmos5l_LevelUp
.ends sg13cmos5l_GateDecode

* ----------------------------------------------------------------------
* LevelDown / secondary input protection
* ----------------------------------------------------------------------

* sg13cmos5l_GuardRing_P576W948HFF
.subckt sg13cmos5l_GuardRing_P576W948HFF conn

.ends sg13cmos5l_GuardRing_P576W948HFF

* sg13cmos5l_GuardRing_P456W948HFF
.subckt sg13cmos5l_GuardRing_P456W948HFF conn

.ends sg13cmos5l_GuardRing_P456W948HFF

* sg13cmos5l_GuardRing_N1324W456HTF
.subckt sg13cmos5l_GuardRing_N1324W456HTF conn

.ends sg13cmos5l_GuardRing_N1324W456HTF

* sg13cmos5l_SecondaryProtection
.subckt sg13cmos5l_SecondaryProtection iovdd iovss pad core
XR pad core sub! rppd l=2.0um w=1.0um
Xguard1 iovss sg13cmos5l_GuardRing_P576W948HFF
XDN iovss core dantenna l=3.1um w=0.64um
Xguard2 iovss sg13cmos5l_GuardRing_P456W948HFF
XDP core iovdd dpantenna l=0.64um w=4.98um
Xguard3 iovdd sg13cmos5l_GuardRing_N1324W456HTF
.ends sg13cmos5l_SecondaryProtection

* sg13cmos5l_LevelDown
.subckt sg13cmos5l_LevelDown vdd vss iovdd iovss pad core
Xn_hvinv vss padres padres_n vss sg13_hv_nmos l=0.45um w=2.65um
Xp_hvinv vdd padres padres_n vdd sg13_hv_pmos l=0.45um w=4.65um
Xn_lvinv core padres_n vss vss sg13_lv_nmos l=0.13um w=2.75um
Xp_lvinv core padres_n vdd vdd sg13_lv_pmos l=0.13um w=4.75um
Xsecondprot iovdd iovss pad padres sg13cmos5l_SecondaryProtection
.ends sg13cmos5l_LevelDown

* ----------------------------------------------------------------------
* Primary ESD diodes
* ----------------------------------------------------------------------

* sg13cmos5l_GuardRing_N7276W2716HFF
.subckt sg13cmos5l_GuardRing_N7276W2716HFF conn

.ends sg13cmos5l_GuardRing_N7276W2716HFF

* sg13cmos5l_DCNDiode
.subckt sg13cmos5l_DCNDiode anode cathode guard
Xdcdiode[0] anode cathode dantenna l=1.26um w=27.78um
Xdcdiode[1] anode cathode dantenna l=1.26um w=27.78um
Xguard guard sg13cmos5l_GuardRing_N7276W2716HFF
.ends sg13cmos5l_DCNDiode

* sg13cmos5l_GuardRing_P7276W2716HFF
.subckt sg13cmos5l_GuardRing_P7276W2716HFF conn

.ends sg13cmos5l_GuardRing_P7276W2716HFF

* sg13cmos5l_DCPDiode
.subckt sg13cmos5l_DCPDiode anode cathode guard
Xdcdiode[0] anode cathode dpantenna l=1.26um w=27.78um
Xdcdiode[1] anode cathode dpantenna l=1.26um w=27.78um
Xguard guard sg13cmos5l_GuardRing_P7276W2716HFF
.ends sg13cmos5l_DCPDiode

* ----------------------------------------------------------------------
* 30 mA output devices
* ----------------------------------------------------------------------

* sg13cmos5l_GuardRing_N16000W1980HFF
.subckt sg13cmos5l_GuardRing_N16000W1980HFF conn

.ends sg13cmos5l_GuardRing_N16000W1980HFF

* sg13cmos5l_GuardRing_P15280W1260HFF
.subckt sg13cmos5l_GuardRing_P15280W1260HFF conn
.ends sg13cmos5l_GuardRing_P15280W1260HFF

* sg13cmos5l_GuardRing_P16000W3852HFF
.subckt sg13cmos5l_GuardRing_P16000W3852HFF conn
.ends sg13cmos5l_GuardRing_P16000W3852HFF

* sg13cmos5l_GuardRing_N15280W3132HTF
.subckt sg13cmos5l_GuardRing_N15280W3132HTF conn

.ends sg13cmos5l_GuardRing_N15280W3132HTF

* sg13cmos5l_Clamp_N15N15D
.subckt sg13cmos5l_Clamp_N15N15D iovss iovdd pad gate
Xclamp_g0 iovss gate pad iovss sg13_hv_nmos l=0.6um w=4.4um
Xclamp_g1 pad gate iovss iovss sg13_hv_nmos l=0.6um w=4.4um
Xclamp_g2 iovss gate pad iovss sg13_hv_nmos l=0.6um w=4.4um
Xclamp_g3 pad gate iovss iovss sg13_hv_nmos l=0.6um w=4.4um
Xclamp_g4 iovss gate pad iovss sg13_hv_nmos l=0.6um w=4.4um
Xclamp_g5 pad gate iovss iovss sg13_hv_nmos l=0.6um w=4.4um
Xclamp_g6 iovss gate pad iovss sg13_hv_nmos l=0.6um w=4.4um
Xclamp_g7 pad gate iovss iovss sg13_hv_nmos l=0.6um w=4.4um
Xclamp_g8 iovss gate pad iovss sg13_hv_nmos l=0.6um w=4.4um
Xclamp_g9 pad gate iovss iovss sg13_hv_nmos l=0.6um w=4.4um
Xclamp_g10 iovss gate pad iovss sg13_hv_nmos l=0.6um w=4.4um
Xclamp_g11 pad gate iovss iovss sg13_hv_nmos l=0.6um w=4.4um
Xclamp_g12 iovss gate pad iovss sg13_hv_nmos l=0.6um w=4.4um
Xclamp_g13 pad gate iovss iovss sg13_hv_nmos l=0.6um w=4.4um
Xclamp_g14 iovss gate pad iovss sg13_hv_nmos l=0.6um w=4.4um
XOuterRing iovdd sg13cmos5l_GuardRing_N16000W1980HFF
XInnerRing iovss sg13cmos5l_GuardRing_P15280W1260HFF
XDGATE iovss gate dantenna l=0.64um w=0.48um
.ends sg13cmos5l_Clamp_N15N15D

* sg13cmos5l_Clamp_P15N15D
.subckt sg13cmos5l_Clamp_P15N15D iovss iovdd pad gate
Xclamp_g0_r0 iovdd gate pad iovdd sg13_hv_pmos l=0.6um w=6.66um
Xclamp_g0_r1 iovdd gate pad iovdd sg13_hv_pmos l=0.6um w=6.66um
Xclamp_g1_r0 pad gate iovdd iovdd sg13_hv_pmos l=0.6um w=6.66um
Xclamp_g1_r1 pad gate iovdd iovdd sg13_hv_pmos l=0.6um w=6.66um
Xclamp_g2_r0 iovdd gate pad iovdd sg13_hv_pmos l=0.6um w=6.66um
Xclamp_g2_r1 iovdd gate pad iovdd sg13_hv_pmos l=0.6um w=6.66um
Xclamp_g3_r0 pad gate iovdd iovdd sg13_hv_pmos l=0.6um w=6.66um
Xclamp_g3_r1 pad gate iovdd iovdd sg13_hv_pmos l=0.6um w=6.66um
Xclamp_g4_r0 iovdd gate pad iovdd sg13_hv_pmos l=0.6um w=6.66um
Xclamp_g4_r1 iovdd gate pad iovdd sg13_hv_pmos l=0.6um w=6.66um
Xclamp_g5_r0 pad gate iovdd iovdd sg13_hv_pmos l=0.6um w=6.66um
Xclamp_g5_r1 pad gate iovdd iovdd sg13_hv_pmos l=0.6um w=6.66um
Xclamp_g6_r0 iovdd gate pad iovdd sg13_hv_pmos l=0.6um w=6.66um
Xclamp_g6_r1 iovdd gate pad iovdd sg13_hv_pmos l=0.6um w=6.66um
Xclamp_g7_r0 pad gate iovdd iovdd sg13_hv_pmos l=0.6um w=6.66um
Xclamp_g7_r1 pad gate iovdd iovdd sg13_hv_pmos l=0.6um w=6.66um
Xclamp_g8_r0 iovdd gate pad iovdd sg13_hv_pmos l=0.6um w=6.66um
Xclamp_g8_r1 iovdd gate pad iovdd sg13_hv_pmos l=0.6um w=6.66um
Xclamp_g9_r0 pad gate iovdd iovdd sg13_hv_pmos l=0.6um w=6.66um
Xclamp_g9_r1 pad gate iovdd iovdd sg13_hv_pmos l=0.6um w=6.66um
Xclamp_g10_r0 iovdd gate pad iovdd sg13_hv_pmos l=0.6um w=6.66um
Xclamp_g10_r1 iovdd gate pad iovdd sg13_hv_pmos l=0.6um w=6.66um
Xclamp_g11_r0 pad gate iovdd iovdd sg13_hv_pmos l=0.6um w=6.66um
Xclamp_g11_r1 pad gate iovdd iovdd sg13_hv_pmos l=0.6um w=6.66um
Xclamp_g12_r0 iovdd gate pad iovdd sg13_hv_pmos l=0.6um w=6.66um
Xclamp_g12_r1 iovdd gate pad iovdd sg13_hv_pmos l=0.6um w=6.66um
Xclamp_g13_r0 pad gate iovdd iovdd sg13_hv_pmos l=0.6um w=6.66um
Xclamp_g13_r1 pad gate iovdd iovdd sg13_hv_pmos l=0.6um w=6.66um
Xclamp_g14_r0 iovdd gate pad iovdd sg13_hv_pmos l=0.6um w=6.66um
Xclamp_g14_r1 iovdd gate pad iovdd sg13_hv_pmos l=0.6um w=6.66um
XOuterRing iovss sg13cmos5l_GuardRing_P16000W3852HFF
XInnerRing iovdd sg13cmos5l_GuardRing_N15280W3132HTF
XDGATE gate iovdd dpantenna l=0.64um w=0.48um
.ends sg13cmos5l_Clamp_P15N15D

* ----------------------------------------------------------------------
* Target cell
* ----------------------------------------------------------------------

* sg13cmos5l_IOPadInOut30mA
.subckt sg13cmos5l_IOPadInOut30mA vss vdd iovss iovdd p2c c2p c2p_en pad
Xnclamp iovss iovdd pad ngate sg13cmos5l_Clamp_N15N15D
Xpclamp iovss iovdd pad pgate sg13cmos5l_Clamp_P15N15D
Xdcndiode iovss pad iovdd sg13cmos5l_DCNDiode
Xdcpdiode pad iovdd iovss sg13cmos5l_DCPDiode
Xgatedec vdd vss iovdd c2p c2p_en ngate pgate sg13cmos5l_GateDecode
Xleveldown vdd vss iovdd iovss pad p2c sg13cmos5l_LevelDown
.ends sg13cmos5l_IOPadInOut30mA
