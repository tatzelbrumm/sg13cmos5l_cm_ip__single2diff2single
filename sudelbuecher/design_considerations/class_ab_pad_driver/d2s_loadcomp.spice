* SPDX-FileCopyrightText: 2026 Christoph Maier
* SPDX-License-Identifier: Apache-2.0
* d2s_loadcomp: differential-in, single-ended pad out, single-stage class-AB, load compensated
* vout - vref = (Gm1/Gm2)*(vinp - vinn) ~= 1/2 * (vinp - vinn), vfb tied to vout
* same DDA front end and floating class-AB control as d2s_miller, but no Miller capacitors:
* the output-device gates are diode-loaded (low impedance), so vout is the only high-impedance
* node and C_L sets the dominant pole
.subckt d2s_loadcomp vdd vss vinp vinn vref vout vfb vbp vbn vbpc vbnc vabp vabn wdp=13.32u wdn=7.6u
* --- pair 1 (signal): gain-setting degeneration R1 = 2*R2
XT1a s1a vbp vdd vdd sg13_hv_pmos w=20u l=2u ng=2
XT1b s1b vbp vdd vdd sg13_hv_pmos w=20u l=2u ng=2
XR1 s1a s1b vss rhigh w=0.5u l=39u
XM1a x vinn s1a s1a sg13_hv_pmos w=20u l=1u ng=2
XM1b y vinp s1b s1b sg13_hv_pmos w=20u l=1u ng=2
* --- pair 2 (feedback)
XT2a s2a vbp vdd vdd sg13_hv_pmos w=20u l=2u ng=2
XT2b s2b vbp vdd vdd sg13_hv_pmos w=20u l=2u ng=2
XR2 s2a s2b vss rhigh w=0.5u l=17u
XM2a y vref s2a s2a sg13_hv_pmos w=20u l=1u ng=2
XM2b x vfb s2b s2b sg13_hv_pmos w=20u l=1u ng=2
* --- folded cascode (50 uA sinks: 2 x 20 uA from the pairs + 10 uA branch)
XSX x vbn vss vss sg13_hv_nmos w=25u l=2u ng=2
XSY y vbn vss vss sg13_hv_nmos w=25u l=2u ng=2
XCX l1 vbnc x vss sg13_hv_nmos w=10u l=1u ng=1
XCY b vbnc y vss sg13_hv_nmos w=10u l=1u ng=1
* --- low-voltage cascode mirror (10 uA per branch)
XPL pl l2 vdd vdd sg13_hv_pmos w=10u l=2u ng=1
XPR pr l2 vdd vdd sg13_hv_pmos w=10u l=2u ng=1
XPCL l2 vbpc pl vdd sg13_hv_pmos w=10u l=1u ng=1
XPCR a vbpc pr vdd sg13_hv_pmos w=10u l=1u ng=1
* --- floating current source (left, replica) and floating class-AB control (right)
XFPL l1 vabp l2 vdd sg13_hv_pmos w=6.66u l=0.6u ng=1
XFNL l2 vabn l1 vss sg13_hv_nmos w=4.4u l=1u ng=1
XABP b vabp a vdd sg13_hv_pmos w=6.66u l=0.6u ng=1
XABN a vabn b vss sg13_hv_nmos w=4.4u l=1u ng=1
* --- output devices: one Clamp_P frame (L=0.6, 41 x 2 rows), two Clamp_N frames at L=1.0 (2 x 33)
XOP vout a vdd vdd sg13_hv_pmos w=546.12u l=0.6u ng=82
XON vout b vss vss sg13_hv_nmos w=290.4u l=1u ng=66
* --- low-impedance gate nodes: diode-connected replicas of the output devices (mirror ratio ~ 1/K)
XDP a a vdd vdd sg13_hv_pmos w={wdp} l=0.6u ng=2
XDN b b vss vss sg13_hv_nmos w={wdn} l=1u ng=2
.ends d2s_loadcomp
