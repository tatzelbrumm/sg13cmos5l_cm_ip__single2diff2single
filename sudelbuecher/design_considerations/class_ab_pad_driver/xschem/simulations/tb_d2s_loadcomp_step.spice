** sch_path: /foss/designs/sg13cmos5l_cm_ip__single2diff2single_sudelbuecher/sudelbuecher/design_considerations/class_ab_pad_driver/xschem/tb_d2s_loadcomp_step.sch
**.subckt tb_d2s_loadcomp_step
Vdd vdd GND 3.3
Vcm vref GND 1.65
Xb vdd GND vbp vbn vbpc vbnc vabp vabn d2s_bias
Xd vdd GND vinp vinn vref vout vout vbp vbn vbpc vbnc vabp vabn d2s_loadcomp
Vd dp GND pulse({-vstep} {vstep} 1u 1n 1n 4u 8u)
Ep vinp vref dp GND 0.5
En vinn vref dp GND -0.5
CL vout GND 100p
**** begin user architecture code

.lib cornerMOShv.lib mos_tt
.lib cornerRES.lib res_typ
.lib cornerCAP.lib cap_typ
.param vstep=0.5
.control
tran 2n 9u
meas tran vlo find v(vout) at=0.99u
meas tran vhi find v(vout) at=4.9u
if $?batchmode = 0
  plot v(vout) v(vinp) v(vinn)
end
.endc

**** end user architecture code
**.ends

* expanding   symbol:  d2s_bias.sym # of pins=8
** sym_path: /foss/designs/sg13cmos5l_cm_ip__single2diff2single_sudelbuecher/sudelbuecher/design_considerations/class_ab_pad_driver/xschem/d2s_bias.sym
** sch_path: /foss/designs/sg13cmos5l_cm_ip__single2diff2single_sudelbuecher/sudelbuecher/design_considerations/class_ab_pad_driver/xschem/d2s_bias.sch
.subckt d2s_bias vdd vss vbp vbn vbpc vbnc vabp vabn
*.iopin vdd
*.iopin vss
*.opin vbp
*.opin vbn
*.opin vbpc
*.opin vbnc
*.opin vabp
*.opin vabn
IBP vbp vss 20u
XBP vbp vbp vdd vdd sg13_hv_pmos w=20u l=2u ng=2 m=1 mm_ok=1
IBN vdd vbn 50u
XBN vbn vbn vss vss sg13_hv_nmos w=25u l=2u ng=2 m=1 mm_ok=1
IBNC vdd vbnc 5u
XBNC vbnc vbnc vss vss sg13_hv_nmos w=1u l=4u ng=1 m=1 mm_ok=1
IBPC vbpc vss 5u
XBPC vbpc vbpc vdd vdd sg13_hv_pmos w=2u l=4u ng=1 m=1 mm_ok=1
IABP vabp vss 5u
XRP1 n1 n1 vdd vdd sg13_hv_pmos w=13.32u l=0.6u ng=2 m=1 mm_ok=1
XRP2 vabp vabp n1 vdd sg13_hv_pmos w=6.66u l=0.6u ng=1 m=1 mm_ok=1
IABN vdd vabn 5u
XRN1 n2 n2 vss vss sg13_hv_nmos w=8.8u l=1u ng=2 m=1 mm_ok=1
XRN2 vabn vabn n2 vss sg13_hv_nmos w=4.4u l=1u ng=1 m=1 mm_ok=1
.ends

* expanding   symbol:  d2s_loadcomp.sym # of pins=13
** sym_path: /foss/designs/sg13cmos5l_cm_ip__single2diff2single_sudelbuecher/sudelbuecher/design_considerations/class_ab_pad_driver/xschem/d2s_loadcomp.sym
** sch_path: /foss/designs/sg13cmos5l_cm_ip__single2diff2single_sudelbuecher/sudelbuecher/design_considerations/class_ab_pad_driver/xschem/d2s_loadcomp.sch
.subckt d2s_loadcomp vdd vss vinp vinn vref vout vfb vbp vbn vbpc vbnc vabp vabn
*.iopin vdd
*.iopin vss
*.ipin vinp
*.ipin vinn
*.ipin vref
*.iopin vout
*.ipin vfb
*.ipin vbp
*.ipin vbn
*.ipin vbpc
*.ipin vbnc
*.ipin vabp
*.ipin vabn
XOP vout a vdd vdd sg13_hv_pmos w=546.12u l=0.6u ng=82 m=1 mm_ok=1
XON vout b vss vss sg13_hv_nmos w=290.4u l=1u ng=66 m=1 mm_ok=1
XDP a a vdd vdd sg13_hv_pmos w=13.32u l=0.6u ng=2 m=1 mm_ok=1
XDN b b vss vss sg13_hv_nmos w=7.6u l=1u ng=2 m=1 mm_ok=1
XT1a s1a vbp vdd vdd sg13_hv_pmos w=20u l=2u ng=2 m=1 mm_ok=1
XT1b s1b vbp vdd vdd sg13_hv_pmos w=20u l=2u ng=2 m=1 mm_ok=1
XR1 s1a s1b vss rhigh w=0.5u l=39u m=1 b=0 mm_ok=1
XM1a x vinn s1a s1a sg13_hv_pmos w=20u l=1u ng=2 m=1 mm_ok=1
XM1b y vinp s1b s1b sg13_hv_pmos w=20u l=1u ng=2 m=1 mm_ok=1
XT2a s2a vbp vdd vdd sg13_hv_pmos w=20u l=2u ng=2 m=1 mm_ok=1
XT2b s2b vbp vdd vdd sg13_hv_pmos w=20u l=2u ng=2 m=1 mm_ok=1
XR2 s2a s2b vss rhigh w=0.5u l=17u m=1 b=0 mm_ok=1
XM2a y vref s2a s2a sg13_hv_pmos w=20u l=1u ng=2 m=1 mm_ok=1
XM2b x vfb s2b s2b sg13_hv_pmos w=20u l=1u ng=2 m=1 mm_ok=1
XSX x vbn vss vss sg13_hv_nmos w=25u l=2u ng=2 m=1 mm_ok=1
XSY y vbn vss vss sg13_hv_nmos w=25u l=2u ng=2 m=1 mm_ok=1
XCX l1 vbnc x vss sg13_hv_nmos w=10u l=1u ng=1 m=1 mm_ok=1
XCY b vbnc y vss sg13_hv_nmos w=10u l=1u ng=1 m=1 mm_ok=1
XFPL l1 vabp l2 vdd sg13_hv_pmos w=6.66u l=0.6u ng=1 m=1 mm_ok=1
XFNL l2 vabn l1 vss sg13_hv_nmos w=4.4u l=1u ng=1 m=1 mm_ok=1
XABP b vabp a vdd sg13_hv_pmos w=6.66u l=0.6u ng=1 m=1 mm_ok=1
XABN a vabn b vss sg13_hv_nmos w=4.4u l=1u ng=1 m=1 mm_ok=1
XPL pl l2 vdd vdd sg13_hv_pmos w=10u l=2u ng=1 m=1 mm_ok=1
XPR pr l2 vdd vdd sg13_hv_pmos w=10u l=2u ng=1 m=1 mm_ok=1
XPCL l2 vbpc pl vdd sg13_hv_pmos w=10u l=1u ng=1 m=1 mm_ok=1
XPCR a vbpc pr vdd sg13_hv_pmos w=10u l=1u ng=1 m=1 mm_ok=1
.ends

.GLOBAL GND
.end
