* tb_mpdda_dc: DC transfer of d2s_mpdda, tt 27 C, load 1 kOhm to vref || 100 pF
* SPDX-FileCopyrightText: 2026 Christoph Maier
* SPDX-License-Identifier: Apache-2.0
* Needs the PDK .spiceinit (sourcepath to libs.tech/ngspice/models, OSDI for psp103/r3_cmc/cap_cmomi).
* Run from this directory: ngspice <deck> (interactive: plots) or ngspice -b <deck> (batch: prints)
* Gain and offset here are two-point estimates (vd = -0.2 / 0 / +0.2 V); run_improvements.py
* fits a line over |vd| <= 0.2 V. Reference (results_improvements.txt): gain 0.4999,
* offset 0.05 mV, nonlin 1.24 mV, IqP/IqN 212/212 uA, Idd 296 uA.
.lib cornerMOShv.lib mos_tt
.lib cornerRES.lib res_typ
.lib cornerCAP.lib cap_typ
.include ../units.spice
.include ../ccomp.spice
.include ../d2s_mpdda.spice
.include ../d2s_bias_lp.spice
Vdd vdd 0 3.3
Vcm vref 0 1.65
Xb vdd 0 vbp vbn vbpc vbnc vabp vabn d2s_bias_lp
.param vstep=0.5
* differential stimulus around vref: vinp - vinn = v(dp)
Vd dp 0 0
Ep vinp vref dp 0 0.5
En vinn vref dp 0 -0.5
Xd vdd 0 vinp vinn vref vout vout vbp vbn vbpc vbnc vabp vabn d2s_mpdda
* load (edit)
RL vout vref 1k
CL vout 0 100p
.save v(vout) v(dp) vdd#branch @n.xd.xop.nsg13_hv_pmos[ids] @n.xd.xon.nsg13_hv_nmos[ids]
.control
dc Vd -1 1 0.01
let vo = v(vout) - 1.65
let ip = abs(@n.xd.xop.nsg13_hv_pmos[ids])
let in = abs(@n.xd.xon.nsg13_hv_nmos[ids])
let idd = -i(vdd)
meas dc vop find vo at=0.2
meas dc von find vo at=-0.2
meas dc off find vo at=0
meas dc iqp find ip at=0
meas dc iqn find in at=0
meas dc iddq find idd at=0
let gain = (vop - von)/0.4
let err = vo - gain*v(dp) - off
let nonlin = vecmax(abs(err))
print gain off nonlin iqp iqn iddq
if $?batchmode = 0
  plot vo
  plot err
end
.endc
.end
