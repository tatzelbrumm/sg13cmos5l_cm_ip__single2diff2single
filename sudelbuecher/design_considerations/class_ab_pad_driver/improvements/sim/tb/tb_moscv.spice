* tb_moscv: C-V of a thick-oxide PMOS used as accumulation capacitor (gate vs S/D/well),
* compared with a 31 x 31 um cap_cmomi, 1 MHz
* SPDX-FileCopyrightText: 2026 Christoph Maier
* SPDX-License-Identifier: Apache-2.0
* Needs the PDK .spiceinit (sourcepath to libs.tech/ngspice/models, OSDI for psp103/r3_cmc/cap_cmomi).
* Run from this directory: ngspice <deck> (interactive: plots) or ngspice -b <deck> (batch: prints)
* Reference (results_improvements.txt, 14 x 14 um): 0.370 pF at V_GW = 0.15 V, 0.648 pF at
* 1.0 V, 0.745 pF at 1.25 V; MOM 1.002 pF.
.lib cornerMOShv.lib mos_tt
.lib cornerCAP.lib cap_typ
.param vgw=0.5
Vg g 0 dc {1.65+vgw} ac 1
Vw w 0 1.65
X1 w g w w sg13_hv_pmos w=14u l=14u ng=1
Vg2 g2 0 dc 0 ac 1
XM g2 0 cap_cmomi w=31e-6 l=31e-6
.control
foreach v -1.0 -0.5 0 0.15 0.5 1.0 1.25 1.5 2.0
  alter Vg dc = $v + 1.65
  ac lin 1 1meg 1meg
  let c = -imag(i(Vg))/(2*pi*1e6)
  echo vgw = $v  C = $&c
end
let cm = -imag(i(Vg2))/(2*pi*1e6)
echo MOM 31x31: C = $&cm
.endc
.end
