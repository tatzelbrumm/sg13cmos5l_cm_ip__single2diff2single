* tb_mpdda_step: step response of d2s_mpdda, vd -0.5 -> +0.5 V (vout vref-0.25 -> vref+0.25 V), tt 27 C
* SPDX-FileCopyrightText: 2026 Christoph Maier
* SPDX-License-Identifier: Apache-2.0
* Needs the PDK .spiceinit (sourcepath to libs.tech/ngspice/models, OSDI for psp103/r3_cmc/cap_cmomi).
* Run from this directory: ngspice <deck> (interactive: plots) or ngspice -b <deck> (batch: prints)
* Reference (results_improvements.txt, 1k||100p): overshoot 0.0 %, 1 % settling 327 ns;
* 100p: 4.7 %, 361 ns.
.lib cornerMOShv.lib mos_tt
.lib cornerRES.lib res_typ
.lib cornerCAP.lib cap_typ
.include ../units.spice
.include ../ccomp.spice
.include ../d2s_mpdda.spice
.include ../d2s_bias_lp.spice
Vdd vdd 0 3.3
Vcm vref 0 1.65
Xb vdd 0 vbp vbn vbpc vbnc vabp vabn d2s_bias_lp
.param vstep=0.5
Vd dp 0 pulse({-vstep} {vstep} 1u 1n 1n 4u 8u)
Ep vinp vref dp 0 0.5
En vinn vref dp 0 -0.5
Xd vdd 0 vinp vinn vref vout vout vbp vbn vbpc vbnc vabp vabn d2s_mpdda
* load (edit)
RL vout vref 1k
CL vout 0 100p
.control
tran 2n 9u
meas tran vlo find v(vout) at=0.99u
meas tran vhi find v(vout) at=4.9u
meas tran vmax max v(vout) from=1u to=5u
let os = 100*(vmax - vhi)/(vhi - vlo)
let v10 = vlo + 0.1*(vhi - vlo)
let v90 = vlo + 0.9*(vhi - vlo)
meas tran t10 when v(vout)=v10 rise=1
meas tran t90 when v(vout)=v90 rise=1
let rate = 0.8*(vhi - vlo)/(t90 - t10)
print vlo vhi os rate
if $?batchmode = 0
  plot v(vout) v(vinp) v(vinn)
end
.endc
.end
