** sch_path: /foss/designs/sg13cmos5l_cm_ip__single2diff2single_sudelbuecher/sudelbuecher/design_considerations/class_ab_pad_driver/improvements/xschem/unit_w.sch
**.subckt unit_w x y gp gn vdd vss vbp
*.opin x
*.opin y
*.ipin gp
*.ipin gn
*.iopin vdd
*.iopin vss
*.ipin vbp
XT s vbp vdd vdd sg13_hv_pmos w=20u l=2u ng=2 m=1 mm_ok=1
XMa y vss s gp sg13_hv_pmos w=wwi l=lwi ng=1 m=1 mm_ok=1
XMb x vss s gn sg13_hv_pmos w=wwi l=lwi ng=1 m=1 mm_ok=1
**.ends
.end
