** sch_path: /foss/designs/sg13cmos5l_cm_ip__single2diff2single_sudelbuecher/sudelbuecher/design_considerations/class_ab_pad_driver/improvements/xschem/unit_q.sch
**.subckt unit_q x y gp gn vdd vss vbp
*.opin x
*.opin y
*.ipin gp
*.ipin gn
*.iopin vdd
*.iopin vss
*.ipin vbp
XT s vbp vdd vdd sg13_hv_pmos w=10u l=2u ng=1 m=1 mm_ok=1
XMa y gp s s sg13_hv_pmos w=2u l=6u ng=1 m=1 mm_ok=1
XMb x gn s s sg13_hv_pmos w=2u l=6u ng=1 m=1 mm_ok=1
**.ends
.end
