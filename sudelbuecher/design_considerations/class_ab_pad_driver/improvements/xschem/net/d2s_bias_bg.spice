** sch_path: /foss/designs/sg13cmos5l_cm_ip__single2diff2single_sudelbuecher/sudelbuecher/design_considerations/class_ab_pad_driver/improvements/xschem/d2s_bias_bg.sch
**.subckt d2s_bias_bg vdd vss vddo vsso vbp vbn vbpc vbnc vabp vabn
*.iopin vdd
*.iopin vss
*.iopin vddo
*.iopin vsso
*.opin vbp
*.opin vbn
*.opin vbpc
*.opin vbnc
*.opin vabp
*.opin vabn
XMS1 ks vss vdd vdd sg13_hv_pmos w=0.5u l=100u ng=1 m=1 mm_ok=1
XMS2 ks g vss vss sg13_hv_nmos w=10u l=1u ng=1 m=1 mm_ok=1
XMS3 vpc ks vss vss sg13_hv_nmos w=0.5u l=2u ng=1 m=1 mm_ok=1
XPB vpg vpg vdd vdd sg13_hv_pmos w=40u l=1u ng=4 m=1 mm_ok=1
XPBC vpc vpc vpg vdd sg13_hv_pmos w=40u l=1u ng=4 m=1 mm_ok=1
XNB vpc g eb vss sg13_hv_nmos w=20u l=4u ng=1 m=1 mm_ok=1
XR1B eb vss vss rhigh w=0.5u l=99.36u m=1 b=0 mm_ok=1
XR0 eb e2 vss rhigh w=0.5u l=179.5u m=1 b=0 mm_ok=1
XQ2 vss vss e2 pnpMPA a=4e-12 p=8e-06 m=8
XPA ca vpg vdd vdd sg13_hv_pmos w=40u l=1u ng=4 m=1 mm_ok=1
XPAC g vpc ca vdd sg13_hv_pmos w=40u l=1u ng=4 m=1 mm_ok=1
XNA g g ea vss sg13_hv_nmos w=20u l=4u ng=1 m=1 mm_ok=1
XR1A ea vss vss rhigh w=0.5u l=109.3u m=1 b=0 mm_ok=1
XQ1 vss vss ea pnpMPA a=4e-12 p=8e-06
XPO co vpg vdd vdd sg13_hv_pmos w=80u l=1u ng=8 m=1 mm_ok=1
XPOC iref vpc co vdd sg13_hv_pmos w=80u l=1u ng=8 m=1 mm_ok=1
XNI iref iref vss vss sg13_hv_nmos w=6u l=6u ng=1 m=1 mm_ok=1
XBPC vbpc vbpc vdd vdd sg13_hv_pmos w=1u l=4u ng=1 m=1 mm_ok=1
XNBPC vbpc iref vss vss sg13_hv_nmos w=2.4u l=6u ng=1 m=1 mm_ok=1
XBP vbp vbp vdd vdd sg13_hv_pmos w=5u l=6u ng=1 m=1 mm_ok=1
XNBP vbp iref vss vss sg13_hv_nmos w=6u l=6u ng=1 m=1 mm_ok=1
XRP1 n1 n1 vddo vddo sg13_hv_pmos w=13.32u l=0.6u ng=2 m=1 mm_ok=1
XRP2 vabp vabp n1 vdd sg13_hv_pmos w=6.66u l=0.6u ng=1 m=1 mm_ok=1
XNABP vabp iref vss vss sg13_hv_nmos w=6u l=6u ng=1 m=1 mm_ok=1
XPBNC vbnc vbp vdd vdd sg13_hv_pmos w=2u l=6u ng=1 m=1 mm_ok=1
XBNC vbnc vbnc vss vss sg13_hv_nmos w=1u l=8u ng=1 m=1 mm_ok=1
XPBN vbn vbp vdd vdd sg13_hv_pmos w=5u l=6u ng=1 m=1 mm_ok=1
XBN vbn vbn vss vss sg13_hv_nmos w=6u l=6u ng=1 m=1 mm_ok=1
XPABN vabn vbp vdd vdd sg13_hv_pmos w=5u l=6u ng=1 m=1 mm_ok=1
XRN2 vabn vabn n2 vss sg13_hv_nmos w=4.4u l=1u ng=1 m=1 mm_ok=1
XRN1 n2 n2 vsso vsso sg13_hv_nmos w=8.8u l=1u ng=2 m=1 mm_ok=1
**.ends
.end
