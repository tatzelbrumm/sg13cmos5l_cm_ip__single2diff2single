** sch_path: /foss/designs/sg13cmos5l_cm_ip__single2diff2single_sudelbuecher/sudelbuecher/design_considerations/class_ab_pad_driver/improvements/xschem/tb_moscv.sch
**.subckt tb_moscv
Vg g GND dc {1.65+vgw} ac 1
X1 w g w w sg13_hv_pmos w=14u l=14u ng=1 m=1 mm_ok=1
Vw w GND 1.65
Vg2 g2 GND dc 0 ac 1
XM g2 GND cap_cmomi w=31e-6 l=31e-6 mmin=1 mmax=4 feed=double subblock=0 m=1 mm_ok=1
**** begin user architecture code

.lib cornerMOShv.lib mos_tt
.lib cornerCAP.lib cap_typ
.param vgw=0.5
.control
foreach v -1.0 -0.5 0 0.15 0.5 1.0 1.25 1.5 2.0
  alter Vg dc = $v + 1.65
  ac lin 1 1meg 1meg
  let c = -imag(i(Vg))/(2*pi*1e6)
  echo vgw = $v  C = $&c
end
let cm = -imag(i(Vg2))/(2*pi*1e6)
echo MOM 31x31: C = $&cm
.endc

**** end user architecture code
**.ends
.GLOBAL GND
.end
