** sch_path: /foss/designs/sg13cmos5l_cm_ip__single2diff2single_sudelbuecher/sudelbuecher/design_considerations/class_ab_pad_driver/improvements/xschem/tb_mpdda_step.sch
**.subckt tb_mpdda_step
Vdd vdd GND 3.3
Vcm vref GND 1.65
Xb vdd GND vbp vbn vbpc vbnc vabp vabn d2s_bias_lp
Xd vdd GND vinp vinn vref vout vout vbp vbn vbpc vbnc vabp vabn d2s_mpdda
Vd dp GND pulse({-vstep} {vstep} 1u 1n 1n 4u 8u)
Ep vinp vref dp GND 0.5
En vinn vref dp GND -0.5
RL vout vref 1k
CL vout GND 1000p
**** begin user architecture code

.lib cornerMOShv.lib mos_tt
.lib cornerRES.lib res_typ
.lib cornerCAP.lib cap_typ
.param vstep=0.5
.control
tran 2n 9u
meas tran vlo find v(vout) at=0.99u
meas tran vhi find v(vout) at=4.9u
meas tran vmax max v(vout) from=1u to=5u
let os = 100*(vmax - vhi)/(vhi - vlo)
let v10 = vlo + 0.1*(vhi - vlo)
let v90 = vlo + 0.9*(vhi - vlo)
meas tran t10 when v(vout)=v10 rise=1
meas tran t90 when v(vout)=v90 rise=1
let rate = 0.8*(vhi - vlo)/(t90 - t10)
print vlo vhi os rate
if $?batchmode = 0
  plot v(vout) v(vinp) v(vinn)
end
.endc

**** end user architecture code
**.ends

* expanding   symbol:  d2s_bias_lp.sym # of pins=8
** sym_path: /foss/designs/sg13cmos5l_cm_ip__single2diff2single_sudelbuecher/sudelbuecher/design_considerations/class_ab_pad_driver/improvements/xschem/d2s_bias_lp.sym
** sch_path: /foss/designs/sg13cmos5l_cm_ip__single2diff2single_sudelbuecher/sudelbuecher/design_considerations/class_ab_pad_driver/improvements/xschem/d2s_bias_lp.sch
.subckt d2s_bias_lp vdd vss vbp vbn vbpc vbnc vabp vabn
*.iopin vdd
*.iopin vss
*.opin vbp
*.opin vbn
*.opin vbpc
*.opin vbnc
*.opin vabp
*.opin vabn
XBP vbp vbp vdd vdd sg13_hv_pmos w=5u l=6u ng=1 m=1 mm_ok=1
IBP vbp vss 5u
XBPC vbpc vbpc vdd vdd sg13_hv_pmos w=1u l=4u ng=1 m=1 mm_ok=1
IBPC vbpc vss 2u
XRP1 n1 n1 vdd vdd sg13_hv_pmos w=13.32u l=0.6u ng=2 m=1 mm_ok=1
XRP2 vabp vabp n1 vdd sg13_hv_pmos w=6.66u l=0.6u ng=1 m=1 mm_ok=1
IABP vabp vss 5u
IBN vdd vbn 5u
XBN vbn vbn vss vss sg13_hv_nmos w=6u l=6u ng=1 m=1 mm_ok=1
IBNC vdd vbnc 2u
XBNC vbnc vbnc vss vss sg13_hv_nmos w=1u l=8u ng=1 m=1 mm_ok=1
IABN vdd vabn 5u
XRN2 vabn vabn n2 vss sg13_hv_nmos w=4.4u l=1u ng=1 m=1 mm_ok=1
XRN1 n2 n2 vss vss sg13_hv_nmos w=8.8u l=1u ng=2 m=1 mm_ok=1
.ends

* expanding   symbol:  d2s_mpdda.sym # of pins=13
** sym_path: /foss/designs/sg13cmos5l_cm_ip__single2diff2single_sudelbuecher/sudelbuecher/design_considerations/class_ab_pad_driver/improvements/xschem/d2s_mpdda.sym
** sch_path: /foss/designs/sg13cmos5l_cm_ip__single2diff2single_sudelbuecher/sudelbuecher/design_considerations/class_ab_pad_driver/improvements/xschem/d2s_mpdda.sch
.subckt d2s_mpdda vdd vss vinp vinn vref vout vfb vbp vbn vbpc vbnc vabp vabn
*.iopin vdd
*.iopin vss
*.ipin vinp
*.ipin vinn
*.ipin vref
*.iopin vout
*.ipin vfb
*.ipin vbp
*.ipin vbn
*.ipin vbpc
*.ipin vbnc
*.ipin vabp
*.ipin vabn
XA x y vinp vref vdd vss vbp unit_r2
XB x y vref vinn vdd vss vbp unit_r2
XC1 x y vref vfb vdd vss vbp unit_r2
XC2 x y vref vfb vdd vss vbp unit_r2
XFNL l2 vabn l1 vss sg13_hv_nmos w=4.4u l=1u ng=1 m=1 mm_ok=1
XCX l1 vbnc x vss sg13_hv_nmos w=30u l=3u ng=2 m=1 mm_ok=1
XSX x vbn vss vss sg13_hv_nmos w=36u l=6u ng=4 m=1 mm_ok=1
XPL pl l2 vdd vdd sg13_hv_pmos w=24u l=4u ng=4 m=1 mm_ok=1
XPCL l2 vbpc pl vdd sg13_hv_pmos w=30u l=3u ng=2 m=1 mm_ok=1
XFPL l1 vabp l2 vdd sg13_hv_pmos w=6.66u l=0.6u ng=1 m=1 mm_ok=1
XPR pr l2 vdd vdd sg13_hv_pmos w=24u l=4u ng=4 m=1 mm_ok=1
XPCR a vbpc pr vdd sg13_hv_pmos w=30u l=3u ng=2 m=1 mm_ok=1
XABP b vabp a vdd sg13_hv_pmos w=6.66u l=0.6u ng=1 m=1 mm_ok=1
XABN a vabn b vss sg13_hv_nmos w=4.4u l=1u ng=1 m=1 mm_ok=1
XCY b vbnc y vss sg13_hv_nmos w=30u l=3u ng=2 m=1 mm_ok=1
XSY y vbn vss vss sg13_hv_nmos w=36u l=6u ng=4 m=1 mm_ok=1
XOP vout a vdd vdd sg13_hv_pmos w=546.12u l=0.6u ng=82 m=1 mm_ok=1
XON vout b vss vss sg13_hv_nmos w=290.4u l=1u ng=66 m=1 mm_ok=1
XCMA vout a vout vout sg13_hv_pmos w=16u l=16u ng=1 m=1 mm_ok=1
XCMB b vout b b sg13_hv_pmos w=16u l=16u ng=1 m=1 mm_ok=1
.ends

* expanding   symbol:  unit_r2.sym # of pins=7
** sym_path: /foss/designs/sg13cmos5l_cm_ip__single2diff2single_sudelbuecher/sudelbuecher/design_considerations/class_ab_pad_driver/improvements/xschem/unit_r2.sym
** sch_path: /foss/designs/sg13cmos5l_cm_ip__single2diff2single_sudelbuecher/sudelbuecher/design_considerations/class_ab_pad_driver/improvements/xschem/unit_r2.sch
.subckt unit_r2 x y gp gn vdd vss vbp
*.opin x
*.opin y
*.ipin gp
*.ipin gn
*.iopin vdd
*.iopin vss
*.ipin vbp
XTa sa vbp vdd vdd sg13_hv_pmos w=5u l=6u ng=1 m=1 mm_ok=1
XTb sb vbp vdd vdd sg13_hv_pmos w=5u l=6u ng=1 m=1 mm_ok=1
XMa y gp sa sa sg13_hv_pmos w=20u l=1u ng=2 m=1 mm_ok=1
XMb x gn sb sb sg13_hv_pmos w=20u l=1u ng=2 m=1 mm_ok=1
XR sa sb vss rhigh w=0.5u l=50.6u m=1 b=0 mm_ok=1
.ends

.GLOBAL GND
.end
