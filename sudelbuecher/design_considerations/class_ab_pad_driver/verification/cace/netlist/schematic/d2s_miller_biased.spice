** sch_path: /foss/designs/sg13cmos5l_cm_ip__single2diff2single_sudelbuecher/sudelbuecher/design_considerations/class_ab_pad_driver/xschem/d2s_miller_biased.sch
.subckt d2s_miller_biased vdd vss vinp vinn vref vout vfb vbp vbn vbpc vbnc vabp vabn
*.PININFO vdd:B vss:B vinp:I vinn:I vref:I vout:B vfb:I vbp:B vbn:B vbpc:B vbnc:B vabp:B vabn:B
xd vdd vss vinp vinn vref vout vfb vbp vbn vbpc vbnc vabp vabn d2s_miller
xb vdd vss vbp vbn vbpc vbnc vabp vabn d2s_bias
.ends

* expanding   symbol:  d2s_miller.sym # of pins=13
** sym_path: /foss/designs/sg13cmos5l_cm_ip__single2diff2single_sudelbuecher/sudelbuecher/design_considerations/class_ab_pad_driver/xschem/d2s_miller.sym
** sch_path: /foss/designs/sg13cmos5l_cm_ip__single2diff2single_sudelbuecher/sudelbuecher/design_considerations/class_ab_pad_driver/xschem/d2s_miller.sch
.subckt d2s_miller vdd vss vinp vinn vref vout vfb vbp vbn vbpc vbnc vabp vabn
*.PININFO vdd:B vss:B vinp:I vinn:I vref:I vout:B vfb:I vbp:I vbn:I vbpc:I vbnc:I vabp:I vabn:I
XT1a s1a vbp vdd vdd sg13_hv_pmos w=20u l=2u ng=2 m=1 mm_ok=1
XT1b s1b vbp vdd vdd sg13_hv_pmos w=20u l=2u ng=2 m=1 mm_ok=1
XR1 s1a s1b vss rhigh w=0.5u l=39u m=1 b=0 mm_ok=1
XM1a x vinn s1a s1a sg13_hv_pmos w=20u l=1u ng=2 m=1 mm_ok=1
XM1b y vinp s1b s1b sg13_hv_pmos w=20u l=1u ng=2 m=1 mm_ok=1
XT2a s2a vbp vdd vdd sg13_hv_pmos w=20u l=2u ng=2 m=1 mm_ok=1
XT2b s2b vbp vdd vdd sg13_hv_pmos w=20u l=2u ng=2 m=1 mm_ok=1
XR2 s2a s2b vss rhigh w=0.5u l=17u m=1 b=0 mm_ok=1
XM2a y vref s2a s2a sg13_hv_pmos w=20u l=1u ng=2 m=1 mm_ok=1
XM2b x vfb s2b s2b sg13_hv_pmos w=20u l=1u ng=2 m=1 mm_ok=1
XSX x vbn vss vss sg13_hv_nmos w=25u l=2u ng=2 m=1 mm_ok=1
XSY y vbn vss vss sg13_hv_nmos w=25u l=2u ng=2 m=1 mm_ok=1
XCX l1 vbnc x vss sg13_hv_nmos w=10u l=1u ng=1 m=1 mm_ok=1
XCY b vbnc y vss sg13_hv_nmos w=10u l=1u ng=1 m=1 mm_ok=1
XFPL l1 vabp l2 vdd sg13_hv_pmos w=6.66u l=0.6u ng=1 m=1 mm_ok=1
XFNL l2 vabn l1 vss sg13_hv_nmos w=4.4u l=1u ng=1 m=1 mm_ok=1
XABP b vabp a vdd sg13_hv_pmos w=6.66u l=0.6u ng=1 m=1 mm_ok=1
XABN a vabn b vss sg13_hv_nmos w=4.4u l=1u ng=1 m=1 mm_ok=1
XOP vout a vdd vdd sg13_hv_pmos w=546.12u l=0.6u ng=82 m=1 mm_ok=1
XON vout b vss vss sg13_hv_nmos w=290.4u l=1u ng=66 m=1 mm_ok=1
XCMA vout a cap_cmomi w=31e-6 l=31e-6 mmin=1 mmax=4 feed=double subblock=0 m=1 mm_ok=1
XCMB vout b cap_cmomi w=31e-6 l=31e-6 mmin=1 mmax=4 feed=double subblock=0 m=1 mm_ok=1
XPL pl l2 vdd vdd sg13_hv_pmos w=10u l=2u ng=1 m=1 mm_ok=1
XPR pr l2 vdd vdd sg13_hv_pmos w=10u l=2u ng=1 m=1 mm_ok=1
XPCL l2 vbpc pl vdd sg13_hv_pmos w=10u l=1u ng=1 m=1 mm_ok=1
XPCR a vbpc pr vdd sg13_hv_pmos w=10u l=1u ng=1 m=1 mm_ok=1
.ends

* expanding   symbol:  d2s_bias.sym # of pins=8
** sym_path: /foss/designs/sg13cmos5l_cm_ip__single2diff2single_sudelbuecher/sudelbuecher/design_considerations/class_ab_pad_driver/xschem/d2s_bias.sym
** sch_path: /foss/designs/sg13cmos5l_cm_ip__single2diff2single_sudelbuecher/sudelbuecher/design_considerations/class_ab_pad_driver/xschem/d2s_bias.sch
.subckt d2s_bias vdd vss vbp vbn vbpc vbnc vabp vabn
*.PININFO vdd:B vss:B vbp:O vbn:O vbpc:O vbnc:O vabp:O vabn:O
IBP vbp vss 20u
XBP vbp vbp vdd vdd sg13_hv_pmos w=20u l=2u ng=2 m=1 mm_ok=1
IBN vdd vbn 50u
XBN vbn vbn vss vss sg13_hv_nmos w=25u l=2u ng=2 m=1 mm_ok=1
IBNC vdd vbnc 5u
XBNC vbnc vbnc vss vss sg13_hv_nmos w=1u l=4u ng=1 m=1 mm_ok=1
IBPC vbpc vss 5u
XBPC vbpc vbpc vdd vdd sg13_hv_pmos w=2u l=4u ng=1 m=1 mm_ok=1
IABP vabp vss 5u
XRP1 n1 n1 vdd vdd sg13_hv_pmos w=13.32u l=0.6u ng=2 m=1 mm_ok=1
XRP2 vabp vabp n1 vdd sg13_hv_pmos w=6.66u l=0.6u ng=1 m=1 mm_ok=1
IABN vdd vabn 5u
XRN1 n2 n2 vss vss sg13_hv_nmos w=8.8u l=1u ng=2 m=1 mm_ok=1
XRN2 vabn vabn n2 vss sg13_hv_nmos w=4.4u l=1u ng=1 m=1 mm_ok=1
.ends
