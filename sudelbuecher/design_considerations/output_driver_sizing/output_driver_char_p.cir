* SPDX-FileCopyrightText: 2026 Christoph Maier
* SPDX-License-Identifier: Apache-2.0
* Interactive bench: one full sg13_hv_pmos clamp frame (ng=41 x 2 rows = 82 fingers, 6.66 um fingers, W=546.12 um, L=0.6 um)
* Same circuit that output_driver_char.py writes to tb.cir; no .control block, so ngspice stays at its prompt.
*
* Start (IIC-OSIC-TOOLS, after `source .designinit`):   ngspice output_driver_char_p.cir
*
* Magnitudes as in the script: Vd = |Vds|, Vg = |Vgs|. The PMOS source sits at VDD; the two VCVS
* map the positive sweep values to the real nodes, dd = VDD - Vd and gg = VDD - Vg.
*   full_drive / fingers_for:   alter Vg = 3.3    (or 2.0 2.5 3.0)
*                               dc Vd 0 3.3 0.01
*   small_signal / idle current: alter Vd = 1.65   (or 0.5 2.8)
*                               dc Vg 0.2 3.3 0.005
*   then e.g.                   plot abs(@n.x1.nsg13_hv_pmos[ids])
*                               plot abs(@n.x1.nsg13_hv_pmos[gm]) abs(@n.x1.nsg13_hv_pmos[gds])
*                               plot abs(@n.x1.nsg13_hv_pmos[cgg]) abs(@n.x1.nsg13_hv_pmos[cgdol]) abs(@n.x1.nsg13_hv_pmos[cjd])
* Corner: edit the .lib line (mos_tt / mos_ss / mos_ff).  Temperature: option temp=125, then rerun the dc.
* Length comparison: change L and nf (two rows: nf = 2*int(63.4/(L+0.91))) and `source` again.

.lib cornerMOShv.lib mos_tt
.temp 27
.param VDD=3.3 L=0.6u nf=82 wf=6.66u

Vd d 0 0
Vg g 0 3.3
Vs s 0 {VDD}
Ed s dd d 0 1
Eg s gg g 0 1
X1 dd gg s s sg13_hv_pmos w={wf*nf} l={L} ng={nf}

.save all @n.x1.nsg13_hv_pmos[ids] @n.x1.nsg13_hv_pmos[gm] @n.x1.nsg13_hv_pmos[gds] @n.x1.nsg13_hv_pmos[cgg] @n.x1.nsg13_hv_pmos[cgdol] @n.x1.nsg13_hv_pmos[cjd]
.end
