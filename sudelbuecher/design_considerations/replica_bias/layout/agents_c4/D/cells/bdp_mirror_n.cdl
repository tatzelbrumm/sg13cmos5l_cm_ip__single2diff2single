* SPDX-FileCopyrightText: 2026 Christoph Maier
* SPDX-License-Identifier: Apache-2.0
* bdp_mirror_n (Claude, agent D, C4 2026-11-07). hv devices 1u/0.45u; every device as drawn.

.SUBCKT bdp_mirror_n ni vpd vss
MDN0 vss ni vss vss sg13_hv_nmos w=2u l=6u ng=1 m=1
MNI_1 ni ni vss vss sg13_hv_nmos w=6u l=6u ng=1 m=1
MNM_2 vpd ni vss vss sg13_hv_nmos w=6u l=6u ng=1 m=1
MDN3 vss ni vss vss sg13_hv_nmos w=2u l=6u ng=1 m=1
.ENDS bdp_mirror_n
