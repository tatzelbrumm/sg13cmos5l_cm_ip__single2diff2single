* SPDX-FileCopyrightText: 2026 Christoph Maier
* SPDX-License-Identifier: Apache-2.0
* rb_caps.cdl: reference netlists of rb_caps.gds (capgen.py, Claude, agent F, C4).

.SUBCKT capr vref vss
MCBR_0 vss vref vss vss sg13_hv_nmos w=34.1u l=16.9u ng=1 m=1
MCBR_1 vss vref vss vss sg13_hv_nmos w=34.1u l=16.9u ng=1 m=1
.ENDS capr

.SUBCKT capm vcm vss
MCBM_0 vss vcm vss vss sg13_hv_nmos w=8.18u l=3.25u ng=1 m=1
MCBM_1 vss vcm vss vss sg13_hv_nmos w=8.18u l=3.25u ng=1 m=1
.ENDS capm

.SUBCKT capt vcm vss
MCBM_0 vss vcm vss vss sg13_hv_nmos w=2.9u l=12.4u ng=1 m=1
.ENDS capt

.SUBCKT capv vcm vss
MCBM_0 vss vcm vss vss sg13_hv_nmos w=19.24u l=12.66u ng=1 m=1
MCBM_1 vss vcm vss vss sg13_hv_nmos w=19.24u l=12.66u ng=1 m=1
.ENDS capv
