* bypass_rb as drawn in pad_ref_rb v2 (bypass_spice.py, Claude, agent F, C4); gate area: vcm 576.3 um2 (+ CB 144 in vcm_rb), vref 1296.6 um2
.subckt bypass_rb vss vcm vref ncm=4 ncr=9
XCBR_cload vss vref vss vss sg13_hv_nmos w=12u l=12u ng=1 m=1
XCBR_capr vss vref vss vss sg13_hv_nmos w=34.1u l=16.9u ng=1 m=2
XCBM_capm vss vcm vss vss sg13_hv_nmos w=8.18u l=3.25u ng=1 m=2
XCBM_capt vss vcm vss vss sg13_hv_nmos w=2.9u l=12.4u ng=1 m=1
XCBM_capv vss vcm vss vss sg13_hv_nmos w=19.24u l=12.66u ng=1 m=2
.ends bypass_rb
