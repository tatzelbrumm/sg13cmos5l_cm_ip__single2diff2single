* LVS form of bg_core_pd_subckt.spice (written by backannotate.py)
.SUBCKT bg_core_pd vdd vss iout en_3v3 en_3v3_b
RR1B_0 eb r1b_1 19.88
RR1B_1 r1b_1 r1b_2 19.88
RR1B_2 r1b_2 r1b_3 19.88
RR1B_3 r1b_3 r1b_4 19.88
RR1B_4 r1b_4 r1b_5 19.88
RR1B_5 r1b_5 r1b_6 19.88
RR1B_6 r1b_6 r1b_7 19.88
RR1B_7 r1b_7 r1b_8 19.88
RR1B_8 r1b_8 r1b_9 19.88
RR1B_9 r1b_9 vss 19.88
RR0_0 eb r0_1 19.88
RR0_1 r0_1 r0_2 19.88
RR0_2 r0_2 r0_3 19.88
RR0_3 r0_3 r0_4 19.88
RR0_4 r0_4 r0_5 19.88
RR0_5 r0_5 r0_6 19.88
RR0_6 r0_6 r0_7 19.88
RR0_7 r0_7 r0_8 19.88
RR0_8 r0_8 r0_9 19.88
RR0_9 r0_9 r0_10 19.88
RR0_10 r0_10 r0_11 19.88
RR0_11 r0_11 r0_12 19.88
RR0_12 r0_12 r0_13 19.88
RR0_13 r0_13 r0_14 19.88
RR0_14 r0_14 r0_15 19.88
RR0_15 r0_15 r0_16 19.88
RR0_16 r0_16 r0_17 19.88
RR0_17 r0_17 e2 19.88
QQ2_0 vss vss e2 pnpMPA AE=4e-12 PE=8e-06
QQ2_1 vss vss e2 pnpMPA AE=4e-12 PE=8e-06
QQ2_2 vss vss e2 pnpMPA AE=4e-12 PE=8e-06
QQ2_3 vss vss e2 pnpMPA AE=4e-12 PE=8e-06
QQ2_4 vss vss e2 pnpMPA AE=4e-12 PE=8e-06
QQ2_5 vss vss e2 pnpMPA AE=4e-12 PE=8e-06
QQ2_6 vss vss e2 pnpMPA AE=4e-12 PE=8e-06
QQ2_7 vss vss e2 pnpMPA AE=4e-12 PE=8e-06
RR1A_0 ea r1a_1 19.88
RR1A_1 r1a_1 r1a_2 19.88
RR1A_2 r1a_2 r1a_3 19.88
RR1A_3 r1a_3 r1a_4 19.88
RR1A_4 r1a_4 r1a_5 19.88
RR1A_5 r1a_5 r1a_6 19.88
RR1A_6 r1a_6 r1a_7 19.88
RR1A_7 r1a_7 r1a_8 19.88
RR1A_8 r1a_8 r1a_9 19.88
RR1A_9 r1a_9 r1a_10 19.88
RR1A_10 r1a_10 vss 19.88
QQ1_0 vss vss ea pnpMPA AE=4e-12 PE=8e-06
RRDUM0_0 vss vss 19.88
RRDUM0_1 vss vss 19.88
MMS1_0 ms1_1 en_3v3_b vdd vdd sg13_hv_pmos  W=0.5u L=12.5u
MMS1_1 ms1_2 en_3v3_b ms1_1 vdd sg13_hv_pmos  W=0.5u L=12.5u
MMS1_2 ms1_3 en_3v3_b ms1_2 vdd sg13_hv_pmos  W=0.5u L=12.5u
MMS1_3 ms1_4 en_3v3_b ms1_3 vdd sg13_hv_pmos  W=0.5u L=12.5u
MMS1_4 ms1_5 en_3v3_b ms1_4 vdd sg13_hv_pmos  W=0.5u L=12.5u
MMS1_5 ms1_6 en_3v3_b ms1_5 vdd sg13_hv_pmos  W=0.5u L=12.5u
MMS1_6 ms1_7 en_3v3_b ms1_6 vdd sg13_hv_pmos  W=0.5u L=12.5u
MMS1_7 ks en_3v3_b ms1_7 vdd sg13_hv_pmos  W=0.5u L=12.5u
MMS2 ks g vss vss sg13_hv_nmos  W=10u L=1u
MMS3 vpc ks vss vss sg13_hv_nmos  W=0.5u L=2u
MPB vpg vpg vdd vdd sg13_hv_pmos  W=40u L=1u
MPBC vpc vpc vpg vdd sg13_hv_pmos  W=40u L=1u
MNB vpc g eb vss sg13_hv_nmos  W=20u L=4u
MPA ca vpg vdd vdd sg13_hv_pmos  W=40u L=1u
MPAC g vpc ca vdd sg13_hv_pmos  W=40u L=1u
MNA g g ea vss sg13_hv_nmos  W=20u L=4u
MPO co vpg vdd vdd sg13_hv_pmos  W=80u L=1u
MPOC iout vpc co vdd sg13_hv_pmos  W=80u L=1u
MSKS ks en_3v3_b vss vss sg13_hv_nmos  W=1u L=0.45u
MSVPG vpg en_3v3 vdd vdd sg13_hv_pmos  W=1u L=0.45u
MMDUM0 vdd vpg vdd vdd sg13_hv_pmos  W=2.4u L=1u
MMDUM1 vdd vpc vdd vdd sg13_hv_pmos  W=2.4u L=1u
MMDUM2 g g g vss sg13_hv_nmos  W=2u L=1u
MMDUM3 g g g vss sg13_hv_nmos  W=16u L=4u
.ENDS bg_core_pd
