* PEX produced on Wed Nov  4 16:58:10 UTC 2026 using /usr/local/bin/sak-pex.sh with m=2 and s=1
* NGSPICE file created from s2d_inputs_c3.ext - technology: ihp-sg13cmos5l

.subckt s2d_inputs_c3 sb_A2 sa_F1 sa_F2 sb_A1 sb_M1 sa_M2 sa_A1 sb_F2 sb_F1 sa_A2
+ sa_M1 sb_M2 vref vfbn vcm vdd vfbp vin y x yc xc
X0 xc vcm sb_M2 sb_M2 sg13_hv_pmos ad=1.9p pd=10.38u as=3.4p ps=20.68u w=10u l=1u
X1 sa_M2 vfbn yc sa_M2 sg13_hv_pmos ad=3.4p pd=20.68u as=1.9p ps=10.38u w=10u l=1u
X2 yc vfbn sa_M2 sa_M2 sg13_hv_pmos ad=1.9p pd=10.38u as=3.4p ps=20.68u w=10u l=1u
X3 yc vfbp sa_M1 sa_M1 sg13_hv_pmos ad=1.9p pd=10.38u as=3.4p ps=20.68u w=10u l=1u
X4 x vfbp sb_F1 sb_F1 sg13_hv_pmos ad=1.9p pd=10.38u as=3.4p ps=20.68u w=10u l=1u
X5 sb_F2 vcm x sb_F2 sg13_hv_pmos ad=3.4p pd=20.68u as=1.9p ps=10.38u w=10u l=1u
X6 vdd vdd vdd vdd sg13_hv_pmos ad=3.4p pd=20.68u as=47.54399p ps=0.3048m w=10u l=1u
X7 y vin sa_A2 sa_A2 sg13_hv_pmos ad=1.9p pd=10.38u as=3.4p ps=20.68u w=10u l=1u
X8 sa_A1 vin y sa_A1 sg13_hv_pmos ad=3.4p pd=20.68u as=1.9p ps=10.38u w=10u l=1u
X9 sb_F1 vfbp x sb_F1 sg13_hv_pmos ad=3.4p pd=20.68u as=1.9p ps=10.38u w=10u l=1u
X10 sb_M1 vcm xc sb_M1 sg13_hv_pmos ad=3.4p pd=20.68u as=1.9p ps=10.38u w=10u l=1u
X11 y vfbn sa_F2 sa_F2 sg13_hv_pmos ad=1.9p pd=10.38u as=3.4p ps=20.68u w=10u l=1u
X12 vdd vdd vdd vdd sg13_hv_pmos ad=1.9p pd=10.38u as=0 ps=0 w=10u l=1u
X13 sa_F1 vcm y sa_F1 sg13_hv_pmos ad=3.4p pd=20.68u as=1.9p ps=10.38u w=10u l=1u
X14 xc vcm sb_M1 sb_M1 sg13_hv_pmos ad=1.9p pd=10.38u as=3.4p ps=20.68u w=10u l=1u
X15 y vcm sa_F1 sa_F1 sg13_hv_pmos ad=1.9p pd=10.38u as=3.4p ps=20.68u w=10u l=1u
X16 x vcm sb_F2 sb_F2 sg13_hv_pmos ad=1.9p pd=10.38u as=3.4p ps=20.68u w=10u l=1u
X17 sb_M2 vcm xc sb_M2 sg13_hv_pmos ad=3.4p pd=20.68u as=1.9p ps=10.38u w=10u l=1u
X18 sb_A1 vref x sb_A1 sg13_hv_pmos ad=3.4p pd=20.68u as=1.9p ps=10.38u w=10u l=1u
X19 vdd vdd vdd vdd sg13_hv_pmos ad=3.4p pd=20.68u as=0 ps=0 w=10u l=1u
X20 y vin sa_A1 sa_A1 sg13_hv_pmos ad=1.9p pd=10.38u as=3.4p ps=20.68u w=10u l=1u
X21 vdd vdd vdd vdd sg13_hv_pmos ad=1.9p pd=10.38u as=0 ps=0 w=10u l=1u
X22 sa_M1 vfbp yc sa_M1 sg13_hv_pmos ad=3.4p pd=20.68u as=1.9p ps=10.38u w=10u l=1u
X23 vdd vdd vdd vdd sg13_hv_pmos ad=3.4p pd=20.68u as=0 ps=0 w=10u l=1u
X24 vdd vdd vdd vdd sg13_hv_pmos ad=1.9p pd=10.38u as=0 ps=0 w=10u l=1u
X25 sb_A2 vref x sb_A2 sg13_hv_pmos ad=3.4p pd=20.68u as=1.9p ps=10.38u w=10u l=1u
X26 x vref sb_A1 sb_A1 sg13_hv_pmos ad=1.9p pd=10.38u as=3.4p ps=20.68u w=10u l=1u
X27 sa_F2 vfbn y sa_F2 sg13_hv_pmos ad=3.4p pd=20.68u as=1.9p ps=10.38u w=10u l=1u
X28 vdd vdd vdd vdd sg13_hv_pmos ad=3.4p pd=20.68u as=0 ps=0 w=10u l=1u
X29 x vref sb_A2 sb_A2 sg13_hv_pmos ad=1.9p pd=10.38u as=3.4p ps=20.68u w=10u l=1u
X30 vdd vdd vdd vdd sg13_hv_pmos ad=1.9p pd=10.38u as=0 ps=0 w=10u l=1u
X31 sa_A2 vin y sa_A2 sg13_hv_pmos ad=3.4p pd=20.68u as=1.9p ps=10.38u w=10u l=1u
C0 vfbn vfbp 0.0651f
C1 y vref 0.05211f
C2 vcm vfbp 0.19333f
C3 sb_A1 x 1.02824f
C4 vcm vin 0.28017f
C5 sb_M2 vcm 2.76526f
C6 x sa_F1 0.07665f
C7 y sa_F2 1.19896f
C8 vfbn xc 0.01316f
C9 sb_F2 sa_A1 0.14088f
C10 sb_M1 xc 1.02824f
C11 xc vcm 1.25516f
C12 y vfbp 0.01523f
C13 sb_F2 vin 0.07327f
C14 x vdd 0.4596f
C15 y sa_A2 1.02824f
C16 vfbp sb_F1 2.76903f
C17 sa_A2 sb_F1 0.14088f
C18 y sa_A1 1.05706f
C19 y vin 1.29543f
C20 sb_F1 vin 0.07336f
C21 vdd sa_M2 0.14219f
C22 sa_F2 vref 0.07434f
C23 yc vdd 3.3524f
C24 yc sa_M1 1.02824f
C25 vref vin 0.09945f
C26 yc sa_M2 1.19973f
C27 sb_M1 sb_A1 0.14088f
C28 vcm sa_F1 2.76691f
C29 xc vref 0.03603f
C30 sa_F1 sb_A2 0.14088f
C31 vfbn x 0.01379f
C32 vfbn vdd 0.25058f
C33 x vcm 0.63415f
C34 vdd vcm 5.68679f
C35 y sb_A1 0.19349f
C36 vfbp vin 5.6494f
C37 x sb_A2 1.05629f
C38 vfbn sa_M2 2.7697f
C39 sa_A2 vin 2.83188f
C40 vdd sb_A2 0.14253f
C41 y sa_F1 1.19896f
C42 sb_M1 sa_M2 0.14088f
C43 sa_A1 vin 2.83188f
C44 x sb_F2 1.19896f
C45 sb_M2 vin 0.07142f
C46 vfbn yc 0.63438f
C47 xc vfbp 0.01254f
C48 yc sb_M1 0.19349f
C49 yc vcm 0.01484f
C50 y x 9.6002f
C51 x sb_F1 1.19896f
C52 y vdd 3.35285f
C53 xc vin 0.03565f
C54 xc sb_M2 1.19896f
C55 sb_A1 vref 2.83221f
C56 sa_F1 vref 0.07439f
C57 sb_A1 sa_F2 0.14088f
C58 x vref 1.29471f
C59 vfbn vcm 5.56257f
C60 vdd vref 0.49226f
C61 sa_F2 sa_F1 0.14088f
C62 sb_M1 vcm 2.7655f
C63 vref sa_M2 0.07255f
C64 x sa_F2 0.07665f
C65 vcm sb_F2 2.7665f
C66 yc vref 0.03751f
C67 vfbn y 0.63502f
C68 x vfbp 0.63349f
C69 x sa_A2 0.19349f
C70 vdd vfbp 5.58949f
C71 y vcm 0.63563f
C72 x sa_A1 0.30211f
C73 vdd sa_A1 0.1427f
C74 x vin 0.04987f
C75 sa_M1 vfbp 2.76903f
C76 y sb_A2 0.30288f
C77 vdd vin 0.50268f
C78 sb_M2 vdd 0.14253f
C79 sa_M1 sa_A2 0.14088f
C80 y sb_F2 0.07665f
C81 sa_M1 vin 0.07327f
C82 sb_F1 sb_F2 0.14088f
C83 sa_M1 sb_M2 0.14088f
C84 yc vfbp 0.63608f
C85 vfbn vref 5.6439f
C86 xc vdd 0.45915f
C87 sb_M1 vref 0.07439f
C88 y sb_F1 0.07665f
C89 vcm vref 0.29133f
C90 yc vin 0.03713f
C91 sa_M1 xc 0.19349f
C92 yc sb_M2 0.07789f
C93 xc sa_M2 0.07712f
C94 sb_A2 vref 2.83221f
C95 vfbn sa_F2 2.7697f
C96 yc xc 6.74405f
C97 xc sub 2.93566f
C98 yc sub 1.68759f
C99 x sub 3.57677f
C100 y sub 2.32629f
C101 sa_M2 sub 0.34565f
C102 sb_A1 sub 0.58048f
C103 sb_M2 sub 0.69627f
C104 sa_M1 sub 0.35767f
C105 sa_A2 sub 0.58512f
.ends
