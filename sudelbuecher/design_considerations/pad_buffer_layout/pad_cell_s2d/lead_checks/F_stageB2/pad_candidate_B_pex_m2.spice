* PEX produced on Wed Nov  4 16:57:43 UTC 2026 using /usr/local/bin/sak-pex.sh with m=2 and s=1
* NGSPICE file created from sg13cmos5l_IOPadSingle2Diff.ext - technology: ihp-sg13cmos5l

.subckt sg13cmos5l_IOPadSingle2Diff vdd iovss pad iovdd vref outp outn vcm en_3v3
+ en_3v3_b iref
X0 iovdd s2d_block_0.s2d_tails_hi_f_0.vbp iovdd iovdd sg13_hv_pmos ad=1.7p pd=10.68u as=0.65668n ps=2.66101m w=5u l=6u
X1 iovss iovss iovss rhigh l=12.65u w=0.5u
X2 s2d_block_0.s2d_loads_f_0.ln s2d_block_0.s2d_loads_f_0.vcmfb iovdd iovdd sg13_hv_pmos ad=2.04p pd=12.68u as=2.04p ps=12.68u w=6u l=4u
X3 s2d_block_0.s2d_loads_f_0.ln s2d_block_0.s2d_casc_p_f_0.vbpc outn iovdd sg13_hv_pmos ad=5.1p pd=30.68u as=5.1p ps=30.68u w=15u l=3u
X4 s2d_block_0.s2d_tails_hi_f_0.sa_A2 a_14374_25646# iovss rhigh l=12.65u w=0.5u
X5 s2d_block_0.s2d_casc_n_f_0.xc s2d_block_0.sinks_6x6_s2d_c3_core_0.vbn iovss iovss sg13_hv_nmos ad=2.04p pd=12.68u as=2.04p ps=12.68u w=6u l=6u
X6 iovdd s2d_block_0.s2d_casc_n_f_0.vbnc s2d_block_0.s2d_casc_n_f_0.yc iovss sg13_hv_nmos ad=5.1p pd=30.68u as=5.1p ps=30.68u w=15u l=3u
X7 Clamp_P_M1_0.gate iovdd iovss rppd l=12.9u w=0.5u
X8 s2d_block_0.s2d_loads_f_0.ln s2d_block_0.s2d_loads_f_0.vcmfb iovdd iovdd sg13_hv_pmos ad=2.04p pd=12.68u as=2.04p ps=12.68u w=6u l=4u
X9 s2d_block_0.s2d_casc_p_f_0.vbpc s2d_block_0.bias_tree_noab_n_c3_0.ni iovss iovss sg13_hv_nmos ad=0.816p pd=5.48u as=0.816p ps=5.48u w=2.4u l=6u
X10 a_11758_27006# a_14374_25510# iovss rhigh l=12.65u w=0.5u
X11 s2d_block_0.s2d_tails_lo_f_0.sa_F1 vcm s2d_block_0.s2d_casc_n_f_0.y s2d_block_0.s2d_tails_lo_f_0.sa_F1 sg13_hv_pmos ad=3.4p pd=20.68u as=1.9p ps=10.38u w=10u l=1u
X12 iovss s2d_block_0.sinks_6x6_s2d_c3_core_0.vbn iovss iovss sg13_hv_nmos ad=0.68p pd=4.68u as=0.74628n ps=2.70983m w=2u l=6u
X13 iovdd Clamp_P_M1_0.gate pad iovdd sg13_hv_pmos ad=2.1312p pd=7.3u as=3.9294p ps=7.84u w=6.66u l=0.6u
X14 iovss s2d_block_0.sinks_6x6_s2d_c3_core_0.vbn s2d_block_0.s2d_casc_n_f_0.xc iovss sg13_hv_nmos ad=2.04p pd=12.68u as=2.04p ps=12.68u w=6u l=6u
X15 s2d_block_0.bias_tree_noab_n_c3_0.ni en_3v3_b iovss iovss sg13_hv_nmos ad=0.34p pd=2.68u as=0.34p ps=2.68u w=1u l=0.45u
X16 iovdd Clamp_P_M1_0.gate pad iovdd sg13_hv_pmos ad=2.1312p pd=7.3u as=3.9294p ps=7.84u w=6.66u l=0.6u
X17 iovss s2d_block_0.sinks_6x6_s2d_c3_core_0.vbn iovss iovss sg13_hv_nmos ad=2.04p pd=12.68u as=0 ps=0 w=6u l=6u
X18 s2d_block_0.s2d_casc_n_f_0.x s2d_block_0.s2d_casc_n_f_0.vbnc outp iovss sg13_hv_nmos ad=5.1p pd=30.68u as=5.1p ps=30.68u w=15u l=3u
X19 s2d_block_0.s2d_casc_n_f_0.x vref s2d_block_0.s2d_tails_lo_f_0.sb_A2 s2d_block_0.s2d_tails_lo_f_0.sb_A2 sg13_hv_pmos ad=1.9p pd=10.38u as=3.4p ps=20.68u w=10u l=1u
X20 iovdd Clamp_P_M1_0.gate pad iovdd sg13_hv_pmos ad=2.1312p pd=7.3u as=3.9294p ps=7.84u w=6.66u l=0.6u
X21 s2d_block_0.s2d_tails_hi_f_0.sb_F1 outp s2d_block_0.s2d_casc_n_f_0.x s2d_block_0.s2d_tails_hi_f_0.sb_F1 sg13_hv_pmos ad=3.4p pd=20.68u as=1.9p ps=10.38u w=10u l=1u
X22 iovdd iovdd iovdd iovdd sg13_hv_pmos ad=1.9p pd=10.38u as=0 ps=0 w=10u l=1u
X23 iovdd s2d_block_0.s2d_tails_hi_f_0.vbp iovdd iovdd sg13_hv_pmos ad=1.7p pd=10.68u as=0 ps=0 w=5u l=6u
X24 s2d_block_0.s2d_casc_n_f_0.y s2d_block_0.sinks_6x6_s2d_c3_core_0.vbn iovss iovss sg13_hv_nmos ad=2.04p pd=12.68u as=2.04p ps=12.68u w=6u l=6u
X25 s2d_block_0.s2d_tails_lo_f_0.sb_A2 a_14374_27278# iovss rhigh l=12.65u w=0.5u
X26 iovdd s2d_block_0.s2d_loads_f_0.vcmfb s2d_block_0.s2d_loads_f_0.dd iovdd sg13_hv_pmos ad=2.04p pd=12.68u as=2.04p ps=12.68u w=6u l=4u
X27 pad Clamp_N_M1_0.gate iovss iovss sg13_hv_nmos ad=2.596p pd=5.58u as=1.408p ps=5.04u w=4.4u l=0.6u
X28 pad Clamp_N_M1_0.gate iovss iovss sg13_hv_nmos ad=2.596p pd=5.58u as=2.068p ps=9.74u w=4.4u l=0.6u
X29 iovdd s2d_block_0.s2d_loads_f_0.vcmfb s2d_block_0.s2d_loads_f_0.lp iovdd sg13_hv_pmos ad=2.04p pd=12.68u as=2.04p ps=12.68u w=6u l=4u
X30 pad Clamp_N_M1_0.gate iovss iovss sg13_hv_nmos ad=2.596p pd=5.58u as=1.408p ps=5.04u w=4.4u l=0.6u
X31 vcm en_3v3_b outp iovss sg13_hv_nmos ad=0.19p pd=1.38u as=0.34p ps=2.68u w=1u l=0.45u
X32 s2d_block_0.s2d_tails_lo_f_0.sa_F1 a_14374_25782# iovss rhigh l=12.65u w=0.5u
X33 a_11758_27006# a_14374_27142# iovss rhigh l=12.65u w=0.5u
X34 iovdd iovdd iovdd iovdd sg13_hv_pmos ad=3.4p pd=20.68u as=0 ps=0 w=10u l=1u
X35 pad Clamp_P_M1_0.gate iovdd iovdd sg13_hv_pmos ad=3.9294p pd=7.84u as=2.1312p ps=7.3u w=6.66u l=0.6u
X36 s2d_block_0.s2d_loads_f_0.lp s2d_block_0.s2d_casc_p_f_0.vbpc outp iovdd sg13_hv_pmos ad=5.1p pd=30.68u as=5.1p ps=30.68u w=15u l=3u
X37 iovdd s2d_block_0.s2d_tails_hi_f_0.vbp s2d_block_0.s2d_tails_hi_f_0.sa_M1 iovdd sg13_hv_pmos ad=1.7p pd=10.68u as=1.7p ps=10.68u w=5u l=6u
X38 s2d_block_0.s2d_casc_n_f_0.y s2d_block_0.sinks_6x6_s2d_c3_core_0.vbn iovss iovss sg13_hv_nmos ad=2.04p pd=12.68u as=2.04p ps=12.68u w=6u l=6u
X39 iovdd Clamp_P_M1_0.gate pad iovdd sg13_hv_pmos ad=2.1312p pd=7.3u as=3.9294p ps=7.84u w=6.66u l=0.6u
X40 iovdd Clamp_P_M1_0.gate pad iovdd sg13_hv_pmos ad=2.1312p pd=7.3u as=3.9294p ps=7.84u w=6.66u l=0.6u
X41 iref en_3v3 s2d_block_0.bias_tree_noab_n_c3_0.ni iovss sg13_hv_nmos ad=0.34p pd=2.68u as=0.34p ps=2.68u w=1u l=0.45u
X42 iovdd Clamp_P_M1_0.gate pad iovdd sg13_hv_pmos ad=2.1312p pd=7.3u as=3.9294p ps=7.84u w=6.66u l=0.6u
X43 pad iovdd dpantenna l=1.26u w=27.78u
X44 pad Clamp_P_M1_0.gate iovdd iovdd sg13_hv_pmos ad=3.9294p pd=7.84u as=2.1312p ps=7.3u w=6.66u l=0.6u
X45 s2d_block_0.s2d_casc_n_f_0.x vcm s2d_block_0.s2d_tails_hi_f_0.sb_F2 s2d_block_0.s2d_tails_hi_f_0.sb_F2 sg13_hv_pmos ad=1.9p pd=10.38u as=3.4p ps=20.68u w=10u l=1u
X46 s2d_block_0.s2d_tails_hi_f_0.sa_A1 a_14374_25510# iovss rhigh l=12.65u w=0.5u
X47 iovss s2d_block_0.sinks_6x6_s2d_c3_core_0.vbn s2d_block_0.s2d_casc_n_f_0.y iovss sg13_hv_nmos ad=2.04p pd=12.68u as=2.04p ps=12.68u w=6u l=6u
X48 s2d_block_0.s2d_tails_hi_f_0.sb_F1 a_14374_27414# iovss rhigh l=12.65u w=0.5u
X49 s2d_block_0.s2d_tails_lo_f_0.sa_F2 outn s2d_block_0.s2d_casc_n_f_0.y s2d_block_0.s2d_tails_lo_f_0.sa_F2 sg13_hv_pmos ad=3.4p pd=20.68u as=1.9p ps=10.38u w=10u l=1u
X50 iovss s2d_block_0.bias_tree_noab_n_c3_0.ni iovss iovss sg13_hv_nmos ad=0.816p pd=5.48u as=0 ps=0 w=2.4u l=6u
X51 s2d_block_0.s2d_casc_n_f_0.y s2d_block_0.s2d_casc_n_f_0.vbnc outn iovss sg13_hv_nmos ad=5.1p pd=30.68u as=5.1p ps=30.68u w=15u l=3u
X52 pad Clamp_N_M1_0.gate iovss iovss sg13_hv_nmos ad=2.596p pd=5.58u as=1.408p ps=5.04u w=4.4u l=0.6u
X53 iovss s2d_block_0.s2d_casc_n_f_0.vbnc iovss iovss sg13_hv_nmos ad=0.68p pd=4.68u as=0 ps=0 w=2u l=3u
X54 iovss pad dantenna l=1.26u w=27.78u
X55 pad Clamp_N_M1_0.gate iovss iovss sg13_hv_nmos ad=2.596p pd=5.58u as=1.408p ps=5.04u w=4.4u l=0.6u
X56 vcm en_3v3 outp iovdd sg13_hv_pmos ad=0.19p pd=1.38u as=0.34p ps=2.68u w=1u l=0.45u
X57 outn en_3v3 vcm iovdd sg13_hv_pmos ad=0.34p pd=2.68u as=0.19p ps=1.38u w=1u l=0.45u
X58 iovdd s2d_block_0.s2d_tails_hi_f_0.vbp s2d_block_0.s2d_tails_hi_f_0.sb_M2 iovdd sg13_hv_pmos ad=1.7p pd=10.68u as=1.7p ps=10.68u w=5u l=6u
X59 iovss s2d_block_0.sinks_6x6_s2d_c3_core_0.vbn s2d_block_0.s2d_casc_n_f_0.y iovss sg13_hv_nmos ad=2.04p pd=12.68u as=2.04p ps=12.68u w=6u l=6u
X60 pad Clamp_P_M1_0.gate iovdd iovdd sg13_hv_pmos ad=3.9294p pd=7.84u as=2.1312p ps=7.3u w=6.66u l=0.6u
X61 iovdd s2d_block_0.s2d_tails_hi_f_0.vbp s2d_block_0.s2d_tails_hi_f_0.sb_F1 iovdd sg13_hv_pmos ad=1.7p pd=10.68u as=1.7p ps=10.68u w=5u l=6u
X62 iovdd s2d_block_0.s2d_loads_f_0.vcmfb s2d_block_0.s2d_loads_f_0.lp iovdd sg13_hv_pmos ad=2.04p pd=12.68u as=2.04p ps=12.68u w=6u l=4u
X63 iovdd Clamp_P_M1_0.gate pad iovdd sg13_hv_pmos ad=2.1312p pd=7.3u as=3.9294p ps=7.84u w=6.66u l=0.6u
X64 a_11758_26734# a_14374_25782# iovss rhigh l=12.65u w=0.5u
X65 pad Clamp_P_M1_0.gate iovdd iovdd sg13_hv_pmos ad=3.9294p pd=7.84u as=2.1312p ps=7.3u w=6.66u l=0.6u
X66 pad Clamp_P_M1_0.gate iovdd iovdd sg13_hv_pmos ad=3.9294p pd=7.84u as=2.1312p ps=7.3u w=6.66u l=0.6u
X67 pad Clamp_P_M1_0.gate iovdd iovdd sg13_hv_pmos ad=3.9294p pd=7.84u as=2.1312p ps=7.3u w=6.66u l=0.6u
X68 s2d_block_0.s2d_tails_hi_f_0.sb_M2 vcm s2d_block_0.s2d_casc_n_f_0.xc s2d_block_0.s2d_tails_hi_f_0.sb_M2 sg13_hv_pmos ad=3.4p pd=20.68u as=1.9p ps=10.38u w=10u l=1u
X69 pad Clamp_P_M1_0.gate iovdd iovdd sg13_hv_pmos ad=3.9294p pd=7.84u as=2.1312p ps=7.3u w=6.66u l=0.6u
X70 iovss Clamp_N_M1_0.gate pad iovss sg13_hv_nmos ad=1.408p pd=5.04u as=2.596p ps=5.58u w=4.4u l=0.6u
X71 iovss Clamp_N_M1_0.gate pad iovss sg13_hv_nmos ad=1.408p pd=5.04u as=2.596p ps=5.58u w=4.4u l=0.6u
X72 iovss iovss iovss rhigh l=12.65u w=0.5u
X73 s2d_block_0.s2d_casc_n_f_0.yc s2d_block_0.s2d_casc_n_f_0.vbnc iovdd iovss sg13_hv_nmos ad=5.1p pd=30.68u as=5.1p ps=30.68u w=15u l=3u
X74 iovdd s2d_block_0.s2d_casc_p_f_0.vbpc iovdd iovdd sg13_hv_pmos ad=0.34p pd=2.68u as=0 ps=0 w=1u l=4u
X75 s2d_block_0.s2d_casc_n_f_0.yc outp s2d_block_0.s2d_tails_hi_f_0.sa_M1 s2d_block_0.s2d_tails_hi_f_0.sa_M1 sg13_hv_pmos ad=1.9p pd=10.38u as=3.4p ps=20.68u w=10u l=1u
X76 s2d_block_0.s2d_casc_n_f_0.y vcm s2d_block_0.s2d_tails_lo_f_0.sa_F1 s2d_block_0.s2d_tails_lo_f_0.sa_F1 sg13_hv_pmos ad=1.9p pd=10.38u as=3.4p ps=20.68u w=10u l=1u
X77 iovdd s2d_block_0.s2d_tails_hi_f_0.vbp s2d_block_0.s2d_tails_hi_f_0.sa_A2 iovdd sg13_hv_pmos ad=1.7p pd=10.68u as=1.7p ps=10.68u w=5u l=6u
X78 s2d_block_0.s2d_tails_hi_f_0.sa_A2 pad s2d_block_0.s2d_casc_n_f_0.y s2d_block_0.s2d_tails_hi_f_0.sa_A2 sg13_hv_pmos ad=3.4p pd=20.68u as=1.9p ps=10.38u w=10u l=1u
X79 iovss s2d_block_0.sinks_6x6_s2d_c3_core_0.vbn s2d_block_0.s2d_casc_n_f_0.yc iovss sg13_hv_nmos ad=2.04p pd=12.68u as=2.04p ps=12.68u w=6u l=6u
X80 iovss s2d_block_0.sinks_6x6_s2d_c3_core_0.vbn iovss iovss sg13_hv_nmos ad=0.68p pd=4.68u as=0 ps=0 w=2u l=6u
X81 s2d_block_0.s2d_tails_hi_f_0.sb_M2 a_14374_27822# iovss rhigh l=12.65u w=0.5u
X82 s2d_block_0.s2d_casc_n_f_0.yc s2d_block_0.sinks_6x6_s2d_c3_core_0.vbn iovss iovss sg13_hv_nmos ad=2.04p pd=12.68u as=2.04p ps=12.68u w=6u l=6u
X83 iovss s2d_block_0.sinks_6x6_s2d_c3_core_0.vbn s2d_block_0.s2d_casc_n_f_0.y iovss sg13_hv_nmos ad=2.04p pd=12.68u as=2.04p ps=12.68u w=6u l=6u
X84 iovdd s2d_block_0.s2d_tails_hi_f_0.vbp s2d_block_0.s2d_tails_hi_f_0.sa_A1 iovdd sg13_hv_pmos ad=1.7p pd=10.68u as=1.7p ps=10.68u w=5u l=6u
X85 a_11758_26870# a_14374_25646# iovss rhigh l=12.65u w=0.5u
X86 s2d_block_0.s2d_casc_n_f_0.vbnc s2d_block_0.s2d_tails_hi_f_0.vbp iovdd iovdd sg13_hv_pmos ad=0.68p pd=4.68u as=0.68p ps=4.68u w=2u l=6u
X87 s2d_block_0.s2d_tails_hi_f_0.sb_F2 a_14374_27550# iovss rhigh l=12.65u w=0.5u
X88 iovdd s2d_block_0.s2d_tails_hi_f_0.vbp iovdd iovdd sg13_hv_pmos ad=1.7p pd=10.68u as=0 ps=0 w=5u l=6u
X89 pad Clamp_P_M1_0.gate iovdd iovdd sg13_hv_pmos ad=3.9294p pd=7.84u as=2.1312p ps=7.3u w=6.66u l=0.6u
X90 pad Clamp_P_M1_0.gate iovdd iovdd sg13_hv_pmos ad=3.9294p pd=7.84u as=2.1312p ps=7.3u w=6.66u l=0.6u
X91 a_11758_26598# a_14374_25918# iovss rhigh l=12.65u w=0.5u
X92 iovss s2d_block_0.sinks_6x6_s2d_c3_core_0.vbn s2d_block_0.s2d_casc_n_f_0.x iovss sg13_hv_nmos ad=2.04p pd=12.68u as=2.04p ps=12.68u w=6u l=6u
X93 s2d_block_0.s2d_loads_f_0.dd s2d_block_0.s2d_loads_f_0.vcmfb iovdd iovdd sg13_hv_pmos ad=2.04p pd=12.68u as=2.04p ps=12.68u w=6u l=4u
X94 pad Clamp_P_M1_0.gate iovdd iovdd sg13_hv_pmos ad=3.9294p pd=7.84u as=2.1312p ps=7.3u w=6.66u l=0.6u
X95 iovss Clamp_N_M1_0.gate pad iovss sg13_hv_nmos ad=1.408p pd=5.04u as=2.596p ps=5.58u w=4.4u l=0.6u
X96 iovdd s2d_block_0.s2d_loads_f_0.vcmfb iovdd iovdd sg13_hv_pmos ad=0.34p pd=2.68u as=0 ps=0 w=1u l=4u
X97 pad iovdd dpantenna l=1.26u w=27.78u
X98 pad Clamp_P_M1_0.gate iovdd iovdd sg13_hv_pmos ad=3.9294p pd=7.84u as=2.1312p ps=7.3u w=6.66u l=0.6u
X99 iovdd s2d_block_0.s2d_loads_f_0.vcmfb s2d_block_0.s2d_loads_f_0.ln iovdd sg13_hv_pmos ad=2.04p pd=12.68u as=2.04p ps=12.68u w=6u l=4u
X100 iovss Clamp_N_M1_0.gate pad iovss sg13_hv_nmos ad=2.068p pd=9.74u as=2.596p ps=5.58u w=4.4u l=0.6u
X101 s2d_block_0.s2d_loads_f_0.lp s2d_block_0.s2d_loads_f_0.vcmfb iovdd iovdd sg13_hv_pmos ad=2.04p pd=12.68u as=2.04p ps=12.68u w=6u l=4u
X102 iovdd s2d_block_0.s2d_loads_f_0.vcmfb s2d_block_0.s2d_loads_f_0.ln iovdd sg13_hv_pmos ad=2.04p pd=12.68u as=2.04p ps=12.68u w=6u l=4u
X103 iovdd s2d_block_0.s2d_casc_p_f_0.vbpc iovdd iovdd sg13_hv_pmos ad=0.34p pd=2.68u as=0 ps=0 w=1u l=4u
X104 pad Clamp_N_M1_0.gate iovss iovss sg13_hv_nmos ad=2.596p pd=5.58u as=1.408p ps=5.04u w=4.4u l=0.6u
X105 s2d_block_0.s2d_tails_lo_f_0.sa_M2 outn s2d_block_0.s2d_casc_n_f_0.yc s2d_block_0.s2d_tails_lo_f_0.sa_M2 sg13_hv_pmos ad=3.4p pd=20.68u as=1.9p ps=10.38u w=10u l=1u
X106 iovdd s2d_block_0.s2d_casc_p_f_0.vbpc s2d_block_0.s2d_casc_p_f_0.vbpc iovdd sg13_hv_pmos ad=0.34p pd=2.68u as=0.34p ps=2.68u w=1u l=4u
X107 iovdd s2d_block_0.s2d_loads_f_0.vcmfb iovdd iovdd sg13_hv_pmos ad=0.34p pd=2.68u as=0 ps=0 w=1u l=4u
X108 s2d_block_0.s2d_casc_n_f_0.y s2d_block_0.sinks_6x6_s2d_c3_core_0.vbn iovss iovss sg13_hv_nmos ad=2.04p pd=12.68u as=2.04p ps=12.68u w=6u l=6u
X109 iovss outp iovss iovss sg13_hv_nmos ad=4.08p pd=24.68u as=0 ps=0 w=12u l=12u
X110 iovss outn iovss iovss sg13_hv_nmos ad=4.08p pd=24.68u as=0 ps=0 w=12u l=12u
X111 iovdd s2d_block_0.s2d_tails_hi_f_0.vbp s2d_block_0.s2d_tails_hi_f_0.sb_F2 iovdd sg13_hv_pmos ad=1.7p pd=10.68u as=1.7p ps=10.68u w=5u l=6u
X112 s2d_block_0.s2d_casc_n_f_0.x outp s2d_block_0.s2d_tails_hi_f_0.sb_F1 s2d_block_0.s2d_tails_hi_f_0.sb_F1 sg13_hv_pmos ad=1.9p pd=10.38u as=3.4p ps=20.68u w=10u l=1u
X113 s2d_block_0.s2d_casc_n_f_0.xc vcm s2d_block_0.s2d_tails_lo_f_0.sb_M1 s2d_block_0.s2d_tails_lo_f_0.sb_M1 sg13_hv_pmos ad=1.9p pd=10.38u as=3.4p ps=20.68u w=10u l=1u
X114 iovss s2d_block_0.sinks_6x6_s2d_c3_core_0.vbn iovss iovss sg13_hv_nmos ad=0.68p pd=4.68u as=0 ps=0 w=2u l=6u
X115 iovdd s2d_block_0.s2d_casc_p_f_0.vbpc iovdd iovdd sg13_hv_pmos ad=0.34p pd=2.68u as=0 ps=0 w=1u l=4u
X116 a_11758_26326# a_14374_26190# iovss rhigh l=12.65u w=0.5u
X117 s2d_block_0.s2d_tails_lo_f_0.sb_A1 vref s2d_block_0.s2d_casc_n_f_0.x s2d_block_0.s2d_tails_lo_f_0.sb_A1 sg13_hv_pmos ad=3.4p pd=20.68u as=1.9p ps=10.38u w=10u l=1u
X118 s2d_block_0.s2d_casc_n_f_0.x s2d_block_0.sinks_6x6_s2d_c3_core_0.vbn iovss iovss sg13_hv_nmos ad=2.04p pd=12.68u as=2.04p ps=12.68u w=6u l=6u
X119 iovdd Clamp_P_M1_0.gate pad iovdd sg13_hv_pmos ad=2.1312p pd=7.3u as=3.9294p ps=7.84u w=6.66u l=0.6u
X120 s2d_block_0.s2d_tails_lo_f_0.sb_M1 a_14374_27686# iovss rhigh l=12.65u w=0.5u
X121 iovss s2d_block_0.sinks_6x6_s2d_c3_core_0.vbn iovss iovss sg13_hv_nmos ad=0.68p pd=4.68u as=0 ps=0 w=2u l=6u
X122 iovdd Clamp_P_M1_0.gate pad iovdd sg13_hv_pmos ad=2.1312p pd=7.3u as=3.9294p ps=7.84u w=6.66u l=0.6u
X123 s2d_block_0.s2d_tails_hi_f_0.sa_A1 pad s2d_block_0.s2d_casc_n_f_0.y s2d_block_0.s2d_tails_hi_f_0.sa_A1 sg13_hv_pmos ad=3.4p pd=20.68u as=1.9p ps=10.38u w=10u l=1u
X124 s2d_block_0.s2d_tails_lo_f_0.sb_M1 s2d_block_0.s2d_tails_hi_f_0.vbp iovdd iovdd sg13_hv_pmos ad=1.7p pd=10.68u as=1.7p ps=10.68u w=5u l=6u
X125 pad Clamp_P_M1_0.gate iovdd iovdd sg13_hv_pmos ad=3.9294p pd=7.84u as=2.1312p ps=7.3u w=6.66u l=0.6u
X126 iovdd iovdd iovdd iovdd sg13_hv_pmos ad=3.4p pd=20.68u as=0 ps=0 w=10u l=1u
X127 a_11758_26326# a_14374_27822# iovss rhigh l=12.65u w=0.5u
X128 s2d_block_0.s2d_casc_n_f_0.xc s2d_block_0.sinks_6x6_s2d_c3_core_0.vbn iovss iovss sg13_hv_nmos ad=2.04p pd=12.68u as=2.04p ps=12.68u w=6u l=6u
X129 pad Clamp_N_M1_0.gate iovss iovss sg13_hv_nmos ad=2.596p pd=5.58u as=1.408p ps=5.04u w=4.4u l=0.6u
X130 pad Clamp_N_M1_0.gate iovss iovss sg13_hv_nmos ad=2.596p pd=5.58u as=1.408p ps=5.04u w=4.4u l=0.6u
X131 iovdd Clamp_P_M1_0.gate pad iovdd sg13_hv_pmos ad=2.1312p pd=7.3u as=3.9294p ps=7.84u w=6.66u l=0.6u
X132 s2d_block_0.bias_tree_noab_n_c3_0.ni en_3v3_b iref iovdd sg13_hv_pmos ad=0.34p pd=2.68u as=0.34p ps=2.68u w=1u l=0.45u
X133 pad Clamp_P_M1_0.gate iovdd iovdd sg13_hv_pmos ad=3.9294p pd=7.84u as=3.1302p ps=14.26u w=6.66u l=0.6u
X134 pad Clamp_N_M1_0.gate iovss iovss sg13_hv_nmos ad=2.596p pd=5.58u as=1.408p ps=5.04u w=4.4u l=0.6u
X135 a_11758_26462# a_14374_26054# iovss rhigh l=12.65u w=0.5u
X136 s2d_block_0.s2d_loads_f_0.dd s2d_block_0.s2d_loads_f_0.vcmfb iovdd iovdd sg13_hv_pmos ad=2.04p pd=12.68u as=2.04p ps=12.68u w=6u l=4u
X137 iovss s2d_block_0.sinks_6x6_s2d_c3_core_0.vbn iovss iovss sg13_hv_nmos ad=0.68p pd=4.68u as=0 ps=0 w=2u l=6u
X138 iovdd iovdd iovdd iovdd sg13_hv_pmos ad=1.9p pd=10.38u as=0 ps=0 w=10u l=1u
X139 s2d_block_0.s2d_loads_f_0.vcmfb s2d_block_0.s2d_casc_p_f_0.vbpc s2d_block_0.s2d_loads_f_0.dd iovdd sg13_hv_pmos ad=5.1p pd=30.68u as=5.1p ps=30.68u w=15u l=3u
X140 iovdd s2d_block_0.s2d_tails_hi_f_0.vbp s2d_block_0.s2d_tails_hi_f_0.vbp iovdd sg13_hv_pmos ad=1.7p pd=10.68u as=1.7p ps=10.68u w=5u l=6u
X141 s2d_block_0.bias_tree_noab_n_c3_0.ni s2d_block_0.bias_tree_noab_n_c3_0.ni iovss iovss sg13_hv_nmos ad=2.04p pd=12.68u as=2.04p ps=12.68u w=6u l=6u
X142 iovdd Clamp_P_M1_0.gate pad iovdd sg13_hv_pmos ad=2.1312p pd=7.3u as=3.9294p ps=7.84u w=6.66u l=0.6u
X143 s2d_block_0.s2d_tails_lo_f_0.sa_M2 s2d_block_0.s2d_tails_hi_f_0.vbp iovdd iovdd sg13_hv_pmos ad=1.7p pd=10.68u as=1.7p ps=10.68u w=5u l=6u
X144 outn s2d_block_0.s2d_casc_n_f_0.vbnc s2d_block_0.s2d_casc_n_f_0.y iovss sg13_hv_nmos ad=5.1p pd=30.68u as=5.1p ps=30.68u w=15u l=3u
X145 iovdd Clamp_P_M1_0.gate pad iovdd sg13_hv_pmos ad=2.1312p pd=7.3u as=3.9294p ps=7.84u w=6.66u l=0.6u
X146 iovdd Clamp_P_M1_0.gate pad iovdd sg13_hv_pmos ad=2.1312p pd=7.3u as=3.9294p ps=7.84u w=6.66u l=0.6u
X147 s2d_block_0.s2d_casc_n_f_0.yc s2d_block_0.sinks_6x6_s2d_c3_core_0.vbn iovss iovss sg13_hv_nmos ad=2.04p pd=12.68u as=2.04p ps=12.68u w=6u l=6u
X148 s2d_block_0.s2d_casc_n_f_0.xc vcm s2d_block_0.s2d_tails_hi_f_0.sb_M2 s2d_block_0.s2d_tails_hi_f_0.sb_M2 sg13_hv_pmos ad=1.9p pd=10.38u as=3.4p ps=20.68u w=10u l=1u
X149 s2d_block_0.s2d_casc_n_f_0.y outn s2d_block_0.s2d_tails_lo_f_0.sa_F2 s2d_block_0.s2d_tails_lo_f_0.sa_F2 sg13_hv_pmos ad=1.9p pd=10.38u as=3.4p ps=20.68u w=10u l=1u
X150 s2d_block_0.s2d_tails_hi_f_0.sa_M1 outp s2d_block_0.s2d_casc_n_f_0.yc s2d_block_0.s2d_tails_hi_f_0.sa_M1 sg13_hv_pmos ad=3.4p pd=20.68u as=1.9p ps=10.38u w=10u l=1u
X151 pad Clamp_P_M1_0.gate iovdd iovdd sg13_hv_pmos ad=3.9294p pd=7.84u as=2.1312p ps=7.3u w=6.66u l=0.6u
X152 s2d_block_0.s2d_tails_lo_f_0.sa_F2 a_14374_25918# iovss rhigh l=12.65u w=0.5u
X153 s2d_block_0.sinks_6x6_s2d_c3_core_0.vbn s2d_block_0.sinks_6x6_s2d_c3_core_0.vbn iovss iovss sg13_hv_nmos ad=2.04p pd=12.68u as=2.04p ps=12.68u w=6u l=6u
X154 iovdd Clamp_P_M1_0.gate pad iovdd sg13_hv_pmos ad=2.1312p pd=7.3u as=3.9294p ps=7.84u w=6.66u l=0.6u
X155 iovss s2d_block_0.s2d_casc_n_f_0.vbnc iovss iovss sg13_hv_nmos ad=0.68p pd=4.68u as=0 ps=0 w=2u l=3u
X156 s2d_block_0.s2d_tails_lo_f_0.sa_F2 s2d_block_0.s2d_tails_hi_f_0.vbp iovdd iovdd sg13_hv_pmos ad=1.7p pd=10.68u as=1.7p ps=10.68u w=5u l=6u
X157 iovss Clamp_N_M1_0.gate pad iovss sg13_hv_nmos ad=1.408p pd=5.04u as=2.596p ps=5.58u w=4.4u l=0.6u
X158 s2d_block_0.s2d_tails_lo_f_0.sb_A2 vref s2d_block_0.s2d_casc_n_f_0.x s2d_block_0.s2d_tails_lo_f_0.sb_A2 sg13_hv_pmos ad=3.4p pd=20.68u as=1.9p ps=10.38u w=10u l=1u
X159 pad Clamp_N_M1_0.gate iovss iovss sg13_hv_nmos ad=2.596p pd=5.58u as=1.408p ps=5.04u w=4.4u l=0.6u
X160 a_11758_26462# a_14374_27686# iovss rhigh l=12.65u w=0.5u
X161 s2d_block_0.s2d_casc_n_f_0.x s2d_block_0.sinks_6x6_s2d_c3_core_0.vbn iovss iovss sg13_hv_nmos ad=2.04p pd=12.68u as=2.04p ps=12.68u w=6u l=6u
X162 iovdd Clamp_P_M1_0.gate pad iovdd sg13_hv_pmos ad=2.1312p pd=7.3u as=3.9294p ps=7.84u w=6.66u l=0.6u
X163 s2d_block_0.s2d_tails_hi_f_0.vbp s2d_block_0.bias_tree_noab_n_c3_0.ni iovss iovss sg13_hv_nmos ad=2.04p pd=12.68u as=2.04p ps=12.68u w=6u l=6u
X164 pad Clamp_P_M1_0.gate iovdd iovdd sg13_hv_pmos ad=3.9294p pd=7.84u as=3.1302p ps=14.26u w=6.66u l=0.6u
X165 iovdd iovdd iovdd iovdd sg13_hv_pmos ad=3.4p pd=20.68u as=0 ps=0 w=10u l=1u
X166 iovss s2d_block_0.sinks_6x6_s2d_c3_core_0.vbn s2d_block_0.s2d_casc_n_f_0.xc iovss sg13_hv_nmos ad=2.04p pd=12.68u as=2.04p ps=12.68u w=6u l=6u
X167 Clamp_N_M1_0.gate iovss iovss rppd l=3.54u w=0.5u
X168 iovdd Clamp_P_M1_0.gate pad iovdd sg13_hv_pmos ad=2.1312p pd=7.3u as=3.9294p ps=7.84u w=6.66u l=0.6u
X169 iovss s2d_block_0.s2d_casc_n_f_0.vbnc iovss iovss sg13_hv_nmos ad=0.68p pd=4.68u as=0 ps=0 w=2u l=3u
X170 iovdd iovdd iovdd iovdd sg13_hv_pmos ad=1.9p pd=10.38u as=0 ps=0 w=10u l=1u
X171 s2d_block_0.s2d_tails_lo_f_0.sb_A1 s2d_block_0.s2d_tails_hi_f_0.vbp iovdd iovdd sg13_hv_pmos ad=1.7p pd=10.68u as=1.7p ps=10.68u w=5u l=6u
X172 pad Clamp_P_M1_0.gate iovdd iovdd sg13_hv_pmos ad=3.9294p pd=7.84u as=2.1312p ps=7.3u w=6.66u l=0.6u
X173 a_11758_26734# a_14374_27414# iovss rhigh l=12.65u w=0.5u
X174 pad Clamp_P_M1_0.gate iovdd iovdd sg13_hv_pmos ad=3.9294p pd=7.84u as=2.1312p ps=7.3u w=6.66u l=0.6u
X175 iovdd Clamp_P_M1_0.gate pad iovdd sg13_hv_pmos ad=2.1312p pd=7.3u as=3.9294p ps=7.84u w=6.66u l=0.6u
X176 iovdd Clamp_P_M1_0.gate pad iovdd sg13_hv_pmos ad=3.1302p pd=14.26u as=3.9294p ps=7.84u w=6.66u l=0.6u
X177 outn s2d_block_0.s2d_casc_p_f_0.vbpc s2d_block_0.s2d_loads_f_0.ln iovdd sg13_hv_pmos ad=5.1p pd=30.68u as=5.1p ps=30.68u w=15u l=3u
X178 s2d_block_0.s2d_casc_n_f_0.y pad s2d_block_0.s2d_tails_hi_f_0.sa_A2 s2d_block_0.s2d_tails_hi_f_0.sa_A2 sg13_hv_pmos ad=1.9p pd=10.38u as=3.4p ps=20.68u w=10u l=1u
X179 pad Clamp_P_M1_0.gate iovdd iovdd sg13_hv_pmos ad=3.9294p pd=7.84u as=2.1312p ps=7.3u w=6.66u l=0.6u
X180 iovss Clamp_N_M1_0.gate pad iovss sg13_hv_nmos ad=1.408p pd=5.04u as=2.596p ps=5.58u w=4.4u l=0.6u
X181 s2d_block_0.s2d_casc_n_f_0.yc outn s2d_block_0.s2d_tails_lo_f_0.sa_M2 s2d_block_0.s2d_tails_lo_f_0.sa_M2 sg13_hv_pmos ad=1.9p pd=10.38u as=3.4p ps=20.68u w=10u l=1u
X182 s2d_block_0.s2d_tails_lo_f_0.sb_A2 s2d_block_0.s2d_tails_hi_f_0.vbp iovdd iovdd sg13_hv_pmos ad=1.7p pd=10.68u as=1.7p ps=10.68u w=5u l=6u
X183 iovss s2d_block_0.sinks_6x6_s2d_c3_core_0.vbn s2d_block_0.s2d_casc_n_f_0.x iovss sg13_hv_nmos ad=2.04p pd=12.68u as=2.04p ps=12.68u w=6u l=6u
X184 iovss Clamp_N_M1_0.gate pad iovss sg13_hv_nmos ad=1.408p pd=5.04u as=2.596p ps=5.58u w=4.4u l=0.6u
X185 s2d_block_0.s2d_loads_f_0.lp s2d_block_0.s2d_loads_f_0.vcmfb iovdd iovdd sg13_hv_pmos ad=2.04p pd=12.68u as=2.04p ps=12.68u w=6u l=4u
X186 s2d_block_0.sinks_6x6_s2d_c3_core_0.vbn s2d_block_0.s2d_tails_hi_f_0.vbp iovdd iovdd sg13_hv_pmos ad=1.7p pd=10.68u as=1.7p ps=10.68u w=5u l=6u
X187 s2d_block_0.s2d_tails_lo_f_0.sb_M1 vcm s2d_block_0.s2d_casc_n_f_0.xc s2d_block_0.s2d_tails_lo_f_0.sb_M1 sg13_hv_pmos ad=3.4p pd=20.68u as=1.9p ps=10.38u w=10u l=1u
X188 outp s2d_block_0.s2d_casc_n_f_0.vbnc s2d_block_0.s2d_casc_n_f_0.x iovss sg13_hv_nmos ad=5.1p pd=30.68u as=5.1p ps=30.68u w=15u l=3u
X189 s2d_block_0.s2d_tails_hi_f_0.sa_M1 a_14374_26054# iovss rhigh l=12.65u w=0.5u
X190 iovss Clamp_N_M1_0.gate pad iovss sg13_hv_nmos ad=1.408p pd=5.04u as=2.596p ps=5.58u w=4.4u l=0.6u
X191 iovss s2d_block_0.s2d_casc_n_f_0.vbnc iovss iovss sg13_hv_nmos ad=0.68p pd=4.68u as=0 ps=0 w=2u l=3u
X192 iovss s2d_block_0.sinks_6x6_s2d_c3_core_0.vbn s2d_block_0.s2d_casc_n_f_0.x iovss sg13_hv_nmos ad=2.04p pd=12.68u as=2.04p ps=12.68u w=6u l=6u
X193 iovss s2d_block_0.sinks_6x6_s2d_c3_core_0.vbn iovss iovss sg13_hv_nmos ad=0.68p pd=4.68u as=0 ps=0 w=2u l=6u
X194 iovdd s2d_block_0.s2d_loads_f_0.vcmfb iovdd iovdd sg13_hv_pmos ad=0.34p pd=2.68u as=0 ps=0 w=1u l=4u
X195 outn en_3v3_b vcm iovss sg13_hv_nmos ad=0.34p pd=2.68u as=0.19p ps=1.38u w=1u l=0.45u
X196 s2d_block_0.s2d_tails_hi_f_0.sb_F2 vcm s2d_block_0.s2d_casc_n_f_0.x s2d_block_0.s2d_tails_hi_f_0.sb_F2 sg13_hv_pmos ad=3.4p pd=20.68u as=1.9p ps=10.38u w=10u l=1u
X197 iovss s2d_block_0.sinks_6x6_s2d_c3_core_0.vbn iovss iovss sg13_hv_nmos ad=0.68p pd=4.68u as=0 ps=0 w=2u l=6u
X198 s2d_block_0.s2d_casc_n_f_0.x s2d_block_0.sinks_6x6_s2d_c3_core_0.vbn iovss iovss sg13_hv_nmos ad=2.04p pd=12.68u as=2.04p ps=12.68u w=6u l=6u
X199 s2d_block_0.s2d_casc_n_f_0.y pad s2d_block_0.s2d_tails_hi_f_0.sa_A1 s2d_block_0.s2d_tails_hi_f_0.sa_A1 sg13_hv_pmos ad=1.9p pd=10.38u as=3.4p ps=20.68u w=10u l=1u
X200 s2d_block_0.s2d_tails_lo_f_0.sb_A1 a_14374_27142# iovss rhigh l=12.65u w=0.5u
X201 iovdd s2d_block_0.s2d_loads_f_0.vcmfb s2d_block_0.s2d_loads_f_0.dd iovdd sg13_hv_pmos ad=2.04p pd=12.68u as=2.04p ps=12.68u w=6u l=4u
X202 iovdd iovdd iovdd iovdd sg13_hv_pmos ad=1.9p pd=10.38u as=0 ps=0 w=10u l=1u
X203 iovdd Clamp_P_M1_0.gate pad iovdd sg13_hv_pmos ad=2.1312p pd=7.3u as=3.9294p ps=7.84u w=6.66u l=0.6u
X204 iovdd s2d_block_0.s2d_loads_f_0.vcmfb iovdd iovdd sg13_hv_pmos ad=0.34p pd=2.68u as=0 ps=0 w=1u l=4u
X205 a_11758_26598# a_14374_27550# iovss rhigh l=12.65u w=0.5u
X206 s2d_block_0.s2d_casc_n_f_0.xc s2d_block_0.s2d_casc_n_f_0.vbnc s2d_block_0.s2d_loads_f_0.vcmfb iovss sg13_hv_nmos ad=5.1p pd=30.68u as=5.1p ps=30.68u w=15u l=3u
X207 pad Clamp_P_M1_0.gate iovdd iovdd sg13_hv_pmos ad=3.9294p pd=7.84u as=2.1312p ps=7.3u w=6.66u l=0.6u
X208 s2d_block_0.s2d_tails_lo_f_0.sa_F1 s2d_block_0.s2d_tails_hi_f_0.vbp iovdd iovdd sg13_hv_pmos ad=1.7p pd=10.68u as=1.7p ps=10.68u w=5u l=6u
X209 iovdd Clamp_P_M1_0.gate pad iovdd sg13_hv_pmos ad=3.1302p pd=14.26u as=3.9294p ps=7.84u w=6.66u l=0.6u
X210 outp s2d_block_0.s2d_casc_p_f_0.vbpc s2d_block_0.s2d_loads_f_0.lp iovdd sg13_hv_pmos ad=5.1p pd=30.68u as=5.1p ps=30.68u w=15u l=3u
X211 iovdd s2d_block_0.s2d_tails_hi_f_0.vbp iovdd iovdd sg13_hv_pmos ad=0.68p pd=4.68u as=0 ps=0 w=2u l=6u
X212 a_11758_26870# a_14374_27278# iovss rhigh l=12.65u w=0.5u
X213 s2d_block_0.s2d_casc_n_f_0.vbnc s2d_block_0.s2d_casc_n_f_0.vbnc iovss iovss sg13_hv_nmos ad=0.34p pd=2.68u as=0.34p ps=2.68u w=1u l=8u
X214 pad Clamp_P_M1_0.gate iovdd iovdd sg13_hv_pmos ad=3.9294p pd=7.84u as=2.1312p ps=7.3u w=6.66u l=0.6u
X215 iovss s2d_block_0.sinks_6x6_s2d_c3_core_0.vbn s2d_block_0.s2d_casc_n_f_0.yc iovss sg13_hv_nmos ad=2.04p pd=12.68u as=2.04p ps=12.68u w=6u l=6u
X216 iovss Clamp_N_M1_0.gate pad iovss sg13_hv_nmos ad=1.408p pd=5.04u as=2.596p ps=5.58u w=4.4u l=0.6u
X217 s2d_block_0.s2d_tails_lo_f_0.sa_M2 a_14374_26190# iovss rhigh l=12.65u w=0.5u
X218 s2d_block_0.s2d_loads_f_0.vcmfb s2d_block_0.s2d_casc_n_f_0.vbnc s2d_block_0.s2d_casc_n_f_0.xc iovss sg13_hv_nmos ad=5.1p pd=30.68u as=5.1p ps=30.68u w=15u l=3u
X219 iovss pad dantenna l=1.26u w=27.78u
X220 s2d_block_0.s2d_loads_f_0.dd s2d_block_0.s2d_casc_p_f_0.vbpc s2d_block_0.s2d_loads_f_0.vcmfb iovdd sg13_hv_pmos ad=5.1p pd=30.68u as=5.1p ps=30.68u w=15u l=3u
X221 iovdd iovdd iovdd iovdd sg13_hv_pmos ad=3.4p pd=20.68u as=0 ps=0 w=10u l=1u
X222 s2d_block_0.s2d_casc_n_f_0.x vref s2d_block_0.s2d_tails_lo_f_0.sb_A1 s2d_block_0.s2d_tails_lo_f_0.sb_A1 sg13_hv_pmos ad=1.9p pd=10.38u as=3.4p ps=20.68u w=10u l=1u
X223 iovss Clamp_N_M1_0.gate pad iovss sg13_hv_nmos ad=1.408p pd=5.04u as=2.596p ps=5.58u w=4.4u l=0.6u
X224 iovss s2d_block_0.sinks_6x6_s2d_c3_core_0.vbn iovss iovss sg13_hv_nmos ad=0.68p pd=4.68u as=0 ps=0 w=2u l=6u
C0 s2d_block_0.s2d_casc_n_f_0.x s2d_block_0.s2d_tails_hi_f_0.sb_F2 1.75142f
C1 iovdd s2d_block_0.s2d_tails_lo_f_0.sb_M1 1.20235f
C2 a_14374_25918# a_14374_25782# 0.78325f
C3 a_14374_25646# a_11844_26870# 0.0271f
C4 outn s2d_block_0.s2d_tails_lo_f_0.sb_M1 0.03002f
C5 a_11844_26870# a_11758_26870# 0.01953f
C6 a_11844_26598# a_11758_26598# 0.01938f
C7 a_11844_26734# a_11758_26734# 0.01944f
C8 a_11844_26326# a_11758_26326# 0.01932f
C9 a_11844_27006# a_11758_27006# 0.01971f
C10 a_11844_26462# a_11758_26462# 0.01935f
C11 s2d_block_0.s2d_casc_n_f_0.x s2d_block_0.s2d_casc_n_f_0.y 23.2365f
C12 vref pad 0.10654f
C13 iovdd iref 0.38696f
C14 a_11844_25782# s2d_block_0.s2d_tails_lo_f_0.sa_F1 0.01924f
C15 vref s2d_block_0.s2d_casc_n_f_0.vbnc 0.03195f
C16 a_11844_28774# a_11844_28638# 0.63642f
C17 s2d_block_0.s2d_tails_lo_f_0.sb_M1 s2d_block_0.s2d_tails_hi_f_0.sa_M1 0.02734f
C18 s2d_block_0.s2d_tails_lo_f_0.sb_A1 s2d_block_0.s2d_tails_hi_f_0.sa_A2 0.03629f
C19 a_11758_26734# s2d_block_0.s2d_tails_lo_f_0.sb_A1 0.01181f
C20 s2d_block_0.s2d_casc_n_f_0.yc s2d_block_0.s2d_tails_hi_f_0.sb_M2 0.2619f
C21 a_11844_25646# s2d_block_0.s2d_tails_hi_f_0.sb_F2 0.0281f
C22 s2d_block_0.s2d_tails_hi_f_0.sa_A1 s2d_block_0.s2d_casc_n_f_0.x 0.33233f
C23 a_11844_28366# s2d_block_0.s2d_tails_hi_f_0.sb_F1 0.01924f
C24 vref vdd 1.09206f
C25 s2d_block_0.s2d_tails_hi_f_0.vbp s2d_block_0.s2d_tails_lo_f_0.sb_M1 0.24775f
C26 a_11844_27414# s2d_block_0.s2d_tails_hi_f_0.sb_F2 0.02303f
C27 s2d_block_0.s2d_loads_f_0.ln s2d_block_0.s2d_casc_n_f_0.yc 0.04676f
C28 outp s2d_block_0.s2d_loads_f_0.dd 0.02837f
C29 a_11844_27822# s2d_block_0.s2d_tails_lo_f_0.sb_M1 0.01326f
C30 iref s2d_block_0.s2d_tails_hi_f_0.vbp 0.07364f
C31 s2d_block_0.s2d_casc_p_f_0.vbpc s2d_block_0.s2d_casc_n_f_0.yc 0.05155f
C32 iovdd s2d_block_0.s2d_tails_lo_f_0.sb_A1 1.16397f
C33 s2d_block_0.s2d_casc_p_f_0.vbpc s2d_block_0.s2d_tails_lo_f_0.sa_M2 0.04225f
C34 outn s2d_block_0.s2d_tails_lo_f_0.sb_A1 0.30789f
C35 vcm outp 0.54809f
C36 s2d_block_0.s2d_loads_f_0.lp s2d_block_0.sinks_6x6_s2d_c3_core_0.vbn 0.01951f
C37 en_3v3 iovdd 0.38341f
C38 en_3v3 outn 0.88692f
C39 a_11844_27278# a_11758_26870# 0.01953f
C40 a_11758_26734# a_11758_26598# 0.78325f
C41 s2d_block_0.s2d_casc_n_f_0.yc s2d_block_0.s2d_tails_hi_f_0.sb_F1 0.01163f
C42 s2d_block_0.s2d_tails_hi_f_0.sb_M2 s2d_block_0.s2d_tails_hi_f_0.sa_A2 0.10456f
C43 s2d_block_0.s2d_tails_lo_f_0.sa_F1 s2d_block_0.sinks_6x6_s2d_c3_core_0.vbn 0.04563f
C44 s2d_block_0.s2d_tails_lo_f_0.sb_A1 s2d_block_0.s2d_tails_hi_f_0.sa_M1 0.02734f
C45 vref s2d_block_0.s2d_casc_n_f_0.xc 0.2609f
C46 en_3v3_b s2d_block_0.s2d_casc_n_f_0.vbnc 0.02878f
C47 outp s2d_block_0.s2d_tails_lo_f_0.sb_A2 0.0209f
C48 a_11844_27278# vdd 0.01422f
C49 vdd a_11758_26462# 0.0103f
C50 s2d_block_0.s2d_loads_f_0.lp s2d_block_0.s2d_loads_f_0.vcmfb 2.06525f
C51 s2d_block_0.s2d_tails_lo_f_0.sa_F1 s2d_block_0.s2d_casc_n_f_0.xc 0.06696f
C52 s2d_block_0.s2d_tails_lo_f_0.sb_A1 s2d_block_0.s2d_tails_hi_f_0.vbp 0.24275f
C53 s2d_block_0.s2d_casc_p_f_0.vbpc s2d_block_0.s2d_tails_hi_f_0.sa_A2 0.03582f
C54 a_14374_27278# a_14374_27142# 1.23642f
C55 s2d_block_0.s2d_tails_lo_f_0.sa_F2 s2d_block_0.s2d_tails_hi_f_0.sb_F2 1.21274f
C56 en_3v3 s2d_block_0.s2d_tails_hi_f_0.vbp 0.03309f
C57 iovdd s2d_block_0.s2d_tails_hi_f_0.sb_M2 1.00738f
C58 outn s2d_block_0.s2d_tails_hi_f_0.sb_M2 0.62434f
C59 en_3v3_b vdd 2.20327f
C60 s2d_block_0.s2d_tails_lo_f_0.sa_F2 s2d_block_0.s2d_casc_n_f_0.y 1.24912f
C61 a_11844_25918# s2d_block_0.s2d_tails_hi_f_0.sb_F2 0.02395f
C62 iovdd s2d_block_0.s2d_loads_f_0.ln 9.07021f
C63 outn s2d_block_0.s2d_loads_f_0.ln 0.36494f
C64 iovdd s2d_block_0.s2d_casc_p_f_0.vbpc 35.3307f
C65 s2d_block_0.s2d_tails_hi_f_0.sb_F1 s2d_block_0.s2d_tails_hi_f_0.sa_A2 0.28062f
C66 outn s2d_block_0.s2d_casc_p_f_0.vbpc 2.00001f
C67 a_11844_26870# s2d_block_0.s2d_tails_hi_f_0.sb_F2 0.02208f
C68 vcm s2d_block_0.s2d_casc_n_f_0.x 0.63396f
C69 s2d_block_0.s2d_tails_hi_f_0.sb_M2 s2d_block_0.s2d_tails_hi_f_0.sa_M1 0.27974f
C70 s2d_block_0.s2d_casc_n_f_0.yc s2d_block_0.s2d_tails_lo_f_0.sa_M2 1.79719f
C71 s2d_block_0.s2d_tails_hi_f_0.sa_A1 s2d_block_0.s2d_tails_lo_f_0.sa_F2 0.03918f
C72 outp s2d_block_0.s2d_casc_n_f_0.x 0.94634f
C73 iref s2d_block_0.s2d_casc_n_f_0.vbnc 0.12949f
C74 a_11844_25374# s2d_block_0.sinks_6x6_s2d_c3_core_0.vbn 0.03332f
C75 a_11844_27414# a_11844_27550# 0.63642f
C76 a_11844_28366# s2d_block_0.s2d_tails_hi_f_0.sa_A2 0.0102f
C77 a_11844_27686# a_11758_26462# 0.01935f
C78 s2d_block_0.s2d_tails_hi_f_0.sb_M2 s2d_block_0.s2d_tails_hi_f_0.vbp 0.25269f
C79 s2d_block_0.s2d_casc_p_f_0.vbpc s2d_block_0.s2d_tails_hi_f_0.sa_M1 0.03197f
C80 iovdd s2d_block_0.s2d_tails_hi_f_0.sb_F1 4.46003f
C81 vref s2d_block_0.s2d_tails_hi_f_0.sb_F2 0.09756f
C82 outn s2d_block_0.s2d_tails_hi_f_0.sb_F1 1.22022f
C83 a_11844_25374# s2d_block_0.s2d_casc_n_f_0.xc 0.01124f
C84 vref s2d_block_0.s2d_casc_n_f_0.y 0.05183f
C85 s2d_block_0.s2d_tails_lo_f_0.sa_F1 s2d_block_0.s2d_tails_hi_f_0.sb_F2 0.56114f
C86 s2d_block_0.s2d_casc_p_f_0.vbpc s2d_block_0.s2d_tails_hi_f_0.vbp 0.03549f
C87 iref vdd 1.6991f
C88 s2d_block_0.s2d_casc_n_f_0.x s2d_block_0.s2d_tails_lo_f_0.sb_A2 1.22267f
C89 s2d_block_0.s2d_tails_lo_f_0.sa_F1 s2d_block_0.s2d_casc_n_f_0.y 1.18782f
C90 s2d_block_0.s2d_tails_hi_f_0.sa_M1 s2d_block_0.s2d_tails_hi_f_0.sb_F1 0.01643f
C91 a_14374_27142# a_11844_28638# 0.02707f
C92 s2d_block_0.s2d_tails_hi_f_0.sa_A1 vref 0.56814f
C93 s2d_block_0.s2d_tails_hi_f_0.vbp s2d_block_0.s2d_tails_hi_f_0.sb_F1 0.74577f
C94 s2d_block_0.s2d_tails_lo_f_0.sa_M2 s2d_block_0.s2d_tails_hi_f_0.sa_A2 0.02981f
C95 s2d_block_0.s2d_tails_lo_f_0.sb_M1 s2d_block_0.sinks_6x6_s2d_c3_core_0.vbn 0.17579f
C96 s2d_block_0.s2d_tails_hi_f_0.sa_A1 s2d_block_0.s2d_tails_lo_f_0.sa_F1 0.24121f
C97 a_8120_4634# Clamp_P_M1_0.gate 0.03336f
C98 a_8120_4634# iovdd 0.08872f
C99 s2d_block_0.s2d_casc_n_f_0.xc s2d_block_0.s2d_tails_lo_f_0.sb_M1 1.91231f
C100 a_11844_28638# s2d_block_0.s2d_tails_lo_f_0.sa_F2 0.02158f
C101 en_3v3 s2d_block_0.s2d_casc_n_f_0.vbnc 0.02771f
C102 a_11844_27278# s2d_block_0.s2d_tails_hi_f_0.sb_F2 0.02263f
C103 en_3v3_b s2d_block_0.bias_tree_noab_n_c3_0.ni 0.29362f
C104 iovdd s2d_block_0.s2d_casc_n_f_0.yc 12.9248f
C105 a_11844_28094# s2d_block_0.s2d_tails_lo_f_0.sb_M1 0.06056f
C106 a_11758_26326# s2d_block_0.s2d_tails_lo_f_0.sb_A2 0.04715f
C107 outn s2d_block_0.s2d_casc_n_f_0.yc 1.60368f
C108 a_11844_26054# s2d_block_0.s2d_tails_hi_f_0.sa_M1 0.09629f
C109 iovdd s2d_block_0.s2d_tails_lo_f_0.sa_M2 1.56854f
C110 a_11844_26598# s2d_block_0.s2d_tails_hi_f_0.sa_M1 0.01028f
C111 a_11844_27414# a_14374_27414# 0.02713f
C112 a_11844_27686# a_14374_27686# 0.02728f
C113 a_11844_27278# a_14374_27278# 0.0271f
C114 a_11844_27822# a_14374_27822# 0.02746f
C115 a_11844_27550# a_14374_27550# 0.02719f
C116 outn s2d_block_0.s2d_tails_lo_f_0.sa_M2 3.25078f
C117 a_14374_27686# a_11844_28094# 0.02728f
C118 a_11844_28230# a_11844_28366# 0.63642f
C119 en_3v3 vdd 1.61139f
C120 a_11844_25374# s2d_block_0.s2d_tails_hi_f_0.sb_F2 0.03166f
C121 a_11844_26190# s2d_block_0.s2d_tails_lo_f_0.sa_F2 0.0105f
C122 pad s2d_block_0.s2d_tails_hi_f_0.sb_M2 0.06574f
C123 s2d_block_0.s2d_casc_n_f_0.yc s2d_block_0.s2d_tails_hi_f_0.sa_M1 1.03531f
C124 vcm s2d_block_0.s2d_tails_lo_f_0.sa_F2 0.22099f
C125 s2d_block_0.s2d_tails_lo_f_0.sb_A1 s2d_block_0.sinks_6x6_s2d_c3_core_0.vbn 0.047f
C126 s2d_block_0.s2d_tails_lo_f_0.sa_M2 s2d_block_0.s2d_tails_hi_f_0.sa_M1 0.32682f
C127 a_11844_25510# s2d_block_0.s2d_tails_hi_f_0.sb_F2 0.02922f
C128 s2d_block_0.s2d_casc_n_f_0.yc s2d_block_0.s2d_tails_hi_f_0.vbp 0.36143f
C129 outp s2d_block_0.s2d_tails_lo_f_0.sa_F2 0.20113f
C130 a_11844_27142# vdd 0.01241f
C131 a_14374_26190# a_11844_26326# 0.02746f
C132 s2d_block_0.s2d_tails_lo_f_0.sa_M2 s2d_block_0.s2d_tails_hi_f_0.vbp 0.25171f
C133 a_11844_28774# s2d_block_0.s2d_tails_lo_f_0.sa_F2 0.02392f
C134 a_11844_26462# a_11844_26598# 0.63642f
C135 s2d_block_0.s2d_tails_lo_f_0.sb_A1 s2d_block_0.s2d_casc_n_f_0.xc 0.15156f
C136 s2d_block_0.s2d_loads_f_0.lp s2d_block_0.s2d_loads_f_0.dd 3.6366f
C137 s2d_block_0.s2d_casc_p_f_0.vbpc s2d_block_0.s2d_casc_n_f_0.vbnc 0.3137f
C138 iovdd s2d_block_0.s2d_tails_hi_f_0.sa_A2 0.79139f
C139 iovdd a_14374_25510# 0.02823f
C140 outn s2d_block_0.s2d_tails_hi_f_0.sa_A2 0.01529f
C141 iref s2d_block_0.bias_tree_noab_n_c3_0.ni 0.20231f
C142 vdd s2d_block_0.s2d_tails_hi_f_0.sb_M2 0.093f
C143 s2d_block_0.s2d_tails_lo_f_0.sb_M1 s2d_block_0.s2d_tails_hi_f_0.sb_F2 1.45977f
C144 pad s2d_block_0.s2d_tails_hi_f_0.sb_F1 0.07445f
C145 s2d_block_0.s2d_tails_lo_f_0.sa_F2 s2d_block_0.s2d_tails_lo_f_0.sb_A2 0.14118f
C146 vdd s2d_block_0.s2d_casc_p_f_0.vbpc 0.37748f
C147 a_11844_28502# s2d_block_0.s2d_tails_hi_f_0.sb_F2 0.01671f
C148 iovdd Clamp_P_M1_0.gate 44.7526f
C149 outp s2d_block_0.s2d_loads_f_0.lp 0.34238f
C150 s2d_block_0.s2d_tails_hi_f_0.sa_M1 s2d_block_0.s2d_tails_hi_f_0.sa_A2 4.59267f
C151 vref vcm 1.2656f
C152 s2d_block_0.s2d_tails_hi_f_0.sb_F1 s2d_block_0.s2d_casc_n_f_0.vbnc 1.91291f
C153 s2d_block_0.s2d_tails_hi_f_0.sa_A1 a_11844_25510# 0.01933f
C154 iovdd outn 16.7646f
C155 a_14374_27550# a_14374_27414# 0.78325f
C156 a_14374_27278# a_11844_28502# 0.0271f
C157 vcm s2d_block_0.s2d_tails_lo_f_0.sa_F1 2.76774f
C158 a_11844_26734# s2d_block_0.s2d_tails_hi_f_0.sb_F2 0.02199f
C159 vref outp 0.12646f
C160 s2d_block_0.s2d_tails_hi_f_0.vbp s2d_block_0.s2d_tails_hi_f_0.sa_A2 0.24322f
C161 outp s2d_block_0.s2d_tails_lo_f_0.sa_F1 0.02376f
C162 vdd s2d_block_0.s2d_tails_hi_f_0.sb_F1 0.98133f
C163 a_14374_25918# a_11844_25918# 0.02719f
C164 s2d_block_0.s2d_tails_hi_f_0.sb_M2 s2d_block_0.s2d_casc_n_f_0.xc 1.21481f
C165 s2d_block_0.s2d_casc_p_f_0.vbpc s2d_block_0.sinks_6x6_s2d_c3_core_0.vbn 0.90554f
C166 iovdd s2d_block_0.s2d_tails_hi_f_0.sa_M1 0.70405f
C167 outn s2d_block_0.s2d_tails_hi_f_0.sa_M1 0.01551f
C168 vref s2d_block_0.s2d_tails_lo_f_0.sb_A2 2.83717f
C169 s2d_block_0.s2d_tails_lo_f_0.sb_A1 s2d_block_0.s2d_tails_hi_f_0.sb_F2 0.07061f
C170 en_3v3 s2d_block_0.bias_tree_noab_n_c3_0.ni 0.06108f
C171 s2d_block_0.s2d_casc_p_f_0.vbpc s2d_block_0.s2d_casc_n_f_0.xc 0.05739f
C172 a_14374_26054# a_14374_25918# 0.55763f
C173 iovdd s2d_block_0.s2d_tails_hi_f_0.vbp 75.9722f
C174 a_14374_25782# a_11844_26734# 0.02713f
C175 outn s2d_block_0.s2d_tails_hi_f_0.vbp 0.1235f
C176 s2d_block_0.s2d_casc_n_f_0.x s2d_block_0.s2d_tails_lo_f_0.sa_F2 0.14813f
C177 s2d_block_0.s2d_tails_lo_f_0.sa_F1 s2d_block_0.s2d_tails_lo_f_0.sb_A2 0.75594f
C178 s2d_block_0.s2d_tails_lo_f_0.sb_A1 s2d_block_0.s2d_casc_n_f_0.y 0.19341f
C179 a_11844_26870# a_11844_27006# 0.63642f
C180 pad s2d_block_0.s2d_casc_n_f_0.yc 0.03716f
C181 s2d_block_0.s2d_loads_f_0.vcmfb s2d_block_0.s2d_loads_f_0.ln 1.84165f
C182 s2d_block_0.s2d_casc_n_f_0.yc s2d_block_0.s2d_casc_n_f_0.vbnc 1.57285f
C183 s2d_block_0.s2d_loads_f_0.vcmfb s2d_block_0.s2d_casc_p_f_0.vbpc 2.28139f
C184 a_7760_4632# Clamp_N_M1_0.gate 0.02705f
C185 s2d_block_0.s2d_tails_hi_f_0.vbp s2d_block_0.s2d_tails_hi_f_0.sa_M1 0.24813f
C186 vcm en_3v3_b 1.42417f
C187 s2d_block_0.s2d_tails_hi_f_0.sa_A1 s2d_block_0.s2d_tails_lo_f_0.sb_A1 0.27455f
C188 a_11844_27142# s2d_block_0.s2d_tails_hi_f_0.sb_F2 0.02238f
C189 vdd s2d_block_0.s2d_casc_n_f_0.yc 0.02686f
C190 outp en_3v3_b 0.21472f
C191 vref s2d_block_0.s2d_casc_n_f_0.x 1.29464f
C192 a_11758_26462# s2d_block_0.s2d_tails_lo_f_0.sb_A2 0.04736f
C193 a_11844_28502# a_11844_28638# 0.63642f
C194 a_11844_27958# s2d_block_0.s2d_tails_lo_f_0.sb_M1 0.02375f
C195 s2d_block_0.s2d_tails_hi_f_0.sb_M2 s2d_block_0.s2d_tails_hi_f_0.sb_F2 0.03186f
C196 s2d_block_0.s2d_casc_p_f_0.vbpc s2d_block_0.bias_tree_noab_n_c3_0.ni 0.57492f
C197 a_11844_26462# s2d_block_0.s2d_tails_hi_f_0.sa_M1 0.01272f
C198 a_11844_25782# s2d_block_0.s2d_tails_hi_f_0.sa_A2 0.04197f
C199 s2d_block_0.s2d_tails_lo_f_0.sa_F1 s2d_block_0.s2d_casc_n_f_0.x 0.16251f
C200 pad s2d_block_0.s2d_tails_hi_f_0.sa_A2 2.82194f
C201 s2d_block_0.s2d_casc_p_f_0.vbpc s2d_block_0.s2d_tails_hi_f_0.sb_F2 0.02121f
C202 a_14374_25646# a_14374_25510# 1.23642f
C203 a_11844_27142# a_11758_27006# 0.01971f
C204 s2d_block_0.s2d_casc_n_f_0.yc s2d_block_0.sinks_6x6_s2d_c3_core_0.vbn 6.17244f
C205 a_11758_26870# a_11758_26734# 0.55763f
C206 pad Clamp_P_M1_0.gate 19.5174f
C207 vcm s2d_block_0.s2d_tails_lo_f_0.sb_M1 2.76676f
C208 s2d_block_0.s2d_tails_lo_f_0.sa_M2 s2d_block_0.sinks_6x6_s2d_c3_core_0.vbn 0.05689f
C209 pad iovdd 39.7827f
C210 pad outn 0.04621f
C211 s2d_block_0.s2d_tails_hi_f_0.sa_A1 s2d_block_0.s2d_tails_hi_f_0.sb_M2 0.38962f
C212 s2d_block_0.s2d_casc_n_f_0.yc s2d_block_0.s2d_casc_n_f_0.xc 10.4448f
C213 outp s2d_block_0.s2d_tails_lo_f_0.sb_M1 0.02431f
C214 vdd s2d_block_0.s2d_tails_hi_f_0.sa_A2 0.10246f
C215 a_14374_26190# a_11844_26190# 0.02746f
C216 s2d_block_0.s2d_tails_hi_f_0.sb_F1 s2d_block_0.s2d_tails_hi_f_0.sb_F2 0.56257f
C217 s2d_block_0.s2d_tails_lo_f_0.sb_A1 a_11844_28638# 0.02257f
C218 s2d_block_0.s2d_tails_lo_f_0.sa_M2 s2d_block_0.s2d_casc_n_f_0.xc 0.81808f
C219 iovdd s2d_block_0.s2d_casc_n_f_0.vbnc 14.3126f
C220 iovdd a_14374_25646# 0.01766f
C221 outn s2d_block_0.s2d_casc_n_f_0.vbnc 9.71317f
C222 s2d_block_0.s2d_casc_n_f_0.y s2d_block_0.s2d_tails_hi_f_0.sb_F1 0.14483f
C223 s2d_block_0.s2d_tails_hi_f_0.sa_A1 s2d_block_0.s2d_casc_p_f_0.vbpc 1.34004f
C224 pad s2d_block_0.s2d_tails_hi_f_0.sa_M1 0.07254f
C225 s2d_block_0.s2d_loads_f_0.vcmfb s2d_block_0.s2d_casc_n_f_0.yc 0.23125f
C226 s2d_block_0.s2d_tails_lo_f_0.sb_M1 s2d_block_0.s2d_tails_lo_f_0.sb_A2 3.42454f
C227 iovdd vdd 5.0684f
C228 a_11844_28366# s2d_block_0.s2d_tails_hi_f_0.sb_F2 0.04247f
C229 outn vdd 4.432f
C230 a_11844_28502# s2d_block_0.s2d_tails_lo_f_0.sb_A2 0.02849f
C231 a_11844_25918# s2d_block_0.s2d_tails_lo_f_0.sa_F2 0.11478f
C232 a_14374_25510# s2d_block_0.sinks_6x6_s2d_c3_core_0.vbn 0.0115f
C233 pad s2d_block_0.s2d_tails_hi_f_0.vbp 1.16149f
C234 s2d_block_0.s2d_tails_hi_f_0.sa_A1 s2d_block_0.s2d_tails_hi_f_0.sb_F1 0.68676f
C235 a_11844_26054# s2d_block_0.s2d_tails_hi_f_0.sb_F2 0.02158f
C236 a_11844_26598# s2d_block_0.s2d_tails_hi_f_0.sb_F2 0.02183f
C237 s2d_block_0.s2d_tails_hi_f_0.vbp s2d_block_0.s2d_casc_n_f_0.vbnc 4.06264f
C238 outp s2d_block_0.s2d_tails_lo_f_0.sb_A1 0.03836f
C239 vdd s2d_block_0.s2d_tails_hi_f_0.sa_M1 0.10508f
C240 a_11844_27278# a_11844_27414# 0.63642f
C241 en_3v3 vcm 0.12306f
C242 a_11844_27550# a_11758_26598# 0.01938f
C243 a_11758_26462# a_11758_26326# 1.23642f
C244 iovdd s2d_block_0.sinks_6x6_s2d_c3_core_0.vbn 18.5068f
C245 outn s2d_block_0.sinks_6x6_s2d_c3_core_0.vbn 0.02952f
C246 s2d_block_0.s2d_casc_n_f_0.yc s2d_block_0.s2d_tails_hi_f_0.sb_F2 0.03658f
C247 a_11844_27958# s2d_block_0.s2d_tails_hi_f_0.sb_M2 0.01935f
C248 en_3v3 outp 0.08032f
C249 vdd s2d_block_0.s2d_tails_hi_f_0.vbp 4.07095f
C250 vref s2d_block_0.s2d_tails_lo_f_0.sa_F2 0.19414f
C251 s2d_block_0.s2d_tails_lo_f_0.sa_M2 s2d_block_0.s2d_tails_hi_f_0.sb_F2 0.03901f
C252 s2d_block_0.s2d_casc_n_f_0.yc s2d_block_0.s2d_casc_n_f_0.y 0.33719f
C253 iovdd s2d_block_0.s2d_casc_n_f_0.xc 7.38042f
C254 outn s2d_block_0.s2d_casc_n_f_0.xc 0.5833f
C255 a_11844_27822# vdd 0.02082f
C256 s2d_block_0.s2d_tails_lo_f_0.sb_A1 s2d_block_0.s2d_tails_lo_f_0.sb_A2 2.4348f
C257 s2d_block_0.s2d_tails_lo_f_0.sa_F1 s2d_block_0.s2d_tails_lo_f_0.sa_F2 0.55194f
C258 s2d_block_0.s2d_loads_f_0.dd s2d_block_0.s2d_loads_f_0.ln 12.8616f
C259 a_11844_25510# a_11844_25646# 0.63642f
C260 vcm s2d_block_0.s2d_tails_hi_f_0.sb_M2 3.34892f
C261 s2d_block_0.s2d_loads_f_0.dd s2d_block_0.s2d_casc_p_f_0.vbpc 1.63073f
C262 iovdd s2d_block_0.s2d_loads_f_0.vcmfb 46.3232f
C263 outn s2d_block_0.s2d_loads_f_0.vcmfb 4.70815f
C264 s2d_block_0.s2d_casc_n_f_0.xc s2d_block_0.s2d_tails_hi_f_0.sa_M1 0.19353f
C265 s2d_block_0.s2d_tails_hi_f_0.sa_A1 s2d_block_0.s2d_casc_n_f_0.yc 0.04876f
C266 s2d_block_0.s2d_tails_hi_f_0.vbp s2d_block_0.sinks_6x6_s2d_c3_core_0.vbn 1.69032f
C267 s2d_block_0.s2d_tails_hi_f_0.sa_A1 s2d_block_0.s2d_tails_lo_f_0.sa_M2 0.05749f
C268 s2d_block_0.s2d_tails_hi_f_0.sa_A2 s2d_block_0.s2d_tails_hi_f_0.sb_F2 0.06194f
C269 s2d_block_0.s2d_casc_n_f_0.xc s2d_block_0.s2d_tails_hi_f_0.vbp 0.03022f
C270 outp s2d_block_0.s2d_loads_f_0.ln 0.02981f
C271 s2d_block_0.s2d_casc_n_f_0.y s2d_block_0.s2d_tails_hi_f_0.sa_A2 1.08118f
C272 vref s2d_block_0.s2d_tails_lo_f_0.sa_F1 0.06427f
C273 outp s2d_block_0.s2d_casc_p_f_0.vbpc 1.4341f
C274 a_11758_26598# s2d_block_0.s2d_tails_lo_f_0.sb_A2 0.04764f
C275 iovdd s2d_block_0.bias_tree_noab_n_c3_0.ni 0.16822f
C276 a_11844_26326# s2d_block_0.s2d_tails_hi_f_0.sa_M1 0.01913f
C277 a_11844_27686# a_11844_27822# 0.63642f
C278 a_14374_27822# a_11844_27958# 0.02746f
C279 s2d_block_0.s2d_tails_lo_f_0.sb_A1 s2d_block_0.s2d_casc_n_f_0.x 1.08004f
C280 s2d_block_0.s2d_tails_hi_f_0.sb_M2 s2d_block_0.s2d_tails_lo_f_0.sb_A2 0.05301f
C281 a_11844_28094# a_11844_28230# 0.63642f
C282 pad s2d_block_0.s2d_casc_n_f_0.vbnc 12.4429f
C283 iovdd s2d_block_0.s2d_tails_hi_f_0.sb_F2 6.03352f
C284 vcm s2d_block_0.s2d_tails_hi_f_0.sb_F1 0.02843f
C285 outn s2d_block_0.s2d_tails_hi_f_0.sb_F2 0.05986f
C286 s2d_block_0.s2d_casc_p_f_0.vbpc s2d_block_0.s2d_tails_lo_f_0.sb_A2 0.02874f
C287 iovdd s2d_block_0.s2d_casc_n_f_0.y 11.5898f
C288 outn s2d_block_0.s2d_casc_n_f_0.y 0.87677f
C289 a_11844_27142# a_11844_27006# 0.63642f
C290 s2d_block_0.s2d_tails_hi_f_0.sa_A1 s2d_block_0.s2d_tails_hi_f_0.sa_A2 2.49686f
C291 outp s2d_block_0.s2d_tails_hi_f_0.sb_F1 4.17044f
C292 pad vdd 0.09566f
C293 iovdd a_14374_27278# 0.01766f
C294 vdd s2d_block_0.s2d_casc_n_f_0.vbnc 2.31537f
C295 a_11844_26054# a_11844_26190# 0.63642f
C296 s2d_block_0.bias_tree_noab_n_c3_0.ni s2d_block_0.s2d_tails_hi_f_0.vbp 0.46375f
C297 s2d_block_0.s2d_tails_hi_f_0.sa_M1 s2d_block_0.s2d_tails_hi_f_0.sb_F2 0.02897f
C298 a_11844_26326# a_11844_26462# 0.63642f
C299 iovdd a_14374_25782# 0.012f
C300 s2d_block_0.s2d_tails_lo_f_0.sb_A2 s2d_block_0.s2d_tails_hi_f_0.sb_F1 0.34054f
C301 a_11758_26326# s2d_block_0.s2d_tails_lo_f_0.sb_A1 0.05685f
C302 s2d_block_0.s2d_tails_hi_f_0.sa_A1 iovdd 1.02088f
C303 s2d_block_0.s2d_tails_hi_f_0.sa_A1 outn 0.03031f
C304 s2d_block_0.s2d_tails_hi_f_0.vbp s2d_block_0.s2d_tails_hi_f_0.sb_F2 0.45545f
C305 vref en_3v3_b 3.42268f
C306 s2d_block_0.s2d_tails_hi_f_0.vbp s2d_block_0.s2d_casc_n_f_0.y 0.16277f
C307 s2d_block_0.s2d_tails_lo_f_0.sb_M1 s2d_block_0.s2d_tails_lo_f_0.sa_F2 0.02026f
C308 s2d_block_0.s2d_loads_f_0.dd s2d_block_0.s2d_casc_n_f_0.yc 0.20626f
C309 a_11844_27822# s2d_block_0.s2d_tails_hi_f_0.sb_F2 0.02771f
C310 a_11844_28230# s2d_block_0.s2d_tails_hi_f_0.sb_F2 0.1402f
C311 a_11844_26190# s2d_block_0.s2d_tails_lo_f_0.sa_M2 0.01935f
C312 a_11844_28366# s2d_block_0.s2d_tails_lo_f_0.sb_A2 0.01228f
C313 a_11844_28502# s2d_block_0.s2d_tails_lo_f_0.sa_F2 0.02158f
C314 s2d_block_0.sinks_6x6_s2d_c3_core_0.vbn s2d_block_0.s2d_casc_n_f_0.vbnc 0.04762f
C315 pad s2d_block_0.s2d_casc_n_f_0.xc 0.03568f
C316 vcm s2d_block_0.s2d_casc_n_f_0.yc 0.28624f
C317 a_14374_27686# a_14374_27550# 0.55763f
C318 a_14374_27414# a_11844_28366# 0.02713f
C319 s2d_block_0.s2d_tails_hi_f_0.sa_A1 s2d_block_0.s2d_tails_hi_f_0.sa_M1 0.11601f
C320 vcm s2d_block_0.s2d_tails_lo_f_0.sa_M2 0.01518f
C321 a_11844_26462# s2d_block_0.s2d_tails_hi_f_0.sb_F2 0.02158f
C322 a_11844_28638# s2d_block_0.s2d_tails_hi_f_0.sa_A2 0.01297f
C323 s2d_block_0.s2d_casc_n_f_0.xc s2d_block_0.s2d_casc_n_f_0.vbnc 2.58001f
C324 outp s2d_block_0.s2d_casc_n_f_0.yc 0.95108f
C325 s2d_block_0.s2d_tails_hi_f_0.sa_A1 s2d_block_0.s2d_tails_hi_f_0.vbp 0.27068f
C326 outp s2d_block_0.s2d_tails_lo_f_0.sa_M2 0.10643f
C327 vdd s2d_block_0.sinks_6x6_s2d_c3_core_0.vbn 1.9456f
C328 s2d_block_0.s2d_casc_n_f_0.x s2d_block_0.s2d_tails_hi_f_0.sb_F1 1.19998f
C329 a_11758_26326# s2d_block_0.s2d_tails_hi_f_0.sb_M2 0.26248f
C330 vref s2d_block_0.s2d_tails_lo_f_0.sb_M1 0.07443f
C331 vdd s2d_block_0.s2d_casc_n_f_0.xc 0.0268f
C332 s2d_block_0.s2d_loads_f_0.vcmfb s2d_block_0.s2d_casc_n_f_0.vbnc 2.71351f
C333 s2d_block_0.s2d_casc_n_f_0.yc s2d_block_0.s2d_tails_lo_f_0.sb_A2 0.04795f
C334 a_14374_26190# a_14374_26054# 0.33426f
C335 vref iref 0.02575f
C336 a_14374_25918# a_11844_26598# 0.02719f
C337 a_11844_27686# vdd 0.0197f
C338 a_11844_26734# a_11844_26870# 0.63642f
C339 s2d_block_0.s2d_tails_lo_f_0.sa_F1 s2d_block_0.s2d_tails_lo_f_0.sb_M1 1.00895f
C340 s2d_block_0.s2d_tails_lo_f_0.sa_M2 s2d_block_0.s2d_tails_lo_f_0.sb_A2 0.18932f
C341 s2d_block_0.s2d_tails_lo_f_0.sb_A1 s2d_block_0.s2d_tails_lo_f_0.sa_F2 0.25648f
C342 vcm s2d_block_0.s2d_tails_hi_f_0.sa_A2 0.02927f
C343 a_11844_25782# s2d_block_0.s2d_tails_hi_f_0.sb_F2 0.02723f
C344 iovdd s2d_block_0.s2d_loads_f_0.dd 11.3424f
C345 outn s2d_block_0.s2d_loads_f_0.dd 0.03812f
C346 s2d_block_0.bias_tree_noab_n_c3_0.ni s2d_block_0.s2d_casc_n_f_0.vbnc 0.01097f
C347 a_11844_28774# s2d_block_0.s2d_tails_hi_f_0.sa_A2 0.0152f
C348 s2d_block_0.s2d_casc_n_f_0.xc s2d_block_0.sinks_6x6_s2d_c3_core_0.vbn 7.63066f
C349 pad s2d_block_0.s2d_tails_hi_f_0.sb_F2 0.16346f
C350 a_11844_27142# a_14374_27142# 0.02707f
C351 pad s2d_block_0.s2d_casc_n_f_0.y 3.1649f
C352 vcm iovdd 7.80763f
C353 vcm outn 9.45068f
C354 s2d_block_0.s2d_casc_n_f_0.y s2d_block_0.s2d_casc_n_f_0.vbnc 1.97858f
C355 s2d_block_0.s2d_tails_lo_f_0.sb_A2 s2d_block_0.s2d_tails_hi_f_0.sa_A2 0.1185f
C356 vdd s2d_block_0.bias_tree_noab_n_c3_0.ni 1.76501f
C357 a_11844_25374# a_11844_25510# 0.63642f
C358 vref s2d_block_0.s2d_tails_lo_f_0.sb_A1 2.83327f
C359 a_11758_26734# s2d_block_0.s2d_tails_lo_f_0.sb_A2 0.04787f
C360 iovdd outp 14.7872f
C361 outn outp 7.48996f
C362 s2d_block_0.s2d_casc_n_f_0.yc s2d_block_0.s2d_casc_n_f_0.x 5.29006f
C363 s2d_block_0.s2d_loads_f_0.vcmfb s2d_block_0.sinks_6x6_s2d_c3_core_0.vbn 0.04213f
C364 a_11844_26190# s2d_block_0.s2d_tails_hi_f_0.sa_M1 0.03964f
C365 a_14374_25782# a_11844_25782# 0.02713f
C366 a_11844_27822# a_11844_27958# 0.63642f
C367 s2d_block_0.s2d_tails_lo_f_0.sb_A1 s2d_block_0.s2d_tails_lo_f_0.sa_F1 0.25712f
C368 s2d_block_0.s2d_tails_hi_f_0.sb_M2 s2d_block_0.s2d_tails_lo_f_0.sa_F2 0.2626f
C369 vdd s2d_block_0.s2d_tails_hi_f_0.sb_F2 0.10958f
C370 vref en_3v3 0.29868f
C371 s2d_block_0.s2d_tails_hi_f_0.sa_A1 pad 2.83737f
C372 s2d_block_0.s2d_loads_f_0.vcmfb s2d_block_0.s2d_casc_n_f_0.xc 0.32881f
C373 vcm s2d_block_0.s2d_tails_hi_f_0.sa_M1 0.03993f
C374 a_11844_25374# s2d_block_0.s2d_tails_lo_f_0.sb_M1 0.01618f
C375 vdd s2d_block_0.s2d_casc_n_f_0.y 0.04859f
C376 iref en_3v3_b 1.53723f
C377 s2d_block_0.s2d_casc_p_f_0.vbpc s2d_block_0.s2d_tails_lo_f_0.sa_F2 0.03272f
C378 iovdd s2d_block_0.s2d_tails_lo_f_0.sb_A2 1.6506f
C379 a_14374_25782# a_14374_25646# 1.00966f
C380 outn s2d_block_0.s2d_tails_lo_f_0.sb_A2 0.02396f
C381 a_14374_25510# a_11844_27006# 0.02707f
C382 a_11758_27006# a_11758_26870# 0.33426f
C383 outp s2d_block_0.s2d_tails_hi_f_0.sa_M1 2.77025f
C384 iovdd a_14374_27414# 0.012f
C385 vcm s2d_block_0.s2d_tails_hi_f_0.vbp 0.35492f
C386 outp s2d_block_0.s2d_tails_hi_f_0.vbp 0.13321f
C387 a_11844_25510# s2d_block_0.s2d_tails_lo_f_0.sb_M1 0.01476f
C388 s2d_block_0.sinks_6x6_s2d_c3_core_0.vbn s2d_block_0.s2d_tails_hi_f_0.sb_F2 2.97635f
C389 s2d_block_0.s2d_tails_hi_f_0.sa_A1 vdd 0.10518f
C390 s2d_block_0.s2d_loads_f_0.lp s2d_block_0.s2d_loads_f_0.ln 6.36668f
C391 s2d_block_0.s2d_casc_n_f_0.y s2d_block_0.sinks_6x6_s2d_c3_core_0.vbn 10.5813f
C392 s2d_block_0.s2d_casc_n_f_0.x s2d_block_0.s2d_tails_hi_f_0.sa_A2 0.19257f
C393 s2d_block_0.s2d_tails_lo_f_0.sa_F2 s2d_block_0.s2d_tails_hi_f_0.sb_F1 0.06213f
C394 s2d_block_0.s2d_tails_lo_f_0.sb_A2 s2d_block_0.s2d_tails_hi_f_0.sa_M1 0.04471f
C395 vref s2d_block_0.s2d_tails_hi_f_0.sb_M2 0.14065f
C396 s2d_block_0.s2d_loads_f_0.lp s2d_block_0.s2d_casc_p_f_0.vbpc 1.82865f
C397 a_11758_26462# s2d_block_0.s2d_tails_lo_f_0.sb_A1 0.02995f
C398 a_11758_26326# s2d_block_0.s2d_tails_lo_f_0.sa_M2 0.26248f
C399 s2d_block_0.s2d_casc_n_f_0.xc s2d_block_0.s2d_tails_hi_f_0.sb_F2 0.9746f
C400 s2d_block_0.s2d_tails_hi_f_0.vbp s2d_block_0.s2d_tails_lo_f_0.sb_A2 0.25264f
C401 s2d_block_0.s2d_casc_n_f_0.xc s2d_block_0.s2d_casc_n_f_0.y 5.73376f
C402 a_11844_27686# s2d_block_0.s2d_tails_hi_f_0.sb_F2 0.02495f
C403 a_8120_4634# a_7760_4632# 0.05849f
C404 a_11844_28094# s2d_block_0.s2d_tails_hi_f_0.sb_F2 0.06483f
C405 vref s2d_block_0.s2d_casc_p_f_0.vbpc 0.09301f
C406 a_11844_28366# s2d_block_0.s2d_tails_lo_f_0.sa_F2 0.02158f
C407 s2d_block_0.s2d_casc_p_f_0.vbpc s2d_block_0.s2d_tails_lo_f_0.sa_F1 0.0612f
C408 iovdd s2d_block_0.s2d_casc_n_f_0.x 8.76917f
C409 outn s2d_block_0.s2d_casc_n_f_0.x 0.03241f
C410 s2d_block_0.s2d_tails_hi_f_0.sa_A1 s2d_block_0.sinks_6x6_s2d_c3_core_0.vbn 0.12097f
C411 en_3v3 en_3v3_b 0.17956f
C412 a_11844_26326# s2d_block_0.s2d_tails_hi_f_0.sb_F2 0.02158f
C413 a_11844_25646# s2d_block_0.s2d_tails_hi_f_0.sa_A2 0.08226f
C414 a_11844_26054# s2d_block_0.s2d_tails_lo_f_0.sa_F2 0.02708f
C415 s2d_block_0.s2d_loads_f_0.vcmfb s2d_block_0.s2d_casc_n_f_0.y 0.15223f
C416 s2d_block_0.s2d_tails_hi_f_0.sa_A1 s2d_block_0.s2d_casc_n_f_0.xc 0.0776f
C417 vref s2d_block_0.s2d_tails_hi_f_0.sb_F1 0.27891f
C418 a_11844_27142# a_11844_27278# 0.63642f
C419 a_11844_27414# a_11758_26734# 0.01944f
C420 a_11844_26054# a_11844_25918# 0.63642f
C421 a_11758_26598# a_11758_26462# 1.00966f
C422 s2d_block_0.s2d_casc_n_f_0.yc s2d_block_0.s2d_tails_lo_f_0.sa_F2 0.01488f
C423 a_11844_26054# a_14374_26054# 0.02728f
C424 pad vcm 0.33417f
C425 a_11844_27550# vdd 0.01806f
C426 s2d_block_0.s2d_casc_n_f_0.x s2d_block_0.s2d_tails_hi_f_0.vbp 0.88785f
C427 s2d_block_0.s2d_tails_lo_f_0.sa_M2 s2d_block_0.s2d_tails_lo_f_0.sa_F2 0.03184f
C428 s2d_block_0.s2d_tails_lo_f_0.sb_A1 s2d_block_0.s2d_tails_lo_f_0.sb_M1 0.42502f
C429 pad outp 5.74492f
C430 vcm s2d_block_0.s2d_casc_n_f_0.vbnc 0.01971f
C431 s2d_block_0.s2d_casc_n_f_0.y s2d_block_0.s2d_tails_hi_f_0.sb_F2 0.26538f
C432 en_3v3 iref 0.23216f
C433 iovdd Clamp_N_M1_0.gate 0.31292f
C434 outp s2d_block_0.s2d_casc_n_f_0.vbnc 10.0705f
C435 s2d_block_0.s2d_loads_f_0.lp s2d_block_0.s2d_casc_n_f_0.yc 0.89259f
C436 a_14374_25510# a_14374_27142# 0.27561f
C437 vcm vdd 1.87232f
C438 iovdd a_7760_4632# 0.04371f
C439 vref s2d_block_0.s2d_casc_n_f_0.yc 0.12653f
C440 outp vdd 4.08914f
C441 s2d_block_0.s2d_tails_hi_f_0.sa_A1 s2d_block_0.s2d_tails_hi_f_0.sb_F2 0.38523f
C442 s2d_block_0.s2d_tails_lo_f_0.sa_F2 s2d_block_0.s2d_tails_hi_f_0.sa_A2 0.64797f
C443 vref s2d_block_0.s2d_tails_lo_f_0.sa_M2 0.07292f
C444 a_11758_26870# s2d_block_0.s2d_tails_lo_f_0.sb_A2 0.04798f
C445 s2d_block_0.s2d_casc_n_f_0.yc s2d_block_0.s2d_tails_lo_f_0.sa_F1 0.03413f
C446 s2d_block_0.s2d_loads_f_0.dd s2d_block_0.sinks_6x6_s2d_c3_core_0.vbn 0.01271f
C447 s2d_block_0.s2d_tails_hi_f_0.sa_A1 s2d_block_0.s2d_casc_n_f_0.y 1.23587f
C448 iovdd a_14374_27142# 0.02823f
C449 a_11844_27550# a_11844_27686# 0.63642f
C450 a_11844_25918# s2d_block_0.s2d_tails_hi_f_0.sa_A2 0.01081f
C451 a_11844_27822# a_11758_26326# 0.01932f
C452 s2d_block_0.s2d_tails_hi_f_0.sb_M2 s2d_block_0.s2d_tails_lo_f_0.sb_M1 0.32756f
C453 s2d_block_0.s2d_tails_lo_f_0.sa_M2 s2d_block_0.s2d_tails_lo_f_0.sa_F1 1.57654f
C454 a_11844_27958# a_11844_28094# 0.63642f
C455 iovdd s2d_block_0.s2d_tails_lo_f_0.sa_F2 3.0746f
C456 s2d_block_0.s2d_casc_p_f_0.vbpc s2d_block_0.s2d_tails_lo_f_0.sb_M1 0.02091f
C457 outn s2d_block_0.s2d_tails_lo_f_0.sa_F2 2.96064f
C458 outp s2d_block_0.sinks_6x6_s2d_c3_core_0.vbn 0.03137f
C459 iref s2d_block_0.s2d_casc_p_f_0.vbpc 0.22924f
C460 vcm s2d_block_0.s2d_casc_n_f_0.xc 1.30615f
C461 pad s2d_block_0.s2d_casc_n_f_0.x 0.10623f
C462 s2d_block_0.s2d_loads_f_0.dd s2d_block_0.s2d_loads_f_0.vcmfb 1.69244f
C463 vref s2d_block_0.s2d_tails_hi_f_0.sa_A2 0.02925f
C464 outp s2d_block_0.s2d_casc_n_f_0.xc 0.41632f
C465 a_11844_26190# a_11844_26326# 0.63642f
C466 vdd a_11844_27006# 0.01077f
C467 s2d_block_0.s2d_casc_n_f_0.x s2d_block_0.s2d_casc_n_f_0.vbnc 3.02607f
C468 s2d_block_0.s2d_tails_lo_f_0.sa_F2 s2d_block_0.s2d_tails_hi_f_0.sa_M1 5.13302f
C469 s2d_block_0.s2d_tails_lo_f_0.sa_F1 s2d_block_0.s2d_tails_hi_f_0.sa_A2 0.31556f
C470 s2d_block_0.s2d_tails_lo_f_0.sb_A2 s2d_block_0.sinks_6x6_s2d_c3_core_0.vbn 0.1341f
C471 iovdd s2d_block_0.s2d_loads_f_0.lp 9.48528f
C472 a_11758_26598# s2d_block_0.s2d_tails_lo_f_0.sb_A1 0.01794f
C473 outn s2d_block_0.s2d_loads_f_0.lp 0.10812f
C474 s2d_block_0.s2d_tails_hi_f_0.sb_M2 s2d_block_0.s2d_tails_lo_f_0.sb_A1 0.08819f
C475 a_11844_27550# s2d_block_0.s2d_tails_hi_f_0.sb_F2 0.0237f
C476 s2d_block_0.s2d_tails_hi_f_0.vbp s2d_block_0.s2d_tails_lo_f_0.sa_F2 0.24847f
C477 s2d_block_0.s2d_casc_n_f_0.xc s2d_block_0.s2d_tails_lo_f_0.sb_A2 0.11316f
C478 a_11844_27958# s2d_block_0.s2d_tails_hi_f_0.sb_F2 0.03529f
C479 outp s2d_block_0.s2d_loads_f_0.vcmfb 12.9821f
C480 vref iovdd 0.94237f
C481 vref outn 5.90972f
C482 vdd s2d_block_0.s2d_casc_n_f_0.x 0.04841f
C483 a_11844_25782# a_11844_25646# 0.63642f
C484 s2d_block_0.s2d_casc_p_f_0.vbpc s2d_block_0.s2d_tails_lo_f_0.sb_A1 1.20865f
C485 iovdd s2d_block_0.s2d_tails_lo_f_0.sa_F1 3.78604f
C486 outn s2d_block_0.s2d_tails_lo_f_0.sa_F1 0.02403f
C487 a_14374_27822# a_14374_27686# 0.33426f
C488 a_14374_27550# a_11844_28230# 0.02719f
C489 a_11844_28366# a_11844_28502# 0.63642f
C490 a_11844_26190# s2d_block_0.s2d_tails_hi_f_0.sb_F2 0.02158f
C491 a_14374_25646# a_11844_25646# 0.0271f
C492 en_3v3 s2d_block_0.s2d_casc_p_f_0.vbpc 0.11347f
C493 vref s2d_block_0.s2d_tails_hi_f_0.sa_M1 0.02889f
C494 vcm s2d_block_0.s2d_tails_hi_f_0.sb_F2 3.14225f
C495 pad Clamp_N_M1_0.gate 7.47115f
C496 vcm s2d_block_0.s2d_casc_n_f_0.y 0.63544f
C497 s2d_block_0.s2d_tails_lo_f_0.sb_A1 s2d_block_0.s2d_tails_hi_f_0.sb_F1 0.07599f
C498 s2d_block_0.s2d_casc_n_f_0.x s2d_block_0.sinks_6x6_s2d_c3_core_0.vbn 11.6323f
C499 outp s2d_block_0.s2d_tails_hi_f_0.sb_F2 0.07024f
C500 vref s2d_block_0.s2d_tails_hi_f_0.vbp 0.32711f
C501 Clamp_N_M1_0.gate s2d_block_0.s2d_casc_n_f_0.vbnc 0.01062f
C502 s2d_block_0.s2d_casc_n_f_0.yc s2d_block_0.s2d_tails_lo_f_0.sb_M1 0.25635f
C503 outp s2d_block_0.s2d_casc_n_f_0.y 0.19269f
C504 a_14374_26054# a_11844_26462# 0.02728f
C505 a_11844_27414# vdd 0.01616f
C506 en_3v3 s2d_block_0.s2d_tails_hi_f_0.sb_F1 0.20957f
C507 a_11844_26598# a_11844_26734# 0.63642f
C508 vdd a_11758_26326# 0.01425f
C509 s2d_block_0.s2d_tails_lo_f_0.sa_F1 s2d_block_0.s2d_tails_hi_f_0.vbp 0.24852f
C510 s2d_block_0.s2d_tails_lo_f_0.sa_M2 s2d_block_0.s2d_tails_lo_f_0.sb_M1 0.28167f
C511 s2d_block_0.s2d_casc_n_f_0.x s2d_block_0.s2d_casc_n_f_0.xc 0.34889f
C512 s2d_block_0.s2d_tails_lo_f_0.sb_A2 s2d_block_0.s2d_tails_hi_f_0.sb_F2 0.66896f
C513 s2d_block_0.s2d_casc_p_f_0.vbpc s2d_block_0.s2d_tails_hi_f_0.sb_M2 0.03287f
C514 s2d_block_0.s2d_tails_hi_f_0.sa_A1 vcm 0.04051f
C515 s2d_block_0.s2d_tails_lo_f_0.sb_A2 s2d_block_0.s2d_casc_n_f_0.y 0.32677f
C516 iovdd en_3v3_b 1.22713f
C517 s2d_block_0.s2d_loads_f_0.ln s2d_block_0.s2d_casc_p_f_0.vbpc 1.72179f
C518 outn en_3v3_b 0.35641f
C519 a_11844_25510# s2d_block_0.s2d_tails_hi_f_0.sa_A2 0.02242f
C520 s2d_block_0.s2d_loads_f_0.vcmfb s2d_block_0.s2d_casc_n_f_0.x 0.26198f
C521 a_14374_25510# a_11844_25510# 0.02707f
C522 s2d_block_0.s2d_tails_hi_f_0.sa_A1 outp 0.14921f
C523 a_11844_25782# s2d_block_0.s2d_tails_lo_f_0.sa_F2 0.03632f
C524 pad s2d_block_0.s2d_tails_lo_f_0.sa_F2 0.27985f
C525 a_14374_27414# a_14374_27278# 1.00966f
C526 a_11844_25782# a_11844_25918# 0.63642f
C527 a_11844_27006# s2d_block_0.s2d_tails_hi_f_0.sb_F2 0.02221f
C528 s2d_block_0.s2d_tails_hi_f_0.sb_M2 s2d_block_0.s2d_tails_hi_f_0.sb_F1 1.52485f
C529 s2d_block_0.s2d_tails_lo_f_0.sb_M1 s2d_block_0.s2d_tails_hi_f_0.sa_A2 1.27636f
C530 a_11758_27006# s2d_block_0.s2d_tails_lo_f_0.sb_A2 0.0467f
C531 Clamp_N_M1_0.gate s2d_block_0.sinks_6x6_s2d_c3_core_0.vbn 0.02015f
C532 s2d_block_0.s2d_casc_n_f_0.yc s2d_block_0.s2d_tails_lo_f_0.sb_A1 0.3272f
C533 s2d_block_0.s2d_tails_hi_f_0.sa_A1 s2d_block_0.s2d_tails_lo_f_0.sb_A2 0.02919f
C534 a_11844_28502# s2d_block_0.s2d_tails_hi_f_0.sa_A2 0.01142f
C535 s2d_block_0.s2d_tails_lo_f_0.sa_M2 s2d_block_0.s2d_tails_lo_f_0.sb_A1 0.21024f
C536 s2d_block_0.s2d_casc_p_f_0.vbpc s2d_block_0.s2d_tails_hi_f_0.sb_F1 0.1427f
C537 en_3v3_b s2d_block_0.s2d_tails_hi_f_0.vbp 1.1167f
C538 vdd s2d_block_0.s2d_tails_lo_f_0.sa_F2 0.02196f
C539 iref iovss 2.84041f
C540 vdd iovss 0.20787p
C541 s2d_block_0.s2d_loads_f_0.dd iovss 3.53484f
C542 s2d_block_0.s2d_loads_f_0.ln iovss 9.8759f
C543 s2d_block_0.s2d_loads_f_0.lp iovss 6.0795f
C544 a_14374_26190# iovss 1.16634f
C545 a_14374_26054# iovss 1.29284f
C546 a_14374_25918# iovss 1.3963f
C547 a_14374_25782# iovss 1.46396f
C548 a_14374_25646# iovss 1.47901f
C549 a_14374_25510# iovss 2.6658f
C550 a_11758_27006# iovss 1.03059f
C551 a_11758_26870# iovss 1.10629f
C552 a_11758_26734# iovss 1.2129f
C553 a_11758_26598# iovss 1.31805f
C554 a_11758_26462# iovss 1.38557f
C555 a_11758_26326# iovss 2.40813f
C556 a_14374_27822# iovss 1.06642f
C557 a_14374_27686# iovss 1.18602f
C558 a_14374_27550# iovss 1.26657f
C559 a_14374_27414# iovss 1.34955f
C560 a_14374_27278# iovss 1.42769f
C561 a_14374_27142# iovss 2.67705f
C562 s2d_block_0.s2d_casc_n_f_0.xc iovss 81.2536f
C563 s2d_block_0.s2d_casc_n_f_0.yc iovss 49.17923f
C564 s2d_block_0.s2d_casc_n_f_0.x iovss 31.30896f
C565 s2d_block_0.s2d_casc_n_f_0.y iovss 32.69825f
C566 s2d_block_0.s2d_tails_lo_f_0.sa_M2 iovss 2.80762f
C567 s2d_block_0.s2d_tails_lo_f_0.sb_M1 iovss 2.97971f
C568 s2d_block_0.s2d_tails_lo_f_0.sb_A1 iovss 4.09079f
C569 s2d_block_0.s2d_tails_lo_f_0.sa_F2 iovss 21.07319f
C570 s2d_block_0.s2d_tails_lo_f_0.sa_F1 iovss 5.91279f
C571 s2d_block_0.s2d_tails_lo_f_0.sb_A2 iovss 9.01883f
C572 s2d_block_0.s2d_tails_hi_f_0.sb_M2 iovss 4.64485f
C573 s2d_block_0.s2d_tails_hi_f_0.sa_M1 iovss 6.04415f
C574 s2d_block_0.s2d_tails_hi_f_0.sa_A2 iovss 4.73024f
C575 s2d_block_0.s2d_tails_hi_f_0.sb_F1 iovss 19.61646f
C576 s2d_block_0.s2d_tails_hi_f_0.sb_F2 iovss 8.49076f
C577 s2d_block_0.s2d_tails_hi_f_0.sa_A1 iovss 7.11202f
.ends
