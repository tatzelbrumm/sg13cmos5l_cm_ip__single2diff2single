* SPDX-FileCopyrightText: 2026 Christoph Maier
* SPDX-License-Identifier: Apache-2.0
* VARIANTS 2026-10-26 (design_considerations/pad_buffer_layout/wells): input-device bulk connection of unit_r2.
* unit_r2_ct: rhigh split in two halves, both input devices' bulks (one shared n-well) on the centre tap c.
* unit_r2_vdd: both input devices' bulks on vdd (they can share the tails' n-well).
* d2s_mpdda_ct / d2s_mpdda_vdd: d2s_mpdda (improvements/sim/d2s_mpdda.spice) with its four units replaced.
.subckt unit_r2_ct x y gp gn vdd vss vbp rl=50.6u
XTa sa vbp vdd vdd sg13_hv_pmos w=5u l=6u ng=1
XTb sb vbp vdd vdd sg13_hv_pmos w=5u l=6u ng=1
XR1 sa c vss rhigh w=0.5u l={rl/2}
XR2 c sb vss rhigh w=0.5u l={rl/2}
XMa y gp sa c sg13_hv_pmos w=20u l=1u ng=2
XMb x gn sb c sg13_hv_pmos w=20u l=1u ng=2
.ends unit_r2_ct
.subckt unit_r2_vdd x y gp gn vdd vss vbp rl=50.6u
XTa sa vbp vdd vdd sg13_hv_pmos w=5u l=6u ng=1
XTb sb vbp vdd vdd sg13_hv_pmos w=5u l=6u ng=1
XR sa sb vss rhigh w=0.5u l={rl}
XMa y gp sa vdd sg13_hv_pmos w=20u l=1u ng=2
XMb x gn sb vdd sg13_hv_pmos w=20u l=1u ng=2
.ends unit_r2_vdd
.subckt d2s_mpdda_ct vdd vss vddo vsso vinp vinn vref vout vfb vbp vbn vbpc vbnc vabp vabn wc=16u lc=16u lcas=3 rl=50.6u
XA x y vinp vref vdd vss vbp unit_r2_ct rl={rl}
XB x y vref vinn vdd vss vbp unit_r2_ct rl={rl}
XC1 x y vref vfb vdd vss vbp unit_r2_ct rl={rl}
XC2 x y vref vfb vdd vss vbp unit_r2_ct rl={rl}
* --- folded cascode (30 uA sinks: 4 x 5 uA from the units + 10 uA branch)
XSX x vbn vss vss sg13_hv_nmos w=36u l=6u ng=4
XSY y vbn vss vss sg13_hv_nmos w=36u l=6u ng=4
XCX l1 vbnc x vss sg13_hv_nmos w={10e-6*lcas} l={1e-6*lcas} ng=2
XCY b vbnc y vss sg13_hv_nmos w={10e-6*lcas} l={1e-6*lcas} ng=2
* --- low-voltage cascode mirror (10 uA per branch)
XPL pl l2 vdd vdd sg13_hv_pmos w=24u l=4u ng=4
XPR pr l2 vdd vdd sg13_hv_pmos w=24u l=4u ng=4
XPCL l2 vbpc pl vdd sg13_hv_pmos w={10e-6*lcas} l={1e-6*lcas} ng=2
XPCR a vbpc pr vdd sg13_hv_pmos w={10e-6*lcas} l={1e-6*lcas} ng=2
* --- floating current source (left, replica) and floating class-AB control (right), as d2s_miller
XFPL l1 vabp l2 vdd sg13_hv_pmos w=6.66u l=0.6u ng=1
XFNL l2 vabn l1 vss sg13_hv_nmos w=4.4u l=1u ng=1
XABP b vabp a vdd sg13_hv_pmos w=6.66u l=0.6u ng=1
XABN a vabn b vss sg13_hv_nmos w=4.4u l=1u ng=1
* --- output devices: one Clamp_P frame (L=0.6, 41 x 2 rows), two Clamp_N frames at L=1.0 (2 x 33)
XOP vout a vddo vddo sg13_hv_pmos w=546.12u l=0.6u ng=82
XON vout b vsso vsso sg13_hv_nmos w=290.4u l=1u ng=66
* --- Miller capacitors: hv PMOS accumulation capacitors (~5 fF/um2 C_ox; 0.4...0.8 of that in use)
XCMA vout a vout vout sg13_hv_pmos w={wc} l={lc} ng=1
XCMB b vout b b sg13_hv_pmos w={wc} l={lc} ng=1
.ends d2s_mpdda_ct
.subckt d2s_mpdda_vdd vdd vss vddo vsso vinp vinn vref vout vfb vbp vbn vbpc vbnc vabp vabn wc=16u lc=16u lcas=3 rl=50.6u
XA x y vinp vref vdd vss vbp unit_r2_vdd rl={rl}
XB x y vref vinn vdd vss vbp unit_r2_vdd rl={rl}
XC1 x y vref vfb vdd vss vbp unit_r2_vdd rl={rl}
XC2 x y vref vfb vdd vss vbp unit_r2_vdd rl={rl}
* --- folded cascode (30 uA sinks: 4 x 5 uA from the units + 10 uA branch)
XSX x vbn vss vss sg13_hv_nmos w=36u l=6u ng=4
XSY y vbn vss vss sg13_hv_nmos w=36u l=6u ng=4
XCX l1 vbnc x vss sg13_hv_nmos w={10e-6*lcas} l={1e-6*lcas} ng=2
XCY b vbnc y vss sg13_hv_nmos w={10e-6*lcas} l={1e-6*lcas} ng=2
* --- low-voltage cascode mirror (10 uA per branch)
XPL pl l2 vdd vdd sg13_hv_pmos w=24u l=4u ng=4
XPR pr l2 vdd vdd sg13_hv_pmos w=24u l=4u ng=4
XPCL l2 vbpc pl vdd sg13_hv_pmos w={10e-6*lcas} l={1e-6*lcas} ng=2
XPCR a vbpc pr vdd sg13_hv_pmos w={10e-6*lcas} l={1e-6*lcas} ng=2
* --- floating current source (left, replica) and floating class-AB control (right), as d2s_miller
XFPL l1 vabp l2 vdd sg13_hv_pmos w=6.66u l=0.6u ng=1
XFNL l2 vabn l1 vss sg13_hv_nmos w=4.4u l=1u ng=1
XABP b vabp a vdd sg13_hv_pmos w=6.66u l=0.6u ng=1
XABN a vabn b vss sg13_hv_nmos w=4.4u l=1u ng=1
* --- output devices: one Clamp_P frame (L=0.6, 41 x 2 rows), two Clamp_N frames at L=1.0 (2 x 33)
XOP vout a vddo vddo sg13_hv_pmos w=546.12u l=0.6u ng=82
XON vout b vsso vsso sg13_hv_nmos w=290.4u l=1u ng=66
* --- Miller capacitors: hv PMOS accumulation capacitors (~5 fF/um2 C_ox; 0.4...0.8 of that in use)
XCMA vout a vout vout sg13_hv_pmos w={wc} l={lc} ng=1
XCMB b vout b b sg13_hv_pmos w={wc} l={lc} ng=1
.ends d2s_mpdda_vdd
