* SPDX-FileCopyrightText: 2026 Christoph Maier
* SPDX-License-Identifier: Apache-2.0
* oa_core_pd v2 LVS reference, composed by generator.compose_reference from the primitives' own netlists
* (primN/out/oa_n_cells.cdl, primP/out/oa_p_cells.cdl, oa_pcas_c.cdl); internal bulk nw = vdd (merged well). 2026-10-28, Claude.
.SUBCKT oa_core_pd vdd vss iout en_3v3 en_3v3_b
* pmir: oa_pmir_c
Mpmir_oa_pmir_c_r1_dummyn_0 vdd vpg vdd vdd sg13_hv_pmos w=0.3u l=8u ng=1 m=1
Mpmir_oa_pmir_c_r1_PO_1 co vpg vdd vdd sg13_hv_pmos w=2u l=8u ng=1 m=1
Mpmir_oa_pmir_c_r1_PO_2 co vpg vdd vdd sg13_hv_pmos w=2u l=8u ng=1 m=1
Mpmir_oa_pmir_c_r1_PO_3 co vpg vdd vdd sg13_hv_pmos w=2u l=8u ng=1 m=1
Mpmir_oa_pmir_c_r1_P8_4 c8 vpg vdd vdd sg13_hv_pmos w=2u l=8u ng=1 m=1
Mpmir_oa_pmir_c_r1_PO_5 co vpg vdd vdd sg13_hv_pmos w=2u l=8u ng=1 m=1
Mpmir_oa_pmir_c_r1_PO_6 co vpg vdd vdd sg13_hv_pmos w=2u l=8u ng=1 m=1
Mpmir_oa_pmir_c_r1_P8_7 c8 vpg vdd vdd sg13_hv_pmos w=2u l=8u ng=1 m=1
Mpmir_oa_pmir_c_r1_PO_8 co vpg vdd vdd sg13_hv_pmos w=2u l=8u ng=1 m=1
Mpmir_oa_pmir_c_r1_dummyn_9 vdd vpg vdd vdd sg13_hv_pmos w=0.3u l=8u ng=1 m=1
Mpmir_oa_pmir_c_r2_dummyn_0 vdd vpg vdd vdd sg13_hv_pmos w=0.3u l=8u ng=1 m=1
Mpmir_oa_pmir_c_r2_PO_1 co vpg vdd vdd sg13_hv_pmos w=2u l=8u ng=1 m=1
Mpmir_oa_pmir_c_r2_P8_2 c8 vpg vdd vdd sg13_hv_pmos w=2u l=8u ng=1 m=1
Mpmir_oa_pmir_c_r2_PO_3 co vpg vdd vdd sg13_hv_pmos w=2u l=8u ng=1 m=1
Mpmir_oa_pmir_c_r2_P0_4 vpg vpg vdd vdd sg13_hv_pmos w=2u l=8u ng=1 m=1
Mpmir_oa_pmir_c_r2_P2_5 c2 vpg vdd vdd sg13_hv_pmos w=2u l=8u ng=1 m=1
Mpmir_oa_pmir_c_r2_P8_6 c8 vpg vdd vdd sg13_hv_pmos w=2u l=8u ng=1 m=1
Mpmir_oa_pmir_c_r2_PO_7 co vpg vdd vdd sg13_hv_pmos w=2u l=8u ng=1 m=1
Mpmir_oa_pmir_c_r2_PO_8 co vpg vdd vdd sg13_hv_pmos w=2u l=8u ng=1 m=1
Mpmir_oa_pmir_c_r2_dummyn_9 vdd vpg vdd vdd sg13_hv_pmos w=0.3u l=8u ng=1 m=1
Mpmir_oa_pmir_c_r3_dummyn_0 vdd vpg vdd vdd sg13_hv_pmos w=0.3u l=8u ng=1 m=1
Mpmir_oa_pmir_c_r3_PO_1 co vpg vdd vdd sg13_hv_pmos w=2u l=8u ng=1 m=1
Mpmir_oa_pmir_c_r3_PO_2 co vpg vdd vdd sg13_hv_pmos w=2u l=8u ng=1 m=1
Mpmir_oa_pmir_c_r3_P8_3 c8 vpg vdd vdd sg13_hv_pmos w=2u l=8u ng=1 m=1
Mpmir_oa_pmir_c_r3_P2_4 c2 vpg vdd vdd sg13_hv_pmos w=2u l=8u ng=1 m=1
Mpmir_oa_pmir_c_r3_dummy_5 vdd vpg vdd vdd sg13_hv_pmos w=2u l=8u ng=1 m=1
Mpmir_oa_pmir_c_r3_PO_6 co vpg vdd vdd sg13_hv_pmos w=2u l=8u ng=1 m=1
Mpmir_oa_pmir_c_r3_P8_7 c8 vpg vdd vdd sg13_hv_pmos w=2u l=8u ng=1 m=1
Mpmir_oa_pmir_c_r3_PO_8 co vpg vdd vdd sg13_hv_pmos w=2u l=8u ng=1 m=1
Mpmir_oa_pmir_c_r3_dummyn_9 vdd vpg vdd vdd sg13_hv_pmos w=0.3u l=8u ng=1 m=1
Mpmir_oa_pmir_c_r4_dummyn_0 vdd vpg vdd vdd sg13_hv_pmos w=0.3u l=8u ng=1 m=1
Mpmir_oa_pmir_c_r4_PO_1 co vpg vdd vdd sg13_hv_pmos w=2u l=8u ng=1 m=1
Mpmir_oa_pmir_c_r4_P8_2 c8 vpg vdd vdd sg13_hv_pmos w=2u l=8u ng=1 m=1
Mpmir_oa_pmir_c_r4_PO_3 co vpg vdd vdd sg13_hv_pmos w=2u l=8u ng=1 m=1
Mpmir_oa_pmir_c_r4_PO_4 co vpg vdd vdd sg13_hv_pmos w=2u l=8u ng=1 m=1
Mpmir_oa_pmir_c_r4_P8_5 c8 vpg vdd vdd sg13_hv_pmos w=2u l=8u ng=1 m=1
Mpmir_oa_pmir_c_r4_PO_6 co vpg vdd vdd sg13_hv_pmos w=2u l=8u ng=1 m=1
Mpmir_oa_pmir_c_r4_PO_7 co vpg vdd vdd sg13_hv_pmos w=2u l=8u ng=1 m=1
Mpmir_oa_pmir_c_r4_PO_8 co vpg vdd vdd sg13_hv_pmos w=2u l=8u ng=1 m=1
Mpmir_oa_pmir_c_r4_dummyn_9 vdd vpg vdd vdd sg13_hv_pmos w=0.3u l=8u ng=1 m=1
* pcas: oa_pcas_c
Mpcas_oa_pcas_POC_0 iout vpc co vdd sg13_hv_pmos w=2u l=2u ng=1 m=1
Mpcas_oa_pcas_POC_1 iout vpc co vdd sg13_hv_pmos w=2u l=2u ng=1 m=1
Mpcas_oa_pcas_P8C_2 vnc vpc c8 vdd sg13_hv_pmos w=2u l=2u ng=1 m=1
Mpcas_oa_pcas_POC_3 iout vpc co vdd sg13_hv_pmos w=2u l=2u ng=1 m=1
Mpcas_oa_pcas_P0C_4 vpc vpc vpg vdd sg13_hv_pmos w=0.5u l=2u ng=1 m=1
Mpcas_oa_pcas_P2C_5 vbr vpc c2 vdd sg13_hv_pmos w=1u l=2u ng=1 m=1
Mpcas_oa_pcas_POC_6 iout vpc co vdd sg13_hv_pmos w=2u l=2u ng=1 m=1
Mpcas_oa_pcas_P8C_7 vnc vpc c8 vdd sg13_hv_pmos w=2u l=2u ng=1 m=1
Mpcas_oa_pcas_POC_8 iout vpc co vdd sg13_hv_pmos w=2u l=2u ng=1 m=1
* ms1: oa_ms1
Mms1_oa_ms1_MS1_0 ms1.ms1 en_3v3_b vdd vdd sg13_hv_pmos w=0.5u l=12.5u ng=1 m=1
Mms1_oa_ms1_MS1_1 ms1.ms2 en_3v3_b ms1.ms1 vdd sg13_hv_pmos w=0.5u l=12.5u ng=1 m=1
Mms1_oa_ms1_MS1_2 ms1.ms3 en_3v3_b ms1.ms2 vdd sg13_hv_pmos w=0.5u l=12.5u ng=1 m=1
Mms1_oa_ms1_MS1_3 ms1.ms4 en_3v3_b ms1.ms3 vdd sg13_hv_pmos w=0.5u l=12.5u ng=1 m=1
Mms1_oa_ms1_MS1_4 ms1.ms5 en_3v3_b ms1.ms4 vdd sg13_hv_pmos w=0.5u l=12.5u ng=1 m=1
Mms1_oa_ms1_MS1_5 ms1.ms6 en_3v3_b ms1.ms5 vdd sg13_hv_pmos w=0.5u l=12.5u ng=1 m=1
Mms1_oa_ms1_MS1_6 ms1.ms7 en_3v3_b ms1.ms6 vdd sg13_hv_pmos w=0.5u l=12.5u ng=1 m=1
Mms1_oa_ms1_MS1_7 ks en_3v3_b ms1.ms7 vdd sg13_hv_pmos w=0.5u l=12.5u ng=1 m=1
* svpg: oa_svpg
Msvpg_oa_svpg_SVPG vpg en_3v3 vdd vdd sg13_hv_pmos w=1u l=0.45u ng=1 m=1
* n10: oa_n10
Mn10_dummy_X0_0 vss vnc vss vss sg13_hv_nmos w=2u l=1u ng=1 m=1
Mn10_M10_X0_1 n10.d10 vnc vres vss sg13_hv_nmos w=10u l=1u ng=1 m=1
Mn10_M10_X0_2 n10.d10 vnc vres vss sg13_hv_nmos w=10u l=1u ng=1 m=1
Mn10_M10_X0_3 n10.d10 vnc vres vss sg13_hv_nmos w=10u l=1u ng=1 m=1
Mn10_dummy_X0_4 vss vnc vss vss sg13_hv_nmos w=2u l=1u ng=1 m=1
Mn10_dummy_X1_0 vss vnc vss vss sg13_hv_nmos w=2u l=1u ng=1 m=1
Mn10_M11_X1_1 vnc vnc vss vss sg13_hv_nmos w=10u l=1u ng=1 m=1
Mn10_M11_X1_2 vnc vnc vss vss sg13_hv_nmos w=10u l=1u ng=1 m=1
Mn10_M11_X1_3 vnc vnc vss vss sg13_hv_nmos w=10u l=1u ng=1 m=1
Mn10_dummy_X1_4 vss vnc vss vss sg13_hv_nmos w=2u l=1u ng=1 m=1
Mn10_dummy_X2_0 vss vnc vss vss sg13_hv_nmos w=2u l=1u ng=1 m=1
Mn10_M10_X2_1 n10.d10 vnc vres vss sg13_hv_nmos w=10u l=1u ng=1 m=1
Mn10_M10_X2_2 n10.d10 vnc vres vss sg13_hv_nmos w=10u l=1u ng=1 m=1
Mn10_M10_X2_3 n10.d10 vnc vres vss sg13_hv_nmos w=10u l=1u ng=1 m=1
Mn10_dummy_X2_4 vss vnc vss vss sg13_hv_nmos w=2u l=1u ng=1 m=1
Mn10_dummy_X3_0 vss vnc vss vss sg13_hv_nmos w=2u l=1u ng=1 m=1
Mn10_M10_X3_1 n10.d10 vnc vres vss sg13_hv_nmos w=10u l=1u ng=1 m=1
Mn10_M10_X3_2 n10.d10 vnc vres vss sg13_hv_nmos w=10u l=1u ng=1 m=1
Mn10_M10_X3_3 n10.d10 vnc vres vss sg13_hv_nmos w=10u l=1u ng=1 m=1
Mn10_dummy_X3_4 vss vnc vss vss sg13_hv_nmos w=2u l=1u ng=1 m=1
Mn10_dummy_X4_0 vss vnc vss vss sg13_hv_nmos w=2u l=1u ng=1 m=1
Mn10_M11_X4_1 vnc vnc vss vss sg13_hv_nmos w=10u l=1u ng=1 m=1
Mn10_M11_X4_2 vnc vnc vss vss sg13_hv_nmos w=10u l=1u ng=1 m=1
Mn10_M11_X4_3 vnc vnc vss vss sg13_hv_nmos w=10u l=1u ng=1 m=1
Mn10_dummy_X4_4 vss vnc vss vss sg13_hv_nmos w=2u l=1u ng=1 m=1
Mn10_dummy_X5_0 vss vnc vss vss sg13_hv_nmos w=2u l=1u ng=1 m=1
Mn10_M10_X5_1 n10.d10 vnc vres vss sg13_hv_nmos w=10u l=1u ng=1 m=1
Mn10_M10_X5_2 n10.d10 vnc vres vss sg13_hv_nmos w=10u l=1u ng=1 m=1
Mn10_M10_X5_3 n10.d10 vnc vres vss sg13_hv_nmos w=10u l=1u ng=1 m=1
Mn10_dummy_X5_4 vss vnc vss vss sg13_hv_nmos w=2u l=1u ng=1 m=1
Mn10_dummy_X6_0 vss vnc vss vss sg13_hv_nmos w=2u l=1u ng=1 m=1
Mn10_M10_X6_1 n10.d10 vnc vres vss sg13_hv_nmos w=10u l=1u ng=1 m=1
Mn10_M10_X6_2 n10.d10 vnc vres vss sg13_hv_nmos w=10u l=1u ng=1 m=1
Mn10_M10_X6_3 n10.d10 vnc vres vss sg13_hv_nmos w=10u l=1u ng=1 m=1
Mn10_dummy_X6_4 vss vnc vss vss sg13_hv_nmos w=2u l=1u ng=1 m=1
Mn10_dummy_X7_0 vss vnc vss vss sg13_hv_nmos w=2u l=1u ng=1 m=1
Mn10_M11_X7_1 vnc vnc vss vss sg13_hv_nmos w=10u l=1u ng=1 m=1
Mn10_M11_X7_2 vnc vnc vss vss sg13_hv_nmos w=10u l=1u ng=1 m=1
Mn10_M11_X7_3 vnc vnc vss vss sg13_hv_nmos w=10u l=1u ng=1 m=1
Mn10_dummy_X7_4 vss vnc vss vss sg13_hv_nmos w=2u l=1u ng=1 m=1
Mn10_dummy_X8_0 vss vnc vss vss sg13_hv_nmos w=2u l=1u ng=1 m=1
Mn10_M10_X8_1 n10.d10 vnc vres vss sg13_hv_nmos w=10u l=1u ng=1 m=1
Mn10_M10_X8_2 n10.d10 vnc vres vss sg13_hv_nmos w=10u l=1u ng=1 m=1
Mn10_M10_X8_3 n10.d10 vnc vres vss sg13_hv_nmos w=10u l=1u ng=1 m=1
Mn10_dummy_X8_4 vss vnc vss vss sg13_hv_nmos w=2u l=1u ng=1 m=1
Mn10_dummy_Y_0 vss vbr vss vss sg13_hv_nmos w=2u l=1u ng=1 m=1
Mn10_MC10_Y_1 vpc vbr n10.d10 vss sg13_hv_nmos w=10u l=1u ng=1 m=1
Mn10_MS2_Y_2 ks vbr vss vss sg13_hv_nmos w=10u l=1u ng=1 m=1
Mn10_dummy_Y_3 vss vbr vss vss sg13_hv_nmos w=2u l=1u ng=1 m=1
Mn10_MS3 vpc ks vss vss sg13_hv_nmos w=0.5u l=2u ng=1 m=1
Mn10_SKS ks en_3v3_b vss vss sg13_hv_nmos w=1u l=0.45u ng=1 m=1
* mcs: oa_mcs_c
Mmcs_MCS vbr vbr vss vss sg13_hv_nmos w=3.4u l=30u ng=1 m=1
Mmcs_MCL vres vbr vss vss sg13_hv_nmos w=3.4u l=30u ng=1 m=1
.ENDS oa_core_pd
