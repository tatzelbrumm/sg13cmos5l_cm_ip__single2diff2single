* SPDX-FileCopyrightText: 2026 Christoph Maier
* SPDX-License-Identifier: Apache-2.0
* slot7_tier1: the minimal functional slot 7 with the custom pads (proposal, 2026-11-08; docs/slot7_hookup/CONCEPT.md).
*   Fixed default mode, no mode decoder: harness enable -> ls_up_fs (en_ctrl_3v3 v2's shifter) -> en_3v3 / en_3v3_b for
*   everything; bandgap core -> bias_dist_pd input 0 -> iout0 pad_ref_rb, iout1 S2D iref, iout2 D2S iref (iout3 spare,
*   off); pad_ref_rb (on the slot's vdd_3v3: the pad ring is not reachable inside the slot) -> vcm to S2D vcm and D2S
*   vref, vref to S2D vref; S2D outp / outn -> D2S vinp / vinn (loop); analog_bus0..3 = outp, outn, vcm, vref, isolated
*   by the harness's own per-slot bus switches (reg 0x51 bits 4..7; open bus0/1 for speed, see RUNLOG row 112).
* Ports: the slot's harness ports used here, then the 13 custom-pad nets (names as in the harness's custom-io route).
* Unused harness ports (dig_in, dig_out, clk, reset, ibias0/1, vbias, vdd_1v2, vss_1v2) are not listed.
.subckt slot7_tier1 vdd_3v3 vss_3v3 enable analog_bus0 analog_bus1 analog_bus2 analog_bus3
+ s7_an_0_vref s7_an_0_outp s7_an_0_outn s7_an_0_vcm s7_an_0_en_3v3 s7_an_0_en_3v3_b s7_an_0_iref
+ s7_an_1_vinp s7_an_1_vinn s7_an_1_vref s7_an_1_iref s7_an_1_en_3v3_b s7_an_1_en_3v3
* master enable (no 1.2 V supply needed; nA while enabled)
XE vdd_3v3 vss_3v3 enable en en_b ls_up_fs
* reference current: bandgap core, 5 uA sourced into bias_dist_pd input 0
XBG vdd_3v3 vss_3v3 ibg en en_b bg_core_pd
* distribution: input 0 on, inputs 1..3 off (tied to vss); outputs 0..2 on, 3 off
XD vdd_3v3 vss_3v3 en en_b ibg vss_3v3 vss_3v3 vss_3v3 vdd_3v3 vss_3v3 vss_3v3 vss_3v3 iprb s7_an_0_iref s7_an_1_iref
+ isp vdd_3v3 vdd_3v3 vdd_3v3 vss_3v3 bias_dist_pd
* replica bias: vcm (S2D vcm = D2S vref) and the S2D vref
XR vdd_3v3 vss_3v3 iprb vcm vref en en_b pad_ref_rb
* same-net joins, written as 0 V sources for simulation (one net each in the layout)
* pad enables and references
Vse0 en s7_an_0_en_3v3 0
Vse1 en s7_an_1_en_3v3 0
Vseb0 en_b s7_an_0_en_3v3_b 0
Vseb1 en_b s7_an_1_en_3v3_b 0
Vsv0 vcm s7_an_0_vcm 0
Vsv1 vcm s7_an_1_vref 0
Vsr0 vref s7_an_0_vref 0
* loop S2D -> D2S
Vslp s7_an_0_outp s7_an_1_vinp 0
Vsln s7_an_0_outn s7_an_1_vinn 0
* bus taps
Vsb0 s7_an_0_outp analog_bus0 0
Vsb1 s7_an_0_outn analog_bus1 0
Vsb2 vcm analog_bus2 0
Vsb3 vref analog_bus3 0
.ends slot7_tier1
